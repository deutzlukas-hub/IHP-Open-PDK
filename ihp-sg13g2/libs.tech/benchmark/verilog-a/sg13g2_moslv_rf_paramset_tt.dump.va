nature current
  access = I;
  units = "A";
  abstol = 1e-12;
endnature

nature voltage
  access = V;
  units = "V";
  abstol = 1e-6;
endnature

nature power
  access = Pwr;
  units = "W";
  abstol = 0.00101010;
endnature

nature flux
  access = Phi;
  units = "We";
  abstol = 1e-5;
endnature

nature temperature
  access = Temp;
  units = "K";
  abstol = 3.14;
endnature

discipline thermal
  potential temperature;
  flow power;
enddiscipline

discipline electrical
  potential voltage;
  flow current;
enddiscipline

discipline magnetic
  potential voltage;
  flow current;
enddiscipline

discipline rotational_omega
  potential voltage;
  flow current;
enddiscipline

// paramsets
module sg13g2_lv_nmos_psp_rf_model(D, G, S, B);
  inout D, G, S, B;
  electrical D;
  electrical G;
  electrical S;
  electrical B;
  electrical NOI;
  electrical GP;
  electrical SI;
  electrical DI;
  electrical BP;
  electrical BI;
  electrical BS;
  electrical BD;
  electrical INT1;
  electrical INT2;
  electrical INT3;
  electrical INT4;
  electrical INT5;
  electrical INT6;
  electrical INT7;
  electrical INT8;
  electrical INT9;
  branch (NOI) NOII;
  branch (NOI) NOIR;
  branch (NOI) NOIC;
  branch (INT1) SPLINE1;
  branch (INT2) SPLINE2;
  branch (INT3) SPLINE3;
  branch (INT4) SPLINE4;
  branch (INT5) SPLINE5;
  branch (INT6) SPLINE6;
  branch (INT7) SPLINE7;
  branch (INT8) SPLINE8;
  branch (INT9) SPLINE9;
  branch (INT1) RES1;
  branch (INT2) RES2;
  branch (INT3) RES3;
  branch (INT4) RES4;
  branch (INT5) RES5;
  branch (INT6) RES6;
  branch (INT7) RES7;
  branch (INT8) RES8;
  branch (INT9) RES9;
  (* type = "instance" *)
  parameter integer rfmode = 1 from [0:1];
  (* type = "instance" *)
  parameter real w =  350.0e-9;
  (* type = "instance" *)
  parameter real l =  340.0e-9;
  (* type = "instance" *)
  parameter integer nf = 1;
  (* type = "instance" *)
  parameter real mult =  1.0;
  (* type = "instance" *)
  parameter real as =  0.0;
  (* type = "instance" *)
  parameter real ad =  0.0;
  (* type = "instance" *)
  parameter real ps =  0.0;
  (* type = "instance" *)
  parameter real pd =  0.0;
  (* type = "instance" *)
  parameter real dta =  0.0;
  (* type = "instance" *)
  parameter real ngcon =  2.0;
  (* type = "instance" *)
  parameter real delvto =  0.0;
  (* type = "instance" *)
  parameter real factuo =  1.0;
  (* type = "instance" *)
  parameter real pre_layout =  1.0;
  localparam integer __LEVEL = 103;
  localparam integer __TYPE = 1;
  localparam real __W = w;
  localparam real __L = l;
  localparam integer __NF = nf;
  localparam real __MULT = mult;
  localparam real __AS = as;
  localparam real __AD = ad;
  localparam real __PS = ps;
  localparam real __PD = pd;
  localparam real __TR =  27.0;
  localparam real __DTA = dta;
  localparam real __NGCON = ngcon;
  localparam real __DELVTO = delvto;
  localparam real __FACTUO = factuo;
  localparam integer __SWGEO =  1.0;
  localparam integer __SWIGATE =  1.0;
  localparam integer __SWIMPACT =  1.0;
  localparam integer __SWGIDL =  1.0;
  localparam integer __SWJUNCAP =  3.0;
  localparam integer __SWJUNASYM =  0.0;
  localparam integer __SWNUD =  0.0;
  localparam integer __SWEDGE =  0.0;
  localparam integer __SWDELVTAC =  0.0;
  localparam integer __SWIGN =  1.0;
  localparam real __QMC =  1.0;
  localparam real __LVARO =  0.0;
  localparam real __LVARL =  0.0;
  localparam real __LVARW =  0.0;
  localparam real __LAP =  29.423e-9;
  localparam real __WVARO =  0.0;
  localparam real __WVARL =  0.0;
  localparam real __WVARW =  0.0;
  localparam real __WOT = -10.0e-9;
  localparam real __DLQ = ((-13.721e-9 - ((1 - pre_layout) *  20.0e-9)) + (rfmode * ((((nf < 3))? ( 40.0e-9):(0)) + -15.368e-9)));
  localparam real __DWQ = ((rfmode *  480.62e-9) + -10.0e-9);
  localparam real __VFBO = -0.94312;
  localparam real __VFBL =  0.013965;
  localparam real __VFBW = -0.027122;
  localparam real __VFBLW =  0.0044814;
  localparam real __STVFBO =  687.85e-6;
  localparam real __STVFBL =  28.624e-6;
  localparam real __STVFBW = -18.689e-6;
  localparam real __STVFBLW =  514.35e-9;
  localparam real __ST2VFBO =  0.0;
  localparam real __TOXO =  2.2404e-9;
  localparam real __EPSROXO =  3.9;
  localparam real __NSUBO =  104.83e+21;
  localparam real __NSUBW =  7.5708;
  localparam real __WSEG =  5.3426e-6;
  localparam real __NPCK =  1.743e+21;
  localparam real __NPCKW = -1.484;
  localparam real __WSEGP =  10.0e-9;
  localparam real __LPCK =  317.1e-9;
  localparam real __LPCKW =  0.0;
  localparam real __FOL1 = -0.0091066;
  localparam real __FOL2 =  0.0021139;
  localparam real __FACNEFFACO =  1.0;
  localparam real __FACNEFFACL =  0.0;
  localparam real __FACNEFFACW =  0.0;
  localparam real __FACNEFFACLW =  0.0;
  localparam real __GFACNUDO =  1.0;
  localparam real __GFACNUDL =  0.0;
  localparam real __GFACNUDLEXP =  1.0;
  localparam real __GFACNUDW =  0.0;
  localparam real __GFACNUDLW =  0.0;
  localparam real __VSBNUDO =  0.0;
  localparam real __DVSBNUDO =  1.0;
  localparam real __VNSUBO =  0.0;
  localparam real __NSLPO =  0.05;
  localparam real __DNSUBO =  444.09e-18;
  localparam real __DPHIBO = -0.255182355;
  localparam real __DPHIBL =  0.232893711;
  localparam real __DPHIBLEXP =  0.068979;
  localparam real __DPHIBW =  0.01637832;
  localparam real __DPHIBLW = -0.00360498086;
  localparam real __DELVTACO =  0.0;
  localparam real __DELVTACL =  0.0;
  localparam real __DELVTACLEXP =  1.0;
  localparam real __DELVTACW =  0.0;
  localparam real __DELVTACLW =  0.0;
  localparam real __NPO =  464.57e+24;
  localparam real __NPL =  0.0;
  localparam real __TOXOVO =  2.2404e-9;
  localparam real __TOXOVDO =  2.0e-9;
  localparam real __LOV = ( 29.423e-9 - ((1 - pre_layout) *  9.0e-9));
  localparam real __LOVD =  0.0;
  localparam real __NOVO =  35.714e+24;
  localparam real __NOVDO =  50.0e+24;
  localparam real __CTO =  0.054556;
  localparam real __CTL =  0.018190064;
  localparam real __CTLEXP =  0.85719;
  localparam real __CTW = -0.096878;
  localparam real __CTLW =  0.008767;
  localparam real __CTGO =  0.0;
  localparam real __CTBO =  0.0;
  localparam real __STCTO =  1.0;
  localparam real __CFL =  89.001e-9;
  localparam real __CFLEXP =  3.9688;
  localparam real __CFW = -0.17956;
  localparam real __CFBO =  0.6952;
  localparam real __CFDO =  0.0;
  localparam real __PSCEL =  0.0;
  localparam real __PSCELEXP =  2.0;
  localparam real __PSCEW =  0.0;
  localparam real __PSCEBO =  0.0;
  localparam real __PSCEDO =  0.0;
  localparam real __UO =  0.045582;
  localparam real __FBET1 =  12.168;
  localparam real __FBET1W =  0.38931;
  localparam real __LP1 =  5.1674e-9;
  localparam real __LP1W = -0.1544;
  localparam real __FBET2 = -2.302;
  localparam real __LP2 =  19.441e-9;
  localparam real __BETW1 = -0.020925;
  localparam real __BETW2 =  0.0087681;
  localparam real __WBET =  59.171e-9;
  localparam real __STBETO =  2.4165;
  localparam real __STBETL = -0.036997;
  localparam real __STBETW =  0.0046613;
  localparam real __STBETLW =  0.0062828;
  localparam real __MUEO =  0.77874;
  localparam real __MUEW =  0.02630155;
  localparam real __STMUEO =  0.98971;
  localparam real __THEMUO =  1.79921322;
  localparam real __STTHEMUO =  4.441e-15;
  localparam real __CSO =  0.3164;
  localparam real __CSL =  0.12341;
  localparam real __CSLEXP =  1.1398;
  localparam real __CSW =  0.19805;
  localparam real __CSLW = -441.84e-6;
  localparam real __STCSO =  2.9406;
  localparam real __THECSO =  1.1822;
  localparam real __STTHECSO =  0.0;
  localparam real __XCORO =  0.053934;
  localparam real __XCORL = -0.11292;
  localparam real __XCORW = -0.10913;
  localparam real __XCORLW = -0.014959;
  localparam real __STXCORO =  2.0;
  localparam real __FETAO =  1.0;
  localparam real __RSW1 =  93.6;
  localparam real __RSW2 =  0.0;
  localparam real __STRSO = -0.49693;
  localparam real __RSBO = -0.099725;
  localparam real __RSGO =  0.074518;
  localparam real __THESATO =  0.39843;
  localparam real __THESATL =  0.3405958;
  localparam real __THESATLEXP =  1.0316;
  localparam real __THESATW =  0.192375;
  localparam real __THESATLW = -0.00269588;
  localparam real __STTHESATO =  2.7784;
  localparam real __STTHESATL = -0.091893;
  localparam real __STTHESATW = -0.065908;
  localparam real __STTHESATLW =  0.01292;
  localparam real __THESATBO =  0.08213;
  localparam real __THESATGO =  0.1146;
  localparam real __AXO =  13.547;
  localparam real __AXL =  1.0186;
  localparam real __ALPL =  0.0088345;
  localparam real __ALPLEXP =  0.68143;
  localparam real __ALPW =  1.0825;
  localparam real __ALP1L1 =  0.021138;
  localparam real __ALP1LEXP =  0.25;
  localparam real __ALP1L2 =  0.04044;
  localparam real __ALP1W = -0.077622;
  localparam real __ALP2L1 =  2.6817;
  localparam real __ALP2LEXP =  0.25;
  localparam real __ALP2L2 =  0.0;
  localparam real __ALP2W = -0.13012;
  localparam real __VPO =  0.32224;
  localparam real __A1O =  6.239;
  localparam real __A1L =  0.052176;
  localparam real __A1W = -0.052179;
  localparam real __A2O =  17.75;
  localparam real __STA2O =  0.068723;
  localparam real __A3O =  0.708;
  localparam real __A3L = -0.045201;
  localparam real __A3W = -0.041992;
  localparam real __A4O =  0.04649;
  localparam real __A4L =  0.0;
  localparam real __A4W =  158.1e-18;
  localparam real __GCOO =  10.0;
  localparam real __IGINVLW = (((( 247.61e-9 / l) + 1) *  121.29e+3) * (1 - ( 21.167e-9 / w)));
  localparam real __IGOVW =  3.0268e+3;
  localparam real __IGOVDW =  0.0;
  localparam real __STIGO =  2.9949;
  localparam real __GC2O =  0.8413;
  localparam real __GC3O = -0.4698;
  localparam real __CHIBO =  3.1;
  localparam real __AGIDLW =  0.001262;
  localparam real __AGIDLDW =  0.0;
  localparam real __BGIDLO =  19.92;
  localparam real __BGIDLDO =  41.0;
  localparam real __STBGIDLO =  0.0;
  localparam real __STBGIDLDO =  0.0;
  localparam real __CGIDLO =  0.06641;
  localparam real __CGIDLDO =  0.0;
  localparam real __CGBOVL =  444.09e-30;
  localparam real __CFRDW =  0.0;
  localparam real __FNTO =  1.0;
  localparam real __FNTEXCL =  0.0;
  localparam real __NFALW =  76.16e+24;
  localparam real __NFBLW =  1.026e+9;
  localparam real __NFCLW = -50.0e-9;
  localparam real __EFO =  1.0;
  localparam real __LINTNOI = -37.0e-9;
  localparam real __ALPNOI =  1.869;
  localparam real __WEDGE =  10.0e-9;
  localparam real __WEDGEW =  0.0;
  localparam real __VFBEDGEO = -1.0;
  localparam real __STVFBEDGEO =  500.0e-6;
  localparam real __STVFBEDGEL =  0.0;
  localparam real __STVFBEDGEW =  0.0;
  localparam real __STVFBEDGELW =  0.0;
  localparam real __DPHIBEDGEO =  0.0;
  localparam real __DPHIBEDGEL =  0.0;
  localparam real __DPHIBEDGELEXP =  1.0;
  localparam real __DPHIBEDGEW =  0.0;
  localparam real __DPHIBEDGELW =  0.0;
  localparam real __NSUBEDGEO =  500.0e+21;
  localparam real __NSUBEDGEL =  0.0;
  localparam real __NSUBEDGELEXP =  1.0;
  localparam real __NSUBEDGEW =  0.0;
  localparam real __NSUBEDGELW =  0.0;
  localparam real __CTEDGEO =  0.0;
  localparam real __CTEDGEL =  0.0;
  localparam real __CTEDGELEXP =  1.0;
  localparam real __FBETEDGE =  0.0;
  localparam real __LPEDGE =  10.0e-9;
  localparam real __BETEDGEW =  0.0;
  localparam real __STBETEDGEO =  1.0;
  localparam real __STBETEDGEL =  0.0;
  localparam real __STBETEDGEW =  0.0;
  localparam real __STBETEDGELW =  0.0;
  localparam real __PSCEEDGEL =  0.0;
  localparam real __PSCEEDGELEXP =  2.0;
  localparam real __PSCEEDGEW =  0.0;
  localparam real __PSCEBEDGEO =  0.0;
  localparam real __PSCEDEDGEO =  0.0;
  localparam real __CFEDGEL =  0.0;
  localparam real __CFEDGELEXP =  2.0;
  localparam real __CFEDGEW =  0.0;
  localparam real __CFDEDGEO =  0.0;
  localparam real __CFBEDGEO =  0.0;
  localparam real __FNTEDGEO =  1.0;
  localparam real __NFAEDGELW =  80.0e+21;
  localparam real __NFBEDGELW =  30.0e+6;
  localparam real __NFCEDGELW =  0.0;
  localparam real __EFEDGEO =  1.0;
  localparam real __SAREF =  1.0e-6;
  localparam real __SBREF =  1.0e-6;
  localparam real __WLOD =  0.0;
  localparam real __KUO =  0.0;
  localparam real __KVSAT =  0.0;
  localparam real __TKUO =  0.0;
  localparam real __LKUO =  0.0;
  localparam real __WKUO =  0.0;
  localparam real __PKUO =  0.0;
  localparam real __LLODKUO =  0.0;
  localparam real __WLODKUO =  0.0;
  localparam real __KVTHO =  0.0;
  localparam real __LKVTHO =  0.0;
  localparam real __WKVTHO =  0.0;
  localparam real __PKVTHO =  0.0;
  localparam real __LLODVTH =  0.0;
  localparam real __WLODVTH =  0.0;
  localparam real __STETAO =  0.0;
  localparam real __LODETAO =  1.0;
  localparam real __SCREF =  1.0e-6;
  localparam real __WEB =  0.0;
  localparam real __WEC =  0.0;
  localparam real __KVTHOWEO =  0.0;
  localparam real __KVTHOWEL =  0.0;
  localparam real __KVTHOWEW =  0.0;
  localparam real __KVTHOWELW =  0.0;
  localparam real __KUOWEO =  0.0;
  localparam real __KUOWEL =  0.0;
  localparam real __KUOWEW =  0.0;
  localparam real __KUOWELW =  0.0;
  localparam real __TRJ =  21.0;
  localparam real __SWJUNEXP =  0.0;
  localparam real __IMAX =  0.0015358;
  localparam real __FREV =  1.0e+3;
  localparam real __CJORBOT =  976.36e-6;
  localparam real __CJORSTI =  25.279e-12;
  localparam real __CJORGAT =  30.0e-12;
  localparam real __VBIRBOT =  0.70829;
  localparam real __VBIRSTI =  0.79368;
  localparam real __VBIRGAT =  2.0;
  localparam real __PBOT =  0.31309;
  localparam real __PSTI =  0.27362;
  localparam real __PGAT =  0.5424;
  localparam real __CJORBOTD =  0.001;
  localparam real __CJORSTID =  1.0e-9;
  localparam real __CJORGATD =  1.0e-9;
  localparam real __VBIRBOTD =  1.0;
  localparam real __VBIRSTID =  1.0;
  localparam real __VBIRGATD =  1.0;
  localparam real __PBOTD =  0.5;
  localparam real __PSTID =  0.5;
  localparam real __PGATD =  0.5;
  localparam real __PHIGBOT =  1.1136;
  localparam real __PHIGSTI =  1.3844;
  localparam real __PHIGGAT =  1.16;
  localparam real __IDSATRBOT =  63.087e-9;
  localparam real __IDSATRSTI =  1.9278e-15;
  localparam real __IDSATRGAT =  0.0;
  localparam real __CSRHBOT =  100.0;
  localparam real __CSRHSTI =  100.0e-6;
  localparam real __CSRHGAT =  6.682e-6;
  localparam real __XJUNSTI =  157.83e-9;
  localparam real __XJUNGAT =  100.0e-6;
  localparam real __PHIGBOTD =  1.16;
  localparam real __PHIGSTID =  1.16;
  localparam real __PHIGGATD =  1.16;
  localparam real __IDSATRBOTD =  1.0e-12;
  localparam real __IDSATRSTID =  1.0e-18;
  localparam real __IDSATRGATD =  1.0e-18;
  localparam real __CSRHBOTD =  100.0;
  localparam real __CSRHSTID =  100.0e-6;
  localparam real __CSRHGATD =  100.0e-6;
  localparam real __XJUNSTID =  100.0e-9;
  localparam real __XJUNGATD =  100.0e-9;
  localparam real __CTATBOT =  100.0;
  localparam real __CTATSTI =  100.0e-6;
  localparam real __CTATGAT =  100.0e-6;
  localparam real __MEFFTATBOT =  5.204;
  localparam real __MEFFTATSTI =  3.364;
  localparam real __MEFFTATGAT =  0.25;
  localparam real __CTATBOTD =  100.0;
  localparam real __CTATSTID =  100.0e-6;
  localparam real __CTATGATD =  100.0e-6;
  localparam real __MEFFTATBOTD =  0.25;
  localparam real __MEFFTATSTID =  0.25;
  localparam real __MEFFTATGATD =  0.25;
  localparam real __CBBTBOT =  1.0e-12;
  localparam real __CBBTSTI =  1.0e-21;
  localparam real __CBBTGAT =  1.0e-18;
  localparam real __FBBTRBOT =  1.0e+9;
  localparam real __FBBTRSTI =  1.0e+9;
  localparam real __FBBTRGAT =  1.0e+9;
  localparam real __STFBBTBOT = -0.001;
  localparam real __STFBBTSTI = -0.001;
  localparam real __STFBBTGAT = -0.001;
  localparam real __CBBTBOTD =  1.0e-12;
  localparam real __CBBTSTID =  1.0e-18;
  localparam real __CBBTGATD =  1.0e-18;
  localparam real __FBBTRBOTD =  1.0e+9;
  localparam real __FBBTRSTID =  1.0e+9;
  localparam real __FBBTRGATD =  1.0e+9;
  localparam real __STFBBTBOTD = -0.001;
  localparam real __STFBBTSTID = -0.001;
  localparam real __STFBBTGATD = -0.001;
  localparam real __VBRBOT =  10.0;
  localparam real __VBRSTI =  10.0;
  localparam real __VBRGAT =  10.0;
  localparam real __PBRBOT =  4.0;
  localparam real __PBRSTI =  4.0;
  localparam real __PBRGAT =  4.0;
  localparam real __VBRBOTD =  10.0;
  localparam real __VBRSTID =  10.0;
  localparam real __VBRGATD =  10.0;
  localparam real __PBRBOTD =  4.0;
  localparam real __PBRSTID =  4.0;
  localparam real __PBRGATD =  4.0;
  localparam real __VJUNREF =  2.5;
  localparam real __FJUNQ =  0.03;
  localparam real __VJUNREFD =  2.5;
  localparam real __FJUNQD =  0.03;
  localparam real __RINT =  13.025e-12;
  localparam real __RVPOLY =  0.0;
  localparam real __DLSIL =  0.0;
  localparam real __RSH =  0.0;
  localparam real __RSHD =  0.0;
  localparam real __MUNQSO =  1.0;
  localparam integer __SWNQS = (rfmode *  5.0);
  localparam real __CFRW = ((((1 - rfmode) *  200.0e-18) + (rfmode * ((pre_layout * (((nf > 0))? ( 38.525e-18):(0))) +  1.0e-18))) / nf);
  localparam real __RSHG = (rfmode *  3.0);
  localparam real __RGO = (rfmode *  40.0);
  localparam real __RBULKO = (((rfmode *  0.002) * nf) / w);
  localparam real __RWELLO = (((rfmode *  0.002) * nf) / w);
  localparam real __RJUNSO = (((rfmode *  5.0e+3) * l) / w);
  localparam real __RJUNDO = (((rfmode *  5.0e+3) * l) / w);
  localparam integer __SWSOA =  0.0;
  localparam real __VGS_MAX =  1.6;
  localparam real __VGD_MAX =  1.6;
  localparam real __VGB_MAX =  1.6;
  localparam real __VDS_MAX =  1.6;
  localparam real __VDB_MAX =  1.6;
  localparam real __VSB_MAX =  1.6;
  localparam real __SA =  0.0;
  localparam real __SB =  0.0;
  localparam real __SD =  0.0;
  localparam real __SCA =  0.0;
  localparam real __SCB =  0.0;
  localparam real __SCC =  0.0;
  localparam real __SC =  0.0;
  localparam real __XGW =  100.0e-9;
  localparam real __NRS =  0.0;
  localparam real __NRD =  0.0;
  localparam real __JW =  1.0e-6;
  localparam real __DELVTOEDGE =  0.0;
  localparam real __FACTUOEDGE =  1.0;
  localparam real __ABSOURCE =  1.0e-12;
  localparam real __LSSOURCE =  1.0e-6;
  localparam real __LGSOURCE =  1.0e-6;
  localparam real __ABDRAIN =  1.0e-12;
  localparam real __LSDRAIN =  1.0e-6;
  localparam real __LGDRAIN =  1.0e-6;
  localparam real __TRISE =  0.0;
  localparam integer __SWQSAT = 0;
  localparam integer __SWQPART = 0;
  localparam integer __SWFIX = 0;
  localparam real __VFB = -1.0;
  localparam real __STVFB =  500.0e-6;
  localparam real __ST2VFB =  0.0;
  localparam real __TOX =  2.0e-9;
  localparam real __EPSROX =  3.9;
  localparam real __NEFF =  500.0e+21;
  localparam real __FACNEFFAC =  1.0;
  localparam real __GFACNUD =  1.0;
  localparam real __VSBNUD =  0.0;
  localparam real __DVSBNUD =  1.0;
  localparam real __VNSUB =  0.0;
  localparam real __NSLP =  0.05;
  localparam real __DNSUB =  0.0;
  localparam real __DPHIB =  0.0;
  localparam real __DELVTAC =  0.0;
  localparam real __NP =  100.0e+24;
  localparam real __TOXOV =  2.0e-9;
  localparam real __TOXOVD =  2.0e-9;
  localparam real __NOV =  50.0e+24;
  localparam real __NOVD =  50.0e+24;
  localparam real __CT =  0.0;
  localparam real __CTG =  0.0;
  localparam real __CTB =  0.0;
  localparam real __STCT =  1.0;
  localparam real __CF =  0.0;
  localparam real __CFAC =  0.0;
  localparam real __CFD =  0.0;
  localparam real __CFB =  0.0;
  localparam real __PSCE =  0.0;
  localparam real __PSCEB =  0.0;
  localparam real __PSCED =  0.0;
  localparam real __BETN =  0.07;
  localparam real __STBET =  1.0;
  localparam real __MUE =  0.5;
  localparam real __STMUE =  0.0;
  localparam real __THEMU =  1.5;
  localparam real __STTHEMU =  1.5;
  localparam real __CS =  0.0;
  localparam real __STCS =  0.0;
  localparam real __THECS =  2.0;
  localparam real __STTHECS =  0.0;
  localparam real __XCOR =  0.0;
  localparam real __STXCOR =  0.0;
  localparam real __FETA =  1.0;
  localparam real __RS =  30.0;
  localparam real __STRS =  1.0;
  localparam real __RSB =  0.0;
  localparam real __RSG =  0.0;
  localparam real __THESAT =  1.0;
  localparam real __THESATAC =  1.0;
  localparam real __STTHESAT =  1.0;
  localparam real __THESATB =  0.0;
  localparam real __THESATG =  0.0;
  localparam real __AX =  3.0;
  localparam real __AXAC =  3.0;
  localparam real __ALP =  0.01;
  localparam real __ALPAC =  0.01;
  localparam real __ALP1 =  0.0;
  localparam real __ALP2 =  0.0;
  localparam real __VP =  0.05;
  localparam real __A1 =  1.0;
  localparam real __A2 =  10.0;
  localparam real __STA2 =  0.0;
  localparam real __A3 =  1.0;
  localparam real __A4 =  0.0;
  localparam real __GCO =  0.0;
  localparam real __IGINV =  0.0;
  localparam real __IGOV =  0.0;
  localparam real __IGOVD =  0.0;
  localparam real __STIG =  2.0;
  localparam real __GC2 =  0.375;
  localparam real __GC3 =  0.063;
  localparam real __GC2OV =  0.375;
  localparam real __GC3OV =  0.063;
  localparam real __CHIB =  3.1;
  localparam real __AGIDL =  0.0;
  localparam real __AGIDLD =  0.0;
  localparam real __BGIDL =  41.0;
  localparam real __BGIDLD =  41.0;
  localparam real __STBGIDL =  0.0;
  localparam real __STBGIDLD =  0.0;
  localparam real __CGIDL =  0.0;
  localparam real __CGIDLD =  0.0;
  localparam real __COX =  10.0e-15;
  localparam real __CGOV =  1.0e-15;
  localparam real __CGOVD =  1.0e-15;
  localparam real __FCGOVACC =  0.0;
  localparam real __FCGOVACCD =  0.0;
  localparam real __CGOVACCG =  1.0;
  localparam real __CGBOV =  0.0;
  localparam real __CINR =  0.0;
  localparam real __CINRD =  0.0;
  localparam real __DVFBINR =  0.0;
  localparam real __FCINRDEP =  0.3;
  localparam real __FCINRACC =  0.5;
  localparam real __AXINR =  0.5;
  localparam real __CFR =  0.0;
  localparam real __CFRD =  0.0;
  localparam real __FNT =  1.0;
  localparam real __FNTEXC =  0.0;
  localparam real __NFA =  80.0e+21;
  localparam real __NFB =  30.0e+6;
  localparam real __NFC =  0.0;
  localparam real __EF =  1.0;
  localparam real __VFBEDGE = -1.0;
  localparam real __STVFBEDGE =  500.0e-6;
  localparam real __DPHIBEDGE =  0.0;
  localparam real __NEFFEDGE =  500.0e+21;
  localparam real __CTEDGE =  0.0;
  localparam real __BETNEDGE =  500.0e-6;
  localparam real __STBETEDGE =  1.0;
  localparam real __PSCEEDGE =  0.0;
  localparam real __PSCEBEDGE =  0.0;
  localparam real __PSCEDEDGE =  0.0;
  localparam real __CFEDGE =  0.0;
  localparam real __CFDEDGE =  0.0;
  localparam real __CFBEDGE =  0.0;
  localparam real __FNTEDGE =  1.0;
  localparam real __NFAEDGE =  80.0e+21;
  localparam real __NFBEDGE =  30.0e+6;
  localparam real __NFCEDGE =  0.0;
  localparam real __EFEDGE =  1.0;
  localparam real __MUNQS =  1.0;
  localparam real __RG =  0.0;
  localparam real __RSE =  0.0;
  localparam real __RDE =  0.0;
  localparam real __RBULK =  0.0;
  localparam real __RWELL =  0.0;
  localparam real __RJUNS =  0.0;
  localparam real __RJUND =  0.0;
  localparam real __CFACL =  0.0;
  localparam real __CFACLEXP =  2.0;
  localparam real __CFACW =  0.0;
  localparam real __THESATACO =  0.0;
  localparam real __THESATACL =  0.05;
  localparam real __THESATACLEXP =  1.0;
  localparam real __THESATACW =  0.0;
  localparam real __THESATACLW =  0.0;
  localparam real __AXACO =  18.0;
  localparam real __AXACL =  0.4;
  localparam real __ALPACL =  500.0e-6;
  localparam real __ALPACLEXP =  1.0;
  localparam real __ALPACW =  0.0;
  localparam real __GC2OVO =  0.375;
  localparam real __GC3OVO =  0.063;
  localparam real __FCGOVACCO =  0.0;
  localparam real __FCGOVACCDO =  0.0;
  localparam real __CGOVACCGO =  1.0;
  localparam real __CINRW =  0.0;
  localparam real __CINRDW =  0.0;
  localparam real __DVFBINRO =  0.0;
  localparam real __FCINRDEPO =  0.3;
  localparam real __FCINRACCO =  0.5;
  localparam real __AXINRO =  0.5;
  localparam real __POVFB = -1.0;
  localparam real __PLVFB =  0.0;
  localparam real __PWVFB =  0.0;
  localparam real __PLWVFB =  0.0;
  localparam real __POSTVFB =  500.0e-6;
  localparam real __PLSTVFB =  0.0;
  localparam real __PWSTVFB =  0.0;
  localparam real __PLWSTVFB =  0.0;
  localparam real __POST2VFB =  0.0;
  localparam real __POTOX =  2.0e-9;
  localparam real __POEPSROX =  3.9;
  localparam real __PONEFF =  500.0e+21;
  localparam real __PLNEFF =  0.0;
  localparam real __PWNEFF =  0.0;
  localparam real __PLWNEFF =  0.0;
  localparam real __POFACNEFFAC =  1.0;
  localparam real __PLFACNEFFAC =  0.0;
  localparam real __PWFACNEFFAC =  0.0;
  localparam real __PLWFACNEFFAC =  0.0;
  localparam real __POGFACNUD =  1.0;
  localparam real __PLGFACNUD =  0.0;
  localparam real __PWGFACNUD =  0.0;
  localparam real __PLWGFACNUD =  0.0;
  localparam real __POVSBNUD =  0.0;
  localparam real __PODVSBNUD =  1.0;
  localparam real __POVNSUB =  0.0;
  localparam real __PONSLP =  0.05;
  localparam real __PODNSUB =  0.0;
  localparam real __PODPHIB =  0.0;
  localparam real __PLDPHIB =  0.0;
  localparam real __PWDPHIB =  0.0;
  localparam real __PLWDPHIB =  0.0;
  localparam real __PODELVTAC =  0.0;
  localparam real __PLDELVTAC =  0.0;
  localparam real __PWDELVTAC =  0.0;
  localparam real __PLWDELVTAC =  0.0;
  localparam real __PONP =  100.0e+24;
  localparam real __PLNP =  0.0;
  localparam real __PWNP =  0.0;
  localparam real __PLWNP =  0.0;
  localparam real __POTOXOV =  2.0e-9;
  localparam real __POTOXOVD =  2.0e-9;
  localparam real __PONOV =  50.0e+24;
  localparam real __PLNOV =  0.0;
  localparam real __PWNOV =  0.0;
  localparam real __PLWNOV =  0.0;
  localparam real __PONOVD =  50.0e+24;
  localparam real __PLNOVD =  0.0;
  localparam real __PWNOVD =  0.0;
  localparam real __PLWNOVD =  0.0;
  localparam real __POCT =  0.0;
  localparam real __PLCT =  0.0;
  localparam real __PWCT =  0.0;
  localparam real __PLWCT =  0.0;
  localparam real __POCTG =  0.0;
  localparam real __POCTB =  0.0;
  localparam real __POSTCT =  1.0;
  localparam real __POCF =  0.0;
  localparam real __PLCF =  0.0;
  localparam real __PWCF =  0.0;
  localparam real __PLWCF =  0.0;
  localparam real __POCFAC =  0.0;
  localparam real __PLCFAC =  0.0;
  localparam real __PWCFAC =  0.0;
  localparam real __PLWCFAC =  0.0;
  localparam real __POCFD =  0.0;
  localparam real __POCFB =  0.0;
  localparam real __POPSCE =  0.0;
  localparam real __PLPSCE =  0.0;
  localparam real __PWPSCE =  0.0;
  localparam real __PLWPSCE =  0.0;
  localparam real __POPSCEB =  0.0;
  localparam real __POPSCED =  0.0;
  localparam real __POBETN =  0.07;
  localparam real __PLBETN =  0.0;
  localparam real __PWBETN =  0.0;
  localparam real __PLWBETN =  0.0;
  localparam real __POSTBET =  1.0;
  localparam real __PLSTBET =  0.0;
  localparam real __PWSTBET =  0.0;
  localparam real __PLWSTBET =  0.0;
  localparam real __POMUE =  0.5;
  localparam real __PLMUE =  0.0;
  localparam real __PWMUE =  0.0;
  localparam real __PLWMUE =  0.0;
  localparam real __POSTMUE =  0.0;
  localparam real __POTHEMU =  1.5;
  localparam real __POSTTHEMU =  1.5;
  localparam real __POCS =  0.0;
  localparam real __PLCS =  0.0;
  localparam real __PWCS =  0.0;
  localparam real __PLWCS =  0.0;
  localparam real __POSTCS =  0.0;
  localparam real __POTHECS =  2.0;
  localparam real __POSTTHECS =  0.0;
  localparam real __POXCOR =  0.0;
  localparam real __PLXCOR =  0.0;
  localparam real __PWXCOR =  0.0;
  localparam real __PLWXCOR =  0.0;
  localparam real __POSTXCOR =  0.0;
  localparam real __POFETA =  1.0;
  localparam real __PORS =  30.0;
  localparam real __PLRS =  0.0;
  localparam real __PWRS =  0.0;
  localparam real __PLWRS =  0.0;
  localparam real __POSTRS =  1.0;
  localparam real __PORSB =  0.0;
  localparam real __PORSG =  0.0;
  localparam real __POTHESAT =  1.0;
  localparam real __PLTHESAT =  0.0;
  localparam real __PWTHESAT =  0.0;
  localparam real __PLWTHESAT =  0.0;
  localparam real __POTHESATAC =  1.0;
  localparam real __PLTHESATAC =  0.0;
  localparam real __PWTHESATAC =  0.0;
  localparam real __PLWTHESATAC =  0.0;
  localparam real __POSTTHESAT =  1.0;
  localparam real __PLSTTHESAT =  0.0;
  localparam real __PWSTTHESAT =  0.0;
  localparam real __PLWSTTHESAT =  0.0;
  localparam real __POTHESATB =  0.0;
  localparam real __PLTHESATB =  0.0;
  localparam real __PWTHESATB =  0.0;
  localparam real __PLWTHESATB =  0.0;
  localparam real __POTHESATG =  0.0;
  localparam real __PLTHESATG =  0.0;
  localparam real __PWTHESATG =  0.0;
  localparam real __PLWTHESATG =  0.0;
  localparam real __POAX =  3.0;
  localparam real __PLAX =  0.0;
  localparam real __PWAX =  0.0;
  localparam real __PLWAX =  0.0;
  localparam real __POAXAC =  3.0;
  localparam real __PLAXAC =  0.0;
  localparam real __PWAXAC =  0.0;
  localparam real __PLWAXAC =  0.0;
  localparam real __POALP =  0.01;
  localparam real __PLALP =  0.0;
  localparam real __PWALP =  0.0;
  localparam real __PLWALP =  0.0;
  localparam real __POALPAC =  0.01;
  localparam real __PLALPAC =  0.0;
  localparam real __PWALPAC =  0.0;
  localparam real __PLWALPAC =  0.0;
  localparam real __POALP1 =  0.0;
  localparam real __PLALP1 =  0.0;
  localparam real __PWALP1 =  0.0;
  localparam real __PLWALP1 =  0.0;
  localparam real __POALP2 =  0.0;
  localparam real __PLALP2 =  0.0;
  localparam real __PWALP2 =  0.0;
  localparam real __PLWALP2 =  0.0;
  localparam real __POVP =  0.05;
  localparam real __POA1 =  1.0;
  localparam real __PLA1 =  0.0;
  localparam real __PWA1 =  0.0;
  localparam real __PLWA1 =  0.0;
  localparam real __POA2 =  10.0;
  localparam real __POSTA2 =  0.0;
  localparam real __POA3 =  1.0;
  localparam real __PLA3 =  0.0;
  localparam real __PWA3 =  0.0;
  localparam real __PLWA3 =  0.0;
  localparam real __POA4 =  0.0;
  localparam real __PLA4 =  0.0;
  localparam real __PWA4 =  0.0;
  localparam real __PLWA4 =  0.0;
  localparam real __POGCO =  0.0;
  localparam real __POIGINV =  0.0;
  localparam real __PLIGINV =  0.0;
  localparam real __PWIGINV =  0.0;
  localparam real __PLWIGINV =  0.0;
  localparam real __POIGOV =  0.0;
  localparam real __PLIGOV =  0.0;
  localparam real __PWIGOV =  0.0;
  localparam real __PLWIGOV =  0.0;
  localparam real __POIGOVD =  0.0;
  localparam real __PLIGOVD =  0.0;
  localparam real __PWIGOVD =  0.0;
  localparam real __PLWIGOVD =  0.0;
  localparam real __POSTIG =  2.0;
  localparam real __POGC2 =  0.375;
  localparam real __POGC3 =  0.063;
  localparam real __POGC2OV =  0.375;
  localparam real __POGC3OV =  0.063;
  localparam real __POCHIB =  3.1;
  localparam real __POAGIDL =  0.0;
  localparam real __PLAGIDL =  0.0;
  localparam real __PWAGIDL =  0.0;
  localparam real __PLWAGIDL =  0.0;
  localparam real __POAGIDLD =  0.0;
  localparam real __PLAGIDLD =  0.0;
  localparam real __PWAGIDLD =  0.0;
  localparam real __PLWAGIDLD =  0.0;
  localparam real __POBGIDL =  41.0;
  localparam real __POBGIDLD =  41.0;
  localparam real __POSTBGIDL =  0.0;
  localparam real __POSTBGIDLD =  0.0;
  localparam real __POCGIDL =  0.0;
  localparam real __POCGIDLD =  0.0;
  localparam real __POCOX =  10.0e-15;
  localparam real __PLCOX =  0.0;
  localparam real __PWCOX =  0.0;
  localparam real __PLWCOX =  0.0;
  localparam real __POCGOV =  1.0e-15;
  localparam real __PLCGOV =  0.0;
  localparam real __PWCGOV =  0.0;
  localparam real __PLWCGOV =  0.0;
  localparam real __POCGOVD =  1.0e-15;
  localparam real __PLCGOVD =  0.0;
  localparam real __PWCGOVD =  0.0;
  localparam real __PLWCGOVD =  0.0;
  localparam real __POFCGOVACC =  0.0;
  localparam real __POFCGOVACCD =  0.0;
  localparam real __POCGOVACCG =  1.0;
  localparam real __POCGBOV =  0.0;
  localparam real __PLCGBOV =  0.0;
  localparam real __PWCGBOV =  0.0;
  localparam real __PLWCGBOV =  0.0;
  localparam real __POCINR =  0.0;
  localparam real __PLCINR =  0.0;
  localparam real __PWCINR =  0.0;
  localparam real __PLWCINR =  0.0;
  localparam real __POCINRD =  0.0;
  localparam real __PLCINRD =  0.0;
  localparam real __PWCINRD =  0.0;
  localparam real __PLWCINRD =  0.0;
  localparam real __PODVFBINR =  0.0;
  localparam real __POFCINRDEP =  0.3;
  localparam real __POFCINRACC =  0.5;
  localparam real __POAXINR =  0.5;
  localparam real __POCFR =  0.0;
  localparam real __PLCFR =  0.0;
  localparam real __PWCFR =  0.0;
  localparam real __PLWCFR =  0.0;
  localparam real __POCFRD =  0.0;
  localparam real __PLCFRD =  0.0;
  localparam real __PWCFRD =  0.0;
  localparam real __PLWCFRD =  0.0;
  localparam real __POFNT =  1.0;
  localparam real __POFNTEXC =  0.0;
  localparam real __PLFNTEXC =  0.0;
  localparam real __PWFNTEXC =  0.0;
  localparam real __PLWFNTEXC =  0.0;
  localparam real __PONFA =  80.0e+21;
  localparam real __PLNFA =  0.0;
  localparam real __PWNFA =  0.0;
  localparam real __PLWNFA =  0.0;
  localparam real __PONFB =  30.0e+6;
  localparam real __PLNFB =  0.0;
  localparam real __PWNFB =  0.0;
  localparam real __PLWNFB =  0.0;
  localparam real __PONFC =  0.0;
  localparam real __PLNFC =  0.0;
  localparam real __PWNFC =  0.0;
  localparam real __PLWNFC =  0.0;
  localparam real __POEF =  1.0;
  localparam real __POVFBEDGE = -1.0;
  localparam real __POSTVFBEDGE =  0.0;
  localparam real __PLSTVFBEDGE =  0.0;
  localparam real __PWSTVFBEDGE =  0.0;
  localparam real __PLWSTVFBEDGE =  0.0;
  localparam real __PODPHIBEDGE =  0.0;
  localparam real __PLDPHIBEDGE =  0.0;
  localparam real __PWDPHIBEDGE =  0.0;
  localparam real __PLWDPHIBEDGE =  0.0;
  localparam real __PONEFFEDGE =  500.0e+21;
  localparam real __PLNEFFEDGE =  0.0;
  localparam real __PWNEFFEDGE =  0.0;
  localparam real __PLWNEFFEDGE =  0.0;
  localparam real __POCTEDGE =  0.0;
  localparam real __PLCTEDGE =  0.0;
  localparam real __PWCTEDGE =  0.0;
  localparam real __PLWCTEDGE =  0.0;
  localparam real __POBETNEDGE =  500.0e-6;
  localparam real __PLBETNEDGE =  0.0;
  localparam real __PWBETNEDGE =  0.0;
  localparam real __PLWBETNEDGE =  0.0;
  localparam real __POSTBETEDGE =  1.0;
  localparam real __PLSTBETEDGE =  0.0;
  localparam real __PWSTBETEDGE =  0.0;
  localparam real __PLWSTBETEDGE =  0.0;
  localparam real __POPSCEEDGE =  0.0;
  localparam real __PLPSCEEDGE =  0.0;
  localparam real __PWPSCEEDGE =  0.0;
  localparam real __PLWPSCEEDGE =  0.0;
  localparam real __POPSCEBEDGE =  0.0;
  localparam real __POPSCEDEDGE =  0.0;
  localparam real __POCFEDGE =  0.0;
  localparam real __PLCFEDGE =  0.0;
  localparam real __PWCFEDGE =  0.0;
  localparam real __PLWCFEDGE =  0.0;
  localparam real __POCFDEDGE =  0.0;
  localparam real __POCFBEDGE =  0.0;
  localparam real __POFNTEDGE =  1.0;
  localparam real __PONFAEDGE =  80.0e+21;
  localparam real __PLNFAEDGE =  0.0;
  localparam real __PWNFAEDGE =  0.0;
  localparam real __PLWNFAEDGE =  0.0;
  localparam real __PONFBEDGE =  30.0e+6;
  localparam real __PLNFBEDGE =  0.0;
  localparam real __PWNFBEDGE =  0.0;
  localparam real __PLWNFBEDGE =  0.0;
  localparam real __PONFCEDGE =  0.0;
  localparam real __PLNFCEDGE =  0.0;
  localparam real __PWNFCEDGE =  0.0;
  localparam real __PLWNFCEDGE =  0.0;
  localparam real __POEFEDGE =  1.0;
  localparam real __POKVTHOWE =  0.0;
  localparam real __PLKVTHOWE =  0.0;
  localparam real __PWKVTHOWE =  0.0;
  localparam real __PLWKVTHOWE =  0.0;
  localparam real __POKUOWE =  0.0;
  localparam real __PLKUOWE =  0.0;
  localparam real __PWKUOWE =  0.0;
  localparam real __PLWKUOWE =  0.0;
  localparam real __LMIN = 0;
  localparam real __LMAX =  1.0;
  localparam real __WMIN =  0.0;
  localparam real __WMAX =  1.0;
  localparam real __KVSATAC =  0.0;
  localparam real __IFACTOR =  1.0;
  localparam real __CFACTOR =  1.0;

  integer __CHNL_TYPE;
  real __NF_i, __invNF, __L_i, __W_i, __SA_i, __SB_i, __SD_i, __SC_i, __XGW_i, __JW_i, __SCA_i, __SCB_i, __SCC_i, __NGCON_i, __MULT_i, __FACTUO_i, __DELVTO_i;
  real __FACTUOEDGE_i, __DELVTOEDGE_i;
  real __ABS_i, __LSS_i, __LGS_i, __ABD_i, __LSD_i, __LGD_i, __jwcorr, __jww;
  real __CFACL_i, __CFACW_i, __CFACLEXP_i, __THESATACO_i, __THESATACL_i, __THESATACLEXP_i, __THESATACW_i, __THESATACLW_i, __AXACO_i, __AXACL_i, __ALPACL_i;
  real __ALPACLEXP_i, __ALPACW_i, __POCFAC_i, __PLCFAC_i, __PWCFAC_i, __PLWCFAC_i, __POTHESATAC_i, __PLTHESATAC_i, __PWTHESATAC_i, __PLWTHESATAC_i;
  real __POAXAC_i, __PLAXAC_i, __PWAXAC_i, __PLWAXAC_i, __POALPAC_i, __PLALPAC_i, __PWALPAC_i, __PLWALPAC_i, __KVSATAC_i;
  real __VFB_p, __STVFB_p, __ST2VFB_p, __TOX_p, __EPSROX_p, __NEFF_p, __FACNEFFAC_p, __GFACNUD_p, __VSBNUD_p, __DVSBNUD_p, __VNSUB_p, __NSLP_p, __DNSUB_p;
  real __DPHIB_p, __DELVTAC_p, __NP_p, __CT_p, __CTG_p, __CTB_p, __STCT_p, __TOXOV_p, __TOXOVD_p, __NOV_p, __NOVD_p, __PSCE_p, __PSCED_p, __PSCEB_p, __CF_p, __CFAC_p;
  real __CFD_p, __CFB_p, __BETN_p, __STBET_p, __MUE_p, __STMUE_p, __THEMU_p, __STTHEMU_p, __CS_p, __STCS_p, __THECS_p, __STTHECS_p, __XCOR_p, __STXCOR_p;
  real __FETA_p, __RS_p, __STRS_p, __RSB_p, __RSG_p, __THESAT_p, __THESATAC_p, __STTHESAT_p, __THESATB_p, __THESATG_p, __AX_p, __AXAC_p, __ALP_p, __ALPAC_p;
  real __ALP1_p, __ALP2_p, __VP_p, __A1_p, __A2_p, __STA2_p, __A3_p, __A4_p, __GCO_p, __IGINV_p, __IGOV_p, __IGOVD_p, __STIG_p, __GC2_p, __GC3_p, __GC2OV_p, __GC3OV_p;
  real __CHIB_p, __AGIDL_p, __AGIDLD_p, __BGIDL_p, __BGIDLD_p, __STBGIDL_p, __STBGIDLD_p, __CGIDL_p, __CGIDLD_p, __COX_p, __CGOV_p, __CGOVD_p, __FCGOVACC_p;
  real __FCGOVACCD_p, __CGOVACCG_p, __CGBOV_p, __CINR_p, __CINRD_p, __DVFBINR_p, __FCINRDEP_p, __FCINRACC_p, __AXINR_p, __CFR_p, __CFRD_p, __FNT_p, __FNTEXC_p;
  real __NFA_p, __NFB_p, __NFC_p, __EF_p, __VFBEDGE_p, __STVFBEDGE_p, __DPHIBEDGE_p, __NEFFEDGE_p, __CTEDGE_p, __BETNEDGE_p, __STBETEDGE_p, __PSCEEDGE_p;
  real __PSCEBEDGE_p, __PSCEDEDGE_p, __CFEDGE_p, __CFDEDGE_p, __CFBEDGE_p, __FNTEDGE_p, __NFAEDGE_p, __NFBEDGE_p, __NFCEDGE_p, __EFEDGE_p, __RG_p, __RSH_i;
  real __RSHD_i, __RSE_p, __RDE_p, __RWELL_p, __RBULK_p, __RJUNS_p, __RJUND_p;
  real __MUNQS_p;
  real __VFB_i, __STVFB_i, __ST2VFB_i, __STCT_i, __TOX_i, __EPSROX_i, __NEFF_i, __FACNEFFAC_i, __GFACNUD_i, __VSBNUD_i, __DVSBNUD_i, __VNSUB_i, __NSLP_i;
  real __DNSUB_i, __DPHIB_i, __DELVTAC_i, __NP_i, __CT_i, __CTG_i, __CTB_i, __TOXOV_i, __TOXOVD_i, __NOV_i, __NOVD_i, __CF_i, __CFAC_i, __CFD_i, __CFB_i, __PSCE_i, __PSCEB_i;
  real __PSCED_i, __BETN_i, __STBET_i, __MUE_i, __STMUE_i, __THEMU_i, __STTHEMU_i, __CS_i, __STCS_i, __THECS_i, __STTHECS_i, __XCOR_i, __STXCOR_i, __FETA_i, __RS_i, __STRS_i;
  real __RSB_i, __RSG_i, __THESAT_i, __THESATAC_i, __STTHESAT_i, __THESATB_i, __THESATG_i, __AX_i, __AXAC_i, __ALP_i, __ALPAC_i, __ALP1_i, __ALP2_i, __VP_i, __A1_i, __A2_i;
  real __STA2_i, __A3_i, __A4_i, __GCO_i, __IGINV_i, __IGOV_i, __IGOVD_i, __STIG_i, __GC2_i, __GC3_i, __GC2OV_i, __GC3OV_i, __CHIB_i, __AGIDL_i, __AGIDLD_i, __BGIDL_i;
  real __BGIDLD_i, __STBGIDL_i, __STBGIDLD_i, __CGIDL_i, __CGIDLD_i, __COX_i, __CGOV_i, __CGOVD_i, __FCGOVACC_i, __FCGOVACCD_i, __CGOVACCG_i, __CGBOV_i, __CINR_i;
  real __CINRD_i, __DVFBINR_i, __FCINRDEP_i, __FCINRACC_i, __AXINR_i, __CFR_i, __CFRD_i, __FNT_i, __FNTEXC_i, __NFA_i, __NFB_i, __NFC_i, __EF_i, __VFBEDGE_i, __STVFBEDGE_i;
  real __DPHIBEDGE_i, __NEFFEDGE_i, __CTEDGE_i, __BETNEDGE_i, __STBETEDGE_i, __PSCEEDGE_i, __PSCEBEDGE_i, __PSCEDEDGE_i, __CFEDGE_i, __CFDEDGE_i, __CFBEDGE_i;
  real __FNTEDGE_i, __NFAEDGE_i, __NFBEDGE_i, __NFCEDGE_i, __EFEDGE_i, __RG_i, __RSE_i, __RDE_i, __RBULK_i, __RJUNS_i, __RJUND_i, __RWELL_i;
  real __MUNQS_i;
  real __iL, __iW, __delLPS, __delWOD, __LE, __WE, __LEcv, __WEcv, __Lcv, __Wcv, __iLE, __iWE, __L_f, __L_slif, __W_f, __XGWE, __NSUB0e, __NPCKe, __LPCKe, __AA, __BB, __NSUB;
  real __FBET1e, __LP1e, __GPE, __GWE, __tmpx, __Lnoi, __Lred, __WE_edge, __iWE_edge, __GPE_edge, __KVTHOWE, __KUOWE;
  real __iLEWE, __iiLE, __iiWE, __iiLEWE, __iiiLEWE, __iLEcv, __iiLEcv, __iiWEcv, __iiLEWEcv, __iiiLEWEcv, __iLcv, __iiLcv, __iiWcv, __iiLWcv, __iiiLWcv;
  real __TKR, __TKA, __rTa, __delTa, __phita, __inv_phita, __TKD, __TKD_sq, __delT, __rTn, __ln_rTn, __inv_phit, __Eg, __phibFac;
  real __tkr, __tkd, __auxt, __KBOL_over_QELE, __phitr, __phitrinv, __phitd, __phitdinv;
  real __perfc, __berfc, __cerfc;
  real __deltaphigr, __deltaphigd, __pmax;
  real __phigrbot, __phigrsti, __phigrgat, __phigdbot, __phigdsti, __phigdgat;
  real __ftdbot, __ftdsti, __ftdgat, __idsatbot, __idsatsti, __idsatgat;
  real __ubibot, __ubisti, __ubigat, __vbibot, __vbisti, __vbigat;
  real __vbibot2, __vbisti2, __vbigat2, __pbot2, __psti2, __pgat2, __vbibot2r, __vbisti2r, __vbigat2r;
  real __vbiinvbot, __vbiinvsti, __vbiinvgat;
  real __one_minus_PBOT, __one_minus_PSTI, __one_minus_PGAT;
  real __one_over_one_minus_PBOT, __one_over_one_minus_PSTI, __one_over_one_minus_PGAT;
  real __cjobot, __cjosti, __cjogat;
  real __qprefbot, __qprefsti, __qprefgat, __qpref2bot, __qpref2sti, __qpref2gat;
  real __wdepnulrbot, __wdepnulrsti, __wdepnulrgat, __wdepnulrinvbot, __wdepnulrinvsti, __wdepnulrinvgat;
  real __VBIRBOTinv, __VBIRSTIinv, __VBIRGATinv;
  real __deltaEbot, __deltaEsti, __deltaEgat, __atatbot, __atatsti, __atatgat;
  real __btatpartbot, __btatpartsti, __btatpartgat;
  real __fbbtbot, __fbbtsti, __fbbtgat;
  real __alphaav, __fstopbot, __fstopsti, __fstopgat, __VBRinvbot, __VBRinvsti, __VBRinvgat;
  real __slopebot, __slopesti, __slopegat;
  real __vmaxbot, __vmaxsti, __vmaxgat;
  real __SWJUNEXP_i;
  real __I1, __I2, __I3, __I4, __I5;
  real __I1_cor, __I2_cor, __I3_cor, __I4_cor, __I5_cor;
  real __V1, __V2, __V3, __V4, __V5;
  real __alphaje, __m0_rev, __mcor_rev;
  real __tt0, __tt1, __tt2, __tm0, __tm1;
  real __FRACNA, __FRACNB, __FRACI;
  real __zfrac;
  real __ijunfor1, __ijunfor2, __ijunrev;
  real __CJORBOTD_i, __CJORSTID_i, __CJORGATD_i, __VBIRBOTD_i, __VBIRSTID_i, __VBIRGATD_i;
  real __PBOTD_i, __PSTID_i, __PGATD_i, __PHIGBOTD_i, __PHIGSTID_i, __PHIGGATD_i;
  real __IDSATRBOTD_i, __IDSATRSTID_i, __IDSATRGATD_i, __XJUNSTID_i, __XJUNGATD_i;
  real __CSRHBOTD_i, __CSRHSTID_i, __CSRHGATD_i, __CTATBOTD_i, __CTATSTID_i, __CTATGATD_i;
  real __MEFFTATBOTD_i, __MEFFTATSTID_i, __MEFFTATGATD_i;
  real __CBBTBOTD_i, __CBBTSTID_i, __CBBTGATD_i, __FBBTRBOTD_i, __FBBTRSTID_i, __FBBTRGATD_i;
  real __STFBBTBOTD_i, __STFBBTSTID_i, __STFBBTGATD_i;
  real __VBRBOTD_i, __VBRSTID_i, __VBRGATD_i, __PBRBOTD_i, __PBRSTID_i, __PBRGATD_i;
  real __VJUNREFD_i, __FJUNQD_i;
  real __phigrbot_d, __phigrsti_d, __phigrgat_d, __phigdbot_d, __phigdsti_d, __phigdgat_d;
  real __ftdbot_d, __ftdsti_d, __ftdgat_d, __idsatbot_d, __idsatsti_d, __idsatgat_d;
  real __ubibot_d, __ubisti_d, __ubigat_d, __vbibot_d, __vbisti_d, __vbigat_d;
  real __vbiinvbot_d, __vbiinvsti_d, __vbiinvgat_d;
  real __one_minus_PBOT_d, __one_minus_PSTI_d, __one_minus_PGAT_d;
  real __one_over_one_minus_PBOT_d, __one_over_one_minus_PSTI_d, __one_over_one_minus_PGAT_d;
  real __cjobot_d, __cjosti_d, __cjogat_d;
  real __qprefbot_d, __qprefsti_d, __qprefgat_d, __qpref2bot_d, __qpref2sti_d, __qpref2gat_d;
  real __wdepnulrbot_d, __wdepnulrsti_d, __wdepnulrgat_d, __wdepnulrinvbot_d, __wdepnulrinvsti_d, __wdepnulrinvgat_d;
  real __VBIRBOTinv_d, __VBIRSTIinv_d, __VBIRGATinv_d;
  real __deltaEbot_d, __deltaEsti_d, __deltaEgat_d, __atatbot_d, __atatsti_d, __atatgat_d;
  real __btatpartbot_d, __btatpartsti_d, __btatpartgat_d;
  real __fbbtbot_d, __fbbtsti_d, __fbbtgat_d;
  real __fstopbot_d, __fstopsti_d, __fstopgat_d, __VBRinvbot_d, __VBRinvsti_d, __VBRinvgat_d;
  real __slopebot_d, __slopesti_d, __slopegat_d;
  real __ABSOURCE_i, __LSSOURCE_i, __LGSOURCE_i, __AS_i, __PS_i;
  real __zflagbot_s, __zflagsti_s, __zflaggat_s;
  real __VMAX_s, __exp_VMAX_over_phitd_s, __vbimin_s, __vch_s, __vfmin_s, __vbbtlim_s;
  real __xhighf1_s, __expxhf1_s, __xhighf2_s, __expxhf2_s, __xhighr_s, __expxhr_s, __m0flag_s;
  real __ISATFOR1_s, __MFOR1_s, __ISATFOR2_s, __MFOR2_s, __ISATREV_s, __MREV_s;
  real __ABDRAIN_i, __LSDRAIN_i, __LGDRAIN_i, __AD_i, __PD_i;
  real __zflagbot_d, __zflagsti_d, __zflaggat_d;
  real __VMAX_d, __exp_VMAX_over_phitd_d, __vbimin_d, __vch_d, __vfmin_d, __vbbtlim_d;
  real __xhighf1_d, __expxhf1_d, __xhighf2_d, __expxhf2_d, __xhighr_d, __expxhr_d, __m0flag_d;
  real __ISATFOR1_d, __MFOR1_d, __ISATFOR2_d, __MFOR2_d, __ISATREV_d, __MREV_d;
  real __VFB_T, __CT_T, __CTG_T, __BETN_T, __MUE_T, __THEMU_T, __CS_T, __THECS_T, __XCOR_T, __RS_T, __BGIDL_T, __BGIDLD_T, __A2_T, __VFBEDGE_T, __BETNEDGE_T;
  real __phit, __BET_i, __BETEDGE_i, __nt0, __nt, __THESAT_T, __THESATAC_T, __Sfl_prefac, __phit0edge, __Gfedge2, __lnGfedge2, __Sfl_prefac_edge;
  real __ntedge;
  real __phib_dc, __G_0_dc, __kp, __np, __arg2max, __qlim2, __qb0, __dphibq, __sqrt_phib_dc, __phix_dc, __aphi_dc, __bphi_dc, __phix2, __phix1_dc, __alpha_b;
  real __us1, __us21, __phib_ac, __G_0_ac, __phix_ac, __aphi_ac, __bphi_ac, __phix1_ac, __tf_ct, __tf_bet, __tf_mue, __tf_cs, __tf_xcor, __tf_ther, __THER_i, __tf_thesat;
  real __tf_betedge, __phibedge, __Gfedge, __phixedge, __aphiedge, __bphiedge, __phix2edge, __phix1edge;
  real __EPSSI, __EPSOX, __CoxPrime, __tox_sq, __Cox_over_q, __NEFFAC_i, __qq, __E_eff0, __eta_mu, __eta_mu1, __inv_AX, __inv_VP, __CoxovPrime, __CoxovPrime_d, __GOV_s;
  real __GOV_d, __GOV2_s, __GOV2_d, __dxgb_ov_th, __dxgb_ov_s, __dxgb_ov_d, __SP_OV_eps2_s, __SP_OV_a_s, __SP_OV_delta1_s, __SP_OV_eps2_d, __SP_OV_a_d, __SP_OV_delta1_d;
  real __inv_CHIB, __B_fact, __BCH, __BOV, __BOV_d, __GCQ, __GCQOV, __tf_ig, __AGIDLs, __AGIDLDs, __BGIDLs, __BGIDLDs, __Vinr_max, __ainr, __fac_exc, __ggate, __gsource;
  real __gdrain, __gbulk, __gjuns, __gjund, __gwell;
  real __Vgs, __Vds, __Vsb, __Vdb, __Vgb, __Vjun_s, __Vjun_d, __VgsPrime, __VsbPrime, __VdbPrime, __VgdPrime;
  real __Vdsx;
  real __Vgb1, __Vdsp, __delVg, __Vdsat_lim, __Vdsat;
  real __xgs_ov, __xgd_ov, __xgb_ov, __Vsbstar_dc, __Vsbstar_dc_tmp, __Vmb, __us, __usnew, __Vmbnew, __qeff1_dc, __Voxm_dc, __GdL_dc, __eta_p_dc, __Gvsat_dc;
  real __Gmob_dL_dc, __x_ds_dc, __x_m_dc, __Gf_dc, __Vdsat_dc, __Udse_dc, __SP_OV_xg, __xs_ov, __xd_ov, __Vovs, __Vovd, __zg, __TP, __Fs1, __Fs2, __Fs3, __Fs, __Vm, __Dch;
  real __arg2mina, __psi_t, __arg1, __Dsi, __Dgate, __Igc0, __igc, __igcd_h, __u0, __x, __u0_div_H, __Bg, __Ag, __xsq, __inv_x, __ex, __inv_ex, __Sg, __Igc, __Igb, __Vtovd, __Igidl;
  real __Vtovs, __Igisl, __delVsat, __Vsbstar_ac, __xg_ac, __Gf_ac, __Vgb1_ac, __qeff1_ac, __Voxm_ac, __alpha_ac, __dps_ac, __qim_ac, __GdL_ac, __H_ac, __QG, __QI, __QD;
  real __QB, __Fj, __Fj2, __QCLM, __Qg, __Qd, __Qb, __Qs, __Qsinr, __Qdinr, __Qginr, __Qg_ov_s, __Qg_ov_d, __Qg_ov, __Qgs_ov, __Qgd_ov, __Qgb_ov, __Qfgs, __Qfgd, __rgatenoise;
  real __rsourcenoise, __rdrainnoise, __rbulknoise, __rwellnoise, __rjundnoise, __rjunsnoise;
  real __tme1, __tme2;
  real __inv_GOV, __SP_OV_eps, __SP_OV_delta, __mutau, __nu;
  real __Q_EDGE_xsth, __Q_EDGE_xth0, __Q_EDGE_xth, __Q_EDGE_n, __Q_EDGE_n_inv, __Q_EDGE_xgt, __Q_EDGE_xgt0, __Q_EDGE_xgt0e, __Q_EDGE_qi0si, __Q_EDGE_qi0;
  real __Q_EDGE_exp_x, __Q_EDGE_d0, __Q_EDGE_d0p, __Q_EDGE_sqerr, __Q_EDGE_errq;
  real __N1, __Nm1, __Delta_N1, __Sfl, __t1, __sqt2, __t2, __r, __lc, __lcinv2, __g_ideal, __mid, __temp2_exc, __wsat_exc, __temp_exc, __thesat1_exc, __zsat_exc, __Gvsat_exc;
  real __gfac, __Sidexc, __sqid, __mig, __migid0, __migid, __CGeff, __sqig, __c_igid, __shot_igcsx, __shot_igcdx, __shot_igsov, __shot_igdov, __shot_iavl, __jnoisex_s, __jnoisex_d;
  real __shot_igs, __shot_igd, __anoisedge, __N1edge, __Nm1edge, __Delta_N1edge, __H0edge, __t1edge, __sqt2edge, __t2edge, __redge, __lcedge, __lcinv2edge;
  real __g_idealedge;
  integer __SWNQS_i;
  real __xgm_dc, __thesat1_dc, __xgm_ac, __x_m_ac, __thesat1_ac, __margin_dc, __margin_ac;
  real __Qp1_0, __Qp2_0, __Qp3_0, __Qp4_0, __Qp5_0, __Qp6_0, __Qp7_0, __Qp8_0, __Qp9_0, __fk1, __fk2, __fk3, __fk4, __fk5, __fk6, __fk7, __fk8, __fk9, __phi_p1, __phi_p2, __phi_p3;
  real __phi_p4, __phi_p5, __phi_p6, __phi_p7, __phi_p8, __phi_p9, __Qp1, __Qp2, __Qp3, __Qp4, __Qp5, __Qp6, __Qp7, __Qp8, __Qp9, __Qp0, __QpN, __QG_NQS, __QS_NQS, __QD_NQS, __pd;
  real __Gp, __Gp2, __a_factrp, __marginp, __x_sp, __x_dp, __zsat_nqs, __dfQi, __fQi, __dQis, __dQis_1, __d2Qis, __dQbs, __dQy, __d2Qy, __dpsy2, __ym, __Tnorm, __Qb_tmp;
  real __QbSIGN, __r_nqs, __vnorm, __vnorm_inv, __NQS_xg1, __NQS_yg, __NQS_z, __NQS_eta, __NQS_a, __NQS_c, __NQS_tau, __NQS_D0, __NQS_xi, __NQS_p, __NQS_q, __NQS_temp;
  real __NQS_A_fac, __NQS_xbar, __NQS_w, __NQS_x0, __NQS_u, __NQS_y0, __xphi, __fk0, __thesat2, __Fvsat, __temp3, __temp4, __temp5, __temp6, __temp7, __temp8, __temp9;
  real __gmin;
  real __id_op, __is, __ig, __ib, __P_D, __facvsb, __facvsb0, __sig1k, __vth_i, __vts_i, __ids_i;
  (* units=""             ,                             desc="Flag for channel type" *)
  real __ctype;
  (* units=""             ,                             desc="Flag for source-drain interchange" *)
  real __sdint;
  (* units="A"            , multiplicity="multiply",    desc="Total source current" *)
  real __ise;
  (* units="A"            , multiplicity="multiply",    desc="Total gate current" *)
  real __ige;
  (* units="A"            , multiplicity="multiply",    desc="Total drain current" *)
  real __ide;
  (* units="A"            , multiplicity="multiply",    desc="Total bulk current" *)
  real __ibe;
  (* units="A"            , multiplicity="multiply",    desc="Drain current, excl. edge transistor currents, avalanche, tunnel, GISL, GIDL, and junction currents" *)
  real __ids;
  (* units="A"            , multiplicity="multiply",    desc="Drain to bulk current" *)
  real __idb;
  (* units="A"            , multiplicity="multiply",    desc="Source to bulk current" *)
  real __isb;
  (* units="A"            , multiplicity="multiply",    desc="Gate-source tunneling current" *)
  real __igs;
  (* units="A"            , multiplicity="multiply",    desc="Gate-drain tunneling current" *)
  real __igd;
  (* units="A"            , multiplicity="multiply",    desc="Gate-bulk tunneling current" *)
  real __igb;
  (* units="A"            , multiplicity="multiply",    desc="Drain current of edge transistors" *)
  real __idedge;
  (* units="A"            , multiplicity="multiply",    desc="Gate-channel tunneling current (source component)" *)
  real __igcs;
  (* units="A"            , multiplicity="multiply",    desc="Gate-channel tunneling current (drain component)" *)
  real __igcd;
  (* units="A"            , multiplicity="multiply",    desc="Substrate current due to weak avelanche" *)
  real __iavl;
  (* units="A"            , multiplicity="multiply",    desc="Gate-induced source leakage current" *)
  real __igisl;
  (* units="A"            , multiplicity="multiply",    desc="Gate-induced drain leakage current" *)
  real __igidl;
  (* units="A"            , multiplicity="multiply",    desc="Total source junction current" *)
  real __ijs;
  (* units="A"            , multiplicity="multiply",    desc="Source junction current (bottom component)" *)
  real __ijsbot;
  (* units="A"            , multiplicity="multiply",    desc="Source junction current (gate-edge component)" *)
  real __ijsgat;
  (* units="A"            , multiplicity="multiply",    desc="Source junction current (STI-edge component)" *)
  real __ijssti;
  (* units="A"            , multiplicity="multiply",    desc="Total drain junction current" *)
  real __ijd;
  (* units="A"            , multiplicity="multiply",    desc="Drain junction current (bottom component)" *)
  real __ijdbot;
  (* units="A"            , multiplicity="multiply",    desc="Drain junction current (gate-edge component)" *)
  real __ijdgat;
  (* units="A"            , multiplicity="multiply",    desc="Drain junction current (STI-edge component)" *)
  real __ijdsti;
  (* units="V"            ,                             desc="Drain-source voltage" *)
  real __vds;
  (* units="V"            ,                             desc="Gate-source voltage" *)
  real __vgs;
  (* units="V"            ,                             desc="Source-bulk voltage" *)
  real __vsb;
  (* units="V"            ,                             desc="Zero-bias threshold voltage" *)
  real __vto;
  (* units="V"            ,                             desc="Threshold voltage including back bias effects" *)
  real __vts;
  (* units="V"            ,                             desc="Threshold voltage including back bias and drain bias effects" *)
  real __vth;
  (* units="V"            ,                             desc="Effective gate drive voltage including back bias and drain bias effects" *)
  real __vgt;
  (* units="V"            ,                             desc="Drain saturation voltage at actual bias" *)
  real __vdss;
  (* units=""             ,                             desc="Saturation limit" *)
  real __vsat;
  (* units="S"            , multiplicity="multiply",    desc="Transconductance" *)
  real __gm;
  (* units="S"            , multiplicity="multiply",    desc="Substrate transconductance" *)
  real __gmb;
  (* units="S"            , multiplicity="multiply",    desc="Output conductance" *)
  real __gds;
  (* units="S"            , multiplicity="multiply",    desc="Source junction conductance" *)
  real __gjs;
  (* units="S"            , multiplicity="multiply",    desc="Drain junction conductance" *)
  real __gjd;
  (* units="F"            , multiplicity="multiply",    desc="Drain capacitance" *)
  real __cdd;
  (* units="F"            , multiplicity="multiply",    desc="Drain-gate capacitance" *)
  real __cdg;
  (* units="F"            , multiplicity="multiply",    desc="Drain-source capacitance" *)
  real __cds;
  (* units="F"            , multiplicity="multiply",    desc="Drain-bulk capacitance" *)
  real __cdb;
  (* units="F"            , multiplicity="multiply",    desc="Gate-drain capacitance" *)
  real __cgd;
  (* units="F"            , multiplicity="multiply",    desc="Gate capacitance" *)
  real __cgg;
  (* units="F"            , multiplicity="multiply",    desc="Gate-source capacitance" *)
  real __cgs;
  (* units="F"            , multiplicity="multiply",    desc="Gate-bulk capacitance" *)
  real __cgb;
  (* units="F"            , multiplicity="multiply",    desc="Source-drain capacitance" *)
  real __csd;
  (* units="F"            , multiplicity="multiply",    desc="Source-gate capacitance" *)
  real __csg;
  (* units="F"            , multiplicity="multiply",    desc="Source capacitance" *)
  real __css;
  (* units="F"            , multiplicity="multiply",    desc="Source-bulk capacitance" *)
  real __csb;
  (* units="F"            , multiplicity="multiply",    desc="Bulk-drain capacitance" *)
  real __cbd;
  (* units="F"            , multiplicity="multiply",    desc="Bulk-gate capacitance" *)
  real __cbg;
  (* units="F"            , multiplicity="multiply",    desc="Bulk-source capacitance" *)
  real __cbs;
  (* units="F"            , multiplicity="multiply",    desc="Bulk capacitance" *)
  real __cbb;
  (* units="F"            , multiplicity="multiply",    desc="Total gate-source overlap capacitance" *)
  real __cgsol;
  (* units="F"            , multiplicity="multiply",    desc="Total gate-drain overlap capacitance" *)
  real __cgdol;
  (* units="F"            , multiplicity="multiply",    desc="Total source junction capacitance" *)
  real __cjs;
  (* units="F"            , multiplicity="multiply",    desc="Source junction capacitance (bottom component)" *)
  real __cjsbot;
  (* units="F"            , multiplicity="multiply",    desc="Source junction capacitance (gate-edge component)" *)
  real __cjsgat;
  (* units="F"            , multiplicity="multiply",    desc="Source junction capacitance (STI-edge component)" *)
  real __cjssti;
  (* units="F"            , multiplicity="multiply",    desc="Total drain junction capacitance" *)
  real __cjd;
  (* units="F"            , multiplicity="multiply",    desc="Drain junction capacitance (bottom component)" *)
  real __cjdbot;
  (* units="F"            , multiplicity="multiply",    desc="Drain junction capacitance (gate-edge component)" *)
  real __cjdgat;
  (* units="F"            , multiplicity="multiply",    desc="Drain junction capacitance (STI-edge component)" *)
  real __cjdsti;
  (* units="m"            ,                             desc="Effective channel width for geometrical models" *)
  real __weff;
  (* units="m"            ,                             desc="Effective channel length for geometrical models" *)
  real __leff;
  (* units=""             ,                             desc="Transistor gain" *)
  real __u;
  (* units="Ohm"          , multiplicity="divide",      desc="Small-signal output resistance" *)
  real __rout;
  (* units="V"            ,                             desc="Equivalent Early voltage" *)
  real __vearly;
  (* units="A/V^2"        , multiplicity="multiply",    desc="Gain factor" *)
  real __beff;
  (* units="Hz"           ,                             desc="Unity gain frequency at actual bias" *)
  real __fug;
  (* units="Ohm"          , multiplicity="divide",      desc="Gate resistance" *)
  real __rg;
  (* units="A^2/Hz"       , multiplicity="multiply",    desc="Flicker noise current spectral density at 1 Hz" *)
  real __sfl;
  (* units="V/sqrt(Hz)"   ,                             desc="Input-referred RMS white noise voltage spectral density at 1 kHz" *)
  real __sqrtsff;
  (* units="V/sqrt(Hz)"   ,                             desc="Input-referred RMS white noise voltage spectral density" *)
  real __sqrtsfw;
  (* units="A^2/Hz"       , multiplicity="multiply",    desc="White noise current spectral density" *)
  real __sid;
  (* units="A^2/Hz"       , multiplicity="multiply",    desc="Induced gate noise current spectral density at 1 Hz" *)
  real __sig;
  (* units=""             ,                             desc="Imaginary part of correlation coefficient between Sig and Sid" *)
  real __cigid;
  (* units="Hz"           ,                             desc="Cross-over frequency above which white noise is dominant" *)
  real __fknee;
  (* units="A^2/Hz"       , multiplicity="multiply",    desc="Gate-source current noise spectral density" *)
  real __sigs;
  (* units="A^2/Hz"       , multiplicity="multiply",    desc="Gate-drain current noise spectral density" *)
  real __sigd;
  (* units="A^2/Hz"       , multiplicity="multiply",    desc="Impact ionization current noise spectral density" *)
  real __siavl;
  (* units="A^2/Hz"       , multiplicity="multiply",    desc="Total source junction current noise spectral density" *)
  real __ssi;
  (* units="A^2/Hz"       , multiplicity="multiply",    desc="Total drain junction current noise spectral density" *)
  real __sdi;
  (* units="A^2/Hz"       , multiplicity="multiply",    desc="Flicker noise current spectral density at 1 Hz of edge transistors" *)
  real __sfledge;
  (* units="A^2/Hz"       , multiplicity="multiply",    desc="White noise current spectral density of edge transistors" *)
  real __sidedge;
  (* units="V"            ,                             desc="Local parameter VFB after T-scaling and clipping" *)
  real __lp_vfb;
  (* units="V/K"          ,                             desc="Local parameter STVFB after clipping" *)
  real __lp_stvfb;
  (* units="K^-1"         ,                             desc="Local parameter ST2VFB after clipping" *)
  real __lp_st2vfb;
  (* units="m"            ,                             desc="Local parameter TOX after clipping" *)
  real __lp_tox;
  (* units=""             ,                             desc="Local parameter EPSROX after clipping" *)
  real __lp_epsrox;
  (* units="m^-3"         ,                             desc="Local parameter NEFF after clipping" *)
  real __lp_neff;
  (* units=""             ,                             desc="Local parameter FACNEFFAC after clipping" *)
  real __lp_facneffac;
  (* units=""             ,                             desc="Local parameter GFACNUD after clipping" *)
  real __lp_gfacnud;
  (* units="V"            ,                             desc="Local parameter VSBNUD after clipping" *)
  real __lp_vsbnud;
  (* units="V"            ,                             desc="Local parameter DVSBNUD after clipping" *)
  real __lp_dvsbnud;
  (* units="V"            ,                             desc="Local parameter VNSUB after clipping" *)
  real __lp_vnsub;
  (* units="V"            ,                             desc="Local parameter NSLP after clipping" *)
  real __lp_nslp;
  (* units="V^-1"         ,                             desc="Local parameter DNSUB after clipping" *)
  real __lp_dnsub;
  (* units="V"            ,                             desc="Local parameter DPHIB after clipping" *)
  real __lp_dphib;
  (* units="V"            ,                             desc="Local parameter DELVTAC after clipping" *)
  real __lp_delvtac;
  (* units="m^-3"         ,                             desc="Local parameter NP after clipping" *)
  real __lp_np;
  (* units="m"            ,                             desc="Local parameter TOXOV after clipping" *)
  real __lp_toxov;
  (* units="m"            ,                             desc="Local parameter TOXOVD after clipping" *)
  real __lp_toxovd;
  (* units="m^-3"         ,                             desc="Local parameter NOV after clipping" *)
  real __lp_nov;
  (* units="m^-3"         ,                             desc="Local parameter NOVD after clipping" *)
  real __lp_novd;
  (* units=""             ,                             desc="Local parameter CT after clipping" *)
  real __lp_ct;
  (* units=""             ,                             desc="Local parameter CTG after clipping" *)
  real __lp_ctg;
  (* units=""             ,                             desc="Local parameter CTB after clipping" *)
  real __lp_ctb;
  (* units=""             ,                             desc="Local parameter STCT after clipping" *)
  real __lp_stct;
  (* units=""             ,                             desc="Local parameter CF after clipping" *)
  real __lp_cf;
  (* units=""             ,                             desc="Local parameter CFAC after clipping" *)
  real __lp_cfac;
  (* units="V^-1"         ,                             desc="Local parameter CFD after clipping" *)
  real __lp_cfd;
  (* units="V^-1"         ,                             desc="Local parameter CFB after clipping" *)
  real __lp_cfb;
  (* units=""             ,                             desc="Local parameter PSCE after clipping" *)
  real __lp_psce;
  (* units="V^-1"         ,                             desc="Local parameter PSCEB after clipping" *)
  real __lp_psceb;
  (* units="V^-1"         ,                             desc="Local parameter PSCED after clipping" *)
  real __lp_psced;
  (* units="m^2/(V s)"    ,                             desc="Local parameter BETN after T-scaling and clipping" *)
  real __lp_betn;
  (* units=""             ,                             desc="Local parameter STBET after clipping" *)
  real __lp_stbet;
  (* units="m/V"          ,                             desc="Local parameter MUE after T-scaling and clipping" *)
  real __lp_mue;
  (* units=""             ,                             desc="Local parameter STMUE after clipping" *)
  real __lp_stmue;
  (* units=""             ,                             desc="Local parameter THEMU after T-scaling and clipping" *)
  real __lp_themu;
  (* units=""             ,                             desc="Local parameter STTHEMU after clipping" *)
  real __lp_stthemu;
  (* units=""             ,                             desc="Local parameter CS after T-scaling and clipping" *)
  real __lp_cs;
  (* units=""             ,                             desc="Local parameter STCS after clipping" *)
  real __lp_stcs;
  (* units=""             ,                             desc="Local parameter THECS after T-scaling and clipping" *)
  real __lp_thecs;
  (* units=""             ,                             desc="Local parameter STTHECS after clipping" *)
  real __lp_stthecs;
  (* units="V^-1"         ,                             desc="Local parameter XCOR after T-scaling and clipping" *)
  real __lp_xcor;
  (* units=""             ,                             desc="Local parameter STXCOR after clipping" *)
  real __lp_stxcor;
  (* units=""             ,                             desc="Local parameter FETA after clipping" *)
  real __lp_feta;
  (* units="Ohm"          , multiplicity="divide",      desc="Local parameter RS after T-scaling and clipping" *)
  real __lp_rs;
  (* units=""             ,                             desc="Local parameter STRS after clipping" *)
  real __lp_strs;
  (* units="V^-1"         ,                             desc="Local parameter RSB after clipping" *)
  real __lp_rsb;
  (* units="V^-1"         ,                             desc="Local parameter RSG after clipping" *)
  real __lp_rsg;
  (* units="V^-1"         ,                             desc="Local parameter THESAT after T-scaling and clipping" *)
  real __lp_thesat;
  (* units="V^-1"         ,                             desc="Local parameter THESATAC after T-scaling and clipping" *)
  real __lp_thesatac;
  (* units=""             ,                             desc="Local parameter STTHESAT after clipping" *)
  real __lp_stthesat;
  (* units="V^-1"         ,                             desc="Local parameter THESATB after clipping" *)
  real __lp_thesatb;
  (* units="V^-1"         ,                             desc="Local parameter THESATG after clipping" *)
  real __lp_thesatg;
  (* units=""             ,                             desc="Local parameter AX after clipping" *)
  real __lp_ax;
  (* units=""             ,                             desc="Local parameter AXAC after clipping" *)
  real __lp_axac;
  (* units=""             ,                             desc="Local parameter ALP after clipping" *)
  real __lp_alp;
  (* units=""             ,                             desc="Local parameter ALPAC after clipping" *)
  real __lp_alpac;
  (* units="V"            ,                             desc="Local parameter ALP1 after clipping" *)
  real __lp_alp1;
  (* units="V^-1"         ,                             desc="Local parameter ALP2 after clipping" *)
  real __lp_alp2;
  (* units="V"            ,                             desc="Local parameter VP after clipping" *)
  real __lp_vp;
  (* units=""             ,                             desc="Local parameter A1 after clipping" *)
  real __lp_a1;
  (* units="V"            ,                             desc="Local parameter A2 after T-scaling and clipping" *)
  real __lp_a2;
  (* units=""             ,                             desc="Local parameter STA2 after clipping" *)
  real __lp_sta2;
  (* units=""             ,                             desc="Local parameter A3 after clipping" *)
  real __lp_a3;
  (* units="1/sqrt(V)"    ,                             desc="Local parameter A4 after clipping" *)
  real __lp_a4;
  (* units=""             ,                             desc="Local parameter GCO after clipping" *)
  real __lp_gco;
  (* units="A"            , multiplicity="multiply",    desc="Local parameter IGINV after T-scaling and clipping" *)
  real __lp_iginv;
  (* units="A"            , multiplicity="multiply",    desc="Local parameter IGOV after T-scaling and clipping" *)
  real __lp_igov;
  (* units="A"            , multiplicity="multiply",    desc="Local parameter IGOVD after T-scaling and clipping" *)
  real __lp_igovd;
  (* units=""             ,                             desc="Local parameter STIG after clipping" *)
  real __lp_stig;
  (* units=""             ,                             desc="Local parameter GC2 after clipping" *)
  real __lp_gc2;
  (* units=""             ,                             desc="Local parameter GC3 after clipping" *)
  real __lp_gc3;
  (* units=""             ,                             desc="Local parameter GC2OV after clipping" *)
  real __lp_gc2ov;
  (* units=""             ,                             desc="Local parameter GC3OV after clipping" *)
  real __lp_gc3ov;
  (* units="V"            ,                             desc="Local parameter CHIB after clipping" *)
  real __lp_chib;
  (* units="A/V^3"        ,                             desc="Local parameter AGIDL after clipping" *)
  real __lp_agidl;
  (* units="A/V^3"        ,                             desc="Local parameter AGIDLD after clipping" *)
  real __lp_agidld;
  (* units="V"            ,                             desc="Local parameter BGIDL after T-scaling and clipping" *)
  real __lp_bgidl;
  (* units="V"            ,                             desc="Local parameter BGIDLD after T-scaling and clipping" *)
  real __lp_bgidld;
  (* units="V/K"          ,                             desc="Local parameter STBGIDL after clipping" *)
  real __lp_stbgidl;
  (* units="V/K"          ,                             desc="Local parameter STBGIDLD after clipping" *)
  real __lp_stbgidld;
  (* units=""             ,                             desc="Local parameter CGIDL after clipping" *)
  real __lp_cgidl;
  (* units=""             ,                             desc="Local parameter CGIDLD after clipping" *)
  real __lp_cgidld;
  (* units="F"            , multiplicity="multiply",    desc="Local parameter COX after clipping" *)
  real __lp_cox;
  (* units="F"            , multiplicity="multiply",    desc="Local parameter CGOV after clipping" *)
  real __lp_cgov;
  (* units="F"            , multiplicity="multiply",    desc="Local parameter CGOVD after clipping" *)
  real __lp_cgovd;
  (* units=""             ,                             desc="Local parameter FCGOVACC after clipping" *)
  real __lp_fcgovacc;
  (* units=""             ,                             desc="Local parameter FCGOVACCD after clipping" *)
  real __lp_fcgovaccd;
  (* units=""             ,                             desc="Local parameter CGOVACCG after clipping" *)
  real __lp_cgovaccg;
  (* units="F"            , multiplicity="multiply",    desc="Local parameter CGBOV after clipping" *)
  real __lp_cgbov;
  (* units="F"            , multiplicity="multiply",    desc="Local parameter CINR after clipping" *)
  real __lp_cinr;
  (* units="F"            , multiplicity="multiply",    desc="Local parameter CINRD after clipping" *)
  real __lp_cinrd;
  (* units="V"            ,                             desc="Local parameter DVFBINR after clipping" *)
  real __lp_dvfbinr;
  (* units=""             ,                             desc="Local parameter FCINRDEP after clipping" *)
  real __lp_fcinrdep;
  (* units=""             ,                             desc="Local parameter FCINRACC after clipping" *)
  real __lp_fcinracc;
  (* units=""             ,                             desc="Local parameter AXINR after clipping" *)
  real __lp_axinr;
  (* units="F"            , multiplicity="multiply",    desc="Local parameter CFR after clipping" *)
  real __lp_cfr;
  (* units="F"            , multiplicity="multiply",    desc="Local parameter CFRD after clipping" *)
  real __lp_cfrd;
  (* units=""             ,                             desc="Local parameter FNT after clipping" *)
  real __lp_fnt;
  (* units=""             ,                             desc="Local parameter FNTEXC after clipping" *)
  real __lp_fntexc;
  (* units="1/(V m^4)"    ,                             desc="Local parameter NFA after clipping" *)
  real __lp_nfa;
  (* units="1/(V m^4)"    ,                             desc="Local parameter NFB after clipping" *)
  real __lp_nfb;
  (* units="V^-1"         ,                             desc="Local parameter NFC after clipping" *)
  real __lp_nfc;
  (* units=""             ,                             desc="Local parameter EF after clipping" *)
  real __lp_ef;
  (* units="V"            ,                             desc="Local parameter VFBEDGE after T-scaling and clipping" *)
  real __lp_vfbedge;
  (* units="V/K"          ,                             desc="Local parameter STVFBEDGE after clipping" *)
  real __lp_stvfbedge;
  (* units="V"            ,                             desc="Local parameter DPHIBEDGE after clipping" *)
  real __lp_dphibedge;
  (* units="m^-3"         ,                             desc="Local parameter NEFFEDGE after clipping" *)
  real __lp_neffedge;
  (* units=""             ,                             desc="Local parameter CTEDGE after clipping" *)
  real __lp_ctedge;
  (* units="m^2/V/s"      ,                             desc="Local parameter BETNEDGE after T-scaling and clipping" *)
  real __lp_betnedge;
  (* units=""             ,                             desc="Local parameter STBETEDGE after clipping" *)
  real __lp_stbetedge;
  (* units=""             ,                             desc="Local parameter PSCEEDGE after clipping" *)
  real __lp_psceedge;
  (* units="V^-1"         ,                             desc="Local parameter PSCEBEDGE after clipping" *)
  real __lp_pscebedge;
  (* units="V^-1"         ,                             desc="Local parameter PSCEDEDGE after clipping" *)
  real __lp_pscededge;
  (* units="V"            ,                             desc="Local parameter CFEDGE after clipping" *)
  real __lp_cfedge;
  (* units="V^-1"         ,                             desc="Local parameter CFDEDGE after clipping" *)
  real __lp_cfdedge;
  (* units="V^-1"         ,                             desc="Local parameter CFBEDGE after clipping" *)
  real __lp_cfbedge;
  (* units=""             ,                             desc="Local parameter FNTEDGE after clipping" *)
  real __lp_fntedge;
  (* units="1/(V m^4)"    ,                             desc="Local parameter NFAEDGE after clipping" *)
  real __lp_nfaedge;
  (* units="1/(V m^4)"    ,                             desc="Local parameter NFBEDGE after clipping" *)
  real __lp_nfbedge;
  (* units="V^-1"         ,                             desc="Local parameter NFCEDGE after clipping" *)
  real __lp_nfcedge;
  (* units=""             ,                             desc="Local parameter EFEDGE after clipping" *)
  real __lp_efedge;
  (* units="Ohm"          , multiplicity="divide",      desc="Local parameter RG after clipping" *)
  real __lp_rg;
  (* units="Ohm"          , multiplicity="divide",      desc="Local parameter RSE after clipping" *)
  real __lp_rse;
  (* units="Ohm"          , multiplicity="divide",      desc="Local parameter RDE after clipping" *)
  real __lp_rde;
  (* units="Ohm"          , multiplicity="divide",      desc="Local parameter RBULK after clipping" *)
  real __lp_rbulk;
  (* units="Ohm"          , multiplicity="divide",      desc="Local parameter RWELL after clipping" *)
  real __lp_rwell;
  (* units="Ohm"          , multiplicity="divide",      desc="Local parameter RJUNS after clipping" *)
  real __lp_rjuns;
  (* units="Ohm"          , multiplicity="divide",      desc="Local parameter RJUND after clipping" *)
  real __lp_rjund;
  (* units="K"            ,                             desc="Device Temperature" *)
  real __tk;
  (* units="F"            , multiplicity="multiply",    desc="Bottom component of total zero-bias source junction capacitance at device temperature" *)
  real __cjosbot;
  (* units="F"            , multiplicity="multiply",    desc="STI-edge component of total zero-bias source junction capacitance at device temperature" *)
  real __cjossti;
  (* units="F"            , multiplicity="multiply",    desc="Gate-edge component of total zero-bias source junction capacitance at device temperature" *)
  real __cjosgat;
  (* units="V"            ,                             desc="Built-in voltage of source-side bottom junction at device temperature" *)
  real __vbisbot;
  (* units="V"            ,                             desc="Built-in voltage of source-side STI-edge junction at device temperature" *)
  real __vbissti;
  (* units="V"            ,                             desc="Built-in voltage of source-side gate-edge junction at device temperature" *)
  real __vbisgat;
  (* units="A"            , multiplicity="multiply",    desc="Total source-side bottom junction saturation current" *)
  real __idsatsbot;
  (* units="A"            , multiplicity="multiply",    desc="Total source-side STI-edge junction saturation current" *)
  real __idsatssti;
  (* units="A"            , multiplicity="multiply",    desc="Total source-side gate-edge junction saturation current" *)
  real __idsatsgat;
  (* units="F"            , multiplicity="multiply",    desc="Bottom component of total zero-bias drain junction capacitance at device temperature" *)
  real __cjosbotd;
  (* units="F"            , multiplicity="multiply",    desc="STI-edge component of total zero-bias drain junction capacitance at device temperature" *)
  real __cjosstid;
  (* units="F"            , multiplicity="multiply",    desc="Gate-edge component of total zero-bias drain junction capacitance at device temperature" *)
  real __cjosgatd;
  (* units="V"            ,                             desc="Built-in voltage of drain-side bottom junction at device temperature" *)
  real __vbisbotd;
  (* units="V"            ,                             desc="Built-in voltage of drain-side STI-edge junction at device temperature" *)
  real __vbisstid;
  (* units="V"            ,                             desc="Built-in voltage of drain-side gate-edge junction at device temperature" *)
  real __vbisgatd;
  (* units="A"            , multiplicity="multiply",    desc="Total drain-side bottom junction saturation current" *)
  real __idsatsbotd;
  (* units="A"            , multiplicity="multiply",    desc="Total drain-side STI-edge junction saturation current" *)
  real __idsatsstid;
  (* units="A"            , multiplicity="multiply",    desc="Total drain-side gate-edge junction saturation current" *)
  real __idsatsgatd;
  (* units=""             ,                             desc="Local parameter MUNQS after clipping" *)
  real __lp_munqs;

  analog begin
    begin : initial_model
      if (1) begin
        __CHNL_TYPE = 1;
      end
      else begin
      end
      __EPSSI =  104.47941624768e-12;
      if ((__SWNQS <  0.5)) begin
        __SWNQS_i = 0;
      end
      else begin
        if ((__SWNQS <  1.5)) begin
          __SWNQS_i = 1;
        end
        else begin
          if ((__SWNQS <  2.5)) begin
            __SWNQS_i = 2;
          end
          else begin
            if ((__SWNQS <  4.0)) begin
              __SWNQS_i = 3;
            end
            else begin
              if ((__SWNQS <  7.0)) begin
                __SWNQS_i = 5;
              end
              else begin
                __SWNQS_i = 9;
              end
            end
          end
        end
      end
      __r_nqs =  1.0e+3;
      __vnorm =  10.0;
      __vnorm_inv = ( 1.0 / __vnorm);
      __CFACL_i =  89.001e-9;
      if (0) begin
      end
      __CFACLEXP_i =  3.9688;
      if (0) begin
      end
      __CFACW_i = -0.17956;
      if (0) begin
      end
      __THESATACO_i =  0.39843;
      if (0) begin
      end
      __THESATACL_i =  0.3405958;
      if (0) begin
      end
      __THESATACLEXP_i =  1.0316;
      if (0) begin
      end
      __THESATACW_i =  0.192375;
      if (0) begin
      end
      __THESATACLW_i = -0.00269588;
      if (0) begin
      end
      __AXACO_i =  13.547;
      if (0) begin
      end
      __AXACL_i =  1.0186;
      if (0) begin
      end
      __ALPACL_i =  0.0088345;
      if (0) begin
      end
      __ALPACLEXP_i =  0.68143;
      if (0) begin
      end
      __ALPACW_i =  1.0825;
      if (0) begin
      end
      __POCFAC_i =  0.0;
      if (0) begin
      end
      __PLCFAC_i =  0.0;
      if (0) begin
      end
      __PWCFAC_i =  0.0;
      if (0) begin
      end
      __PLWCFAC_i =  0.0;
      if (0) begin
      end
      __POTHESATAC_i =  1.0;
      if (0) begin
      end
      __PLTHESATAC_i =  0.0;
      if (0) begin
      end
      __PWTHESATAC_i =  0.0;
      if (0) begin
      end
      __PLWTHESATAC_i =  0.0;
      if (0) begin
      end
      __POAXAC_i =  3.0;
      if (0) begin
      end
      __PLAXAC_i =  0.0;
      if (0) begin
      end
      __PWAXAC_i =  0.0;
      if (0) begin
      end
      __PLWAXAC_i =  0.0;
      if (0) begin
      end
      __POALPAC_i =  0.01;
      if (0) begin
      end
      __PLALPAC_i =  0.0;
      if (0) begin
      end
      __PWALPAC_i =  0.0;
      if (0) begin
      end
      __PLWALPAC_i =  0.0;
      if (0) begin
      end
      __KVSATAC_i =  0.0;
      if (0) begin
      end
      __TKR =  300.15;
      __TKA = ($temperature + __DTA);
      __rTa = (__TKA / __TKR);
      __delTa = (__TKA - __TKR);
      __phita = (__TKA *  86.1726105451295e-6);
      __inv_phita = ( 1.0 / __phita);
      __TKD = __TKA;
      __TKD_sq = (__TKD * __TKD);
      __delT = (__TKD - __TKR);
      __rTn = (__TKR / __TKD);
      __ln_rTn = ln(__rTn);
      __phit = (__TKD *  86.1726105451295e-6);
      __inv_phit = ( 1.0 / __phit);
      __Eg = (( 1.179 - (__TKD *  90.25e-6)) - (__TKD_sq *  305.0e-9));
      __phibFac = (((((__TKD *  450.0e-6) +  1.045) * (((__TKD *  0.0014) +  0.523) - (__TKD_sq *  1.48e-6))) * __TKD_sq) /  90.0e+3);
      __phibFac = (((__phibFac >  0.001))? (__phibFac):( 0.001));
      __nt0 = (__TKD *  55.22602e-24);
      __SWJUNEXP_i =  0.0;
      if (0) begin
      end
      else begin
        __SWJUNEXP_i =  0.0;
      end
      if (1) begin
        __CJORBOTD_i =  976.36e-6;
        __CJORSTID_i =  25.279e-12;
        __CJORGATD_i =  30.0e-12;
        __VBIRBOTD_i =  0.70829;
        __VBIRSTID_i =  0.79368;
        __VBIRGATD_i =  2.0;
        __PBOTD_i =  0.31309;
        __PSTID_i =  0.27362;
        __PGATD_i =  0.5424;
        __PHIGBOTD_i =  1.1136;
        __PHIGSTID_i =  1.3844;
        __PHIGGATD_i =  1.16;
        __IDSATRBOTD_i =  63.087e-9;
        __IDSATRSTID_i =  1.9278e-15;
        __IDSATRGATD_i =  0.0;
        __CSRHBOTD_i =  100.0;
        __CSRHSTID_i =  100.0e-6;
        __CSRHGATD_i =  6.682e-6;
        __XJUNSTID_i =  157.83e-9;
        __XJUNGATD_i =  100.0e-6;
        __CTATBOTD_i =  100.0;
        __CTATSTID_i =  100.0e-6;
        __CTATGATD_i =  100.0e-6;
        __MEFFTATBOTD_i =  5.204;
        __MEFFTATSTID_i =  3.364;
        __MEFFTATGATD_i =  0.25;
        __CBBTBOTD_i =  1.0e-12;
        __CBBTSTID_i =  1.0e-21;
        __CBBTGATD_i =  1.0e-18;
        __FBBTRBOTD_i =  1.0e+9;
        __FBBTRSTID_i =  1.0e+9;
        __FBBTRGATD_i =  1.0e+9;
        __STFBBTBOTD_i = -0.001;
        __STFBBTSTID_i = -0.001;
        __STFBBTGATD_i = -0.001;
        __VBRBOTD_i =  10.0;
        __VBRSTID_i =  10.0;
        __VBRGATD_i =  10.0;
        __PBRBOTD_i =  4.0;
        __PBRSTID_i =  4.0;
        __PBRGATD_i =  4.0;
        __VJUNREFD_i =  2.5;
        __FJUNQD_i =  0.03;
      end
      else begin
      end
      __tkr =  294.15;
      __tkd = max(($temperature + __DTA),  23.15);
      __auxt = (__tkd / __tkr);
      __KBOL_over_QELE =  86.1726105451295e-6;
      __phitr = (__KBOL_over_QELE * __tkr);
      __phitrinv = ( 1.0 / __phitr);
      __phitd = (__KBOL_over_QELE * __tkd);
      __phitdinv = ( 1.0 / __phitd);
      __deltaphigr = ((- ((__tkr *  702.0e-6) * __tkr)) / (__tkr +  1.108e+3));
      __phigrbot = (__deltaphigr +  1.1136);
      __phigrsti = (__deltaphigr +  1.3844);
      __phigrgat = (__deltaphigr +  1.16);
      __deltaphigd = ((- ((__tkd *  702.0e-6) * __tkd)) / (__tkd +  1.108e+3));
      __phigdbot = (__deltaphigd +  1.1136);
      __phigdsti = (__deltaphigd +  1.3844);
      __phigdgat = (__deltaphigd +  1.16);
      __ftdbot = (pow(__auxt,  1.5) * exp((((__phigrbot * __phitrinv) - (__phigdbot * __phitdinv)) *  0.5)));
      __ftdsti = (pow(__auxt,  1.5) * exp((((__phigrsti * __phitrinv) - (__phigdsti * __phitdinv)) *  0.5)));
      __ftdgat = (pow(__auxt,  1.5) * exp((((__phigrgat * __phitrinv) - (__phigdgat * __phitdinv)) *  0.5)));
      __idsatbot = ((__ftdbot *  63.087e-9) * __ftdbot);
      __idsatsti = ((__ftdsti *  1.9278e-15) * __ftdsti);
      __idsatgat =  0.0;
      __ubibot = ((__auxt *  0.70829) - ((__phitd *  2.0) * ln(__ftdbot)));
      __ubisti = ((__auxt *  0.79368) - ((__phitd *  2.0) * ln(__ftdsti)));
      __ubigat = ((__auxt *  2.0) - ((__phitd *  2.0) * ln(__ftdgat)));
      __vbibot = (__ubibot + (__phitd * ln((exp((( 0.05 - __ubibot) * __phitdinv)) + 1))));
      __vbisti = (__ubisti + (__phitd * ln((exp((( 0.05 - __ubisti) * __phitdinv)) + 1))));
      __vbigat = (__ubigat + (__phitd * ln((exp((( 0.05 - __ubigat) * __phitdinv)) + 1))));
      __vbiinvbot = ( 1.0 / __vbibot);
      __vbiinvsti = ( 1.0 / __vbisti);
      __vbiinvgat = ( 1.0 / __vbigat);
      __one_minus_PBOT =  0.68691;
      __one_minus_PSTI =  0.72638;
      __one_minus_PGAT =  0.4576;
      __one_over_one_minus_PBOT = ( 1.0 / __one_minus_PBOT);
      __one_over_one_minus_PSTI = ( 1.0 / __one_minus_PSTI);
      __one_over_one_minus_PGAT = ( 1.0 / __one_minus_PGAT);
      __cjobot = (pow((__vbiinvbot *  0.70829),  0.31309) *  976.36e-6);
      __cjosti = (pow((__vbiinvsti *  0.79368),  0.27362) *  25.279e-12);
      __cjogat = (pow((__vbiinvgat *  2.0),  0.5424) *  30.0e-12);
      __qprefbot = ((__cjobot * __vbibot) * __one_over_one_minus_PBOT);
      __qprefsti = ((__cjosti * __vbisti) * __one_over_one_minus_PSTI);
      __qprefgat = ((__cjogat * __vbigat) * __one_over_one_minus_PGAT);
      __qpref2bot = (__cjobot *  2.0);
      __qpref2sti = (__cjosti *  2.0);
      __qpref2gat = (__cjogat *  2.0);
      __wdepnulrbot = (__EPSSI /  976.36e-6);
      __wdepnulrsti = (__EPSSI *  6.24352229122988e+3);
      __wdepnulrgat = (__EPSSI *  3.33333333333333e+6);
      __wdepnulrinvbot = ( 1.0 / __wdepnulrbot);
      __wdepnulrinvsti = ( 1.0 / __wdepnulrsti);
      __wdepnulrinvgat = ( 1.0 / __wdepnulrgat);
      __VBIRBOTinv =  1.4118510779483;
      __VBIRSTIinv =  1.25995363370628;
      __VBIRGATinv =  0.5;
      __perfc =  0.517816437097108;
      __berfc = (( 4.5392668 - pow(__perfc, -2.0)) /  3.0);
      __cerfc = ( 0.70785336 - __berfc);
      __deltaEbot = max((__phigdbot *  0.5), __phitd);
      __deltaEsti = max((__phigdsti *  0.5), __phitd);
      __deltaEgat = max((__phigdgat *  0.5), __phitd);
      __atatbot = (__deltaEbot * __phitdinv);
      __atatsti = (__deltaEsti * __phitdinv);
      __atatgat = (__deltaEgat * __phitdinv);
      __btatpartbot = (sqrt((((__deltaEbot * __deltaEbot) * __deltaEbot) *  24.304725138333e-48)) /  316.371504e-36);
      __btatpartsti = (sqrt((((__deltaEsti * __deltaEsti) * __deltaEsti) *  15.711202030237e-48)) /  316.371504e-36);
      __btatpartgat = (sqrt((((__deltaEgat * __deltaEgat) * __deltaEgat) *  1.1675982483826e-48)) /  316.371504e-36);
      __fbbtbot = ((((__tkd - __tkr) * -0.001) +  1.0) *  1.0e+9);
      __fbbtsti = ((((__tkd - __tkr) * -0.001) +  1.0) *  1.0e+9);
      __fbbtgat = ((((__tkd - __tkr) * -0.001) +  1.0) *  1.0e+9);
      __fbbtbot = (((__fbbtbot >  0.0))? (__fbbtbot):( 0.0));
      __fbbtsti = (((__fbbtsti >  0.0))? (__fbbtsti):( 0.0));
      __fbbtgat = (((__fbbtgat >  0.0))? (__fbbtgat):( 0.0));
      __alphaav =  0.999;
      __fstopbot = ( 1.0 / ( 1.0 - pow(__alphaav,  4.0)));
      __fstopsti = ( 1.0 / ( 1.0 - pow(__alphaav,  4.0)));
      __fstopgat = ( 1.0 / ( 1.0 - pow(__alphaav,  4.0)));
      __VBRinvbot =  0.1;
      __VBRinvsti =  0.1;
      __VBRinvgat =  0.1;
      __slopebot = (((- ((__fstopbot * __fstopbot) * pow(__alphaav,  3.0))) *  4.0) * __VBRinvbot);
      __slopesti = (((- ((__fstopsti * __fstopsti) * pow(__alphaav,  3.0))) *  4.0) * __VBRinvsti);
      __slopegat = (((- ((__fstopgat * __fstopgat) * pow(__alphaav,  3.0))) *  4.0) * __VBRinvgat);
      __phigrbot_d = (__PHIGBOTD_i + __deltaphigr);
      __phigrsti_d = (__PHIGSTID_i + __deltaphigr);
      __phigrgat_d = (__PHIGGATD_i + __deltaphigr);
      __phigdbot_d = (__PHIGBOTD_i + __deltaphigd);
      __phigdsti_d = (__PHIGSTID_i + __deltaphigd);
      __phigdgat_d = (__PHIGGATD_i + __deltaphigd);
      __ftdbot_d = (pow(__auxt,  1.5) * exp((((__phigrbot_d * __phitrinv) - (__phigdbot_d * __phitdinv)) *  0.5)));
      __ftdsti_d = (pow(__auxt,  1.5) * exp((((__phigrsti_d * __phitrinv) - (__phigdsti_d * __phitdinv)) *  0.5)));
      __ftdgat_d = (pow(__auxt,  1.5) * exp((((__phigrgat_d * __phitrinv) - (__phigdgat_d * __phitdinv)) *  0.5)));
      __idsatbot_d = ((__IDSATRBOTD_i * __ftdbot_d) * __ftdbot_d);
      __idsatsti_d = ((__IDSATRSTID_i * __ftdsti_d) * __ftdsti_d);
      __idsatgat_d = ((__IDSATRGATD_i * __ftdgat_d) * __ftdgat_d);
      __ubibot_d = ((__VBIRBOTD_i * __auxt) - ((__phitd *  2.0) * ln(__ftdbot_d)));
      __ubisti_d = ((__VBIRSTID_i * __auxt) - ((__phitd *  2.0) * ln(__ftdsti_d)));
      __ubigat_d = ((__VBIRGATD_i * __auxt) - ((__phitd *  2.0) * ln(__ftdgat_d)));
      __vbibot_d = (__ubibot_d + (__phitd * ln((exp((( 0.05 - __ubibot_d) * __phitdinv)) +  1.0))));
      __vbisti_d = (__ubisti_d + (__phitd * ln((exp((( 0.05 - __ubisti_d) * __phitdinv)) +  1.0))));
      __vbigat_d = (__ubigat_d + (__phitd * ln((exp((( 0.05 - __ubigat_d) * __phitdinv)) +  1.0))));
      __vbiinvbot_d = ( 1.0 / __vbibot_d);
      __vbiinvsti_d = ( 1.0 / __vbisti_d);
      __vbiinvgat_d = ( 1.0 / __vbigat_d);
      __one_minus_PBOT_d = ( 1.0 - __PBOTD_i);
      __one_minus_PSTI_d = ( 1.0 - __PSTID_i);
      __one_minus_PGAT_d = ( 1.0 - __PGATD_i);
      __one_over_one_minus_PBOT_d = ( 1.0 / __one_minus_PBOT_d);
      __one_over_one_minus_PSTI_d = ( 1.0 / __one_minus_PSTI_d);
      __one_over_one_minus_PGAT_d = ( 1.0 / __one_minus_PGAT_d);
      __cjobot_d = (__CJORBOTD_i * pow((__VBIRBOTD_i * __vbiinvbot_d), __PBOTD_i));
      __cjosti_d = (__CJORSTID_i * pow((__VBIRSTID_i * __vbiinvsti_d), __PSTID_i));
      __cjogat_d = (__CJORGATD_i * pow((__VBIRGATD_i * __vbiinvgat_d), __PGATD_i));
      __qprefbot_d = ((__cjobot_d * __vbibot_d) * __one_over_one_minus_PBOT_d);
      __qprefsti_d = ((__cjosti_d * __vbisti_d) * __one_over_one_minus_PSTI_d);
      __qprefgat_d = ((__cjogat_d * __vbigat_d) * __one_over_one_minus_PGAT_d);
      __qpref2bot_d = (__cjobot_d *  2.0);
      __qpref2sti_d = (__cjosti_d *  2.0);
      __qpref2gat_d = (__cjogat_d *  2.0);
      __wdepnulrbot_d = (__EPSSI / __CJORBOTD_i);
      __wdepnulrsti_d = ((__XJUNSTID_i * __EPSSI) / __CJORSTID_i);
      __wdepnulrgat_d = ((__XJUNGATD_i * __EPSSI) / __CJORGATD_i);
      __wdepnulrinvbot_d = ( 1.0 / __wdepnulrbot_d);
      __wdepnulrinvsti_d = ( 1.0 / __wdepnulrsti_d);
      __wdepnulrinvgat_d = ( 1.0 / __wdepnulrgat_d);
      __VBIRBOTinv_d = ( 1.0 / __VBIRBOTD_i);
      __VBIRSTIinv_d = ( 1.0 / __VBIRSTID_i);
      __VBIRGATinv_d = ( 1.0 / __VBIRGATD_i);
      __deltaEbot_d = max((__phigdbot_d *  0.5), __phitd);
      __deltaEsti_d = max((__phigdsti_d *  0.5), __phitd);
      __deltaEgat_d = max((__phigdgat_d *  0.5), __phitd);
      __atatbot_d = (__deltaEbot_d * __phitdinv);
      __atatsti_d = (__deltaEsti_d * __phitdinv);
      __atatgat_d = (__deltaEgat_d * __phitdinv);
      __btatpartbot_d = (sqrt(((__MEFFTATBOTD_i *  4.6703929935305e-48) * ((__deltaEbot_d * __deltaEbot_d) * __deltaEbot_d))) /  316.371504e-36);
      __btatpartsti_d = (sqrt(((__MEFFTATSTID_i *  4.6703929935305e-48) * ((__deltaEsti_d * __deltaEsti_d) * __deltaEsti_d))) /  316.371504e-36);
      __btatpartgat_d = (sqrt(((__MEFFTATGATD_i *  4.6703929935305e-48) * ((__deltaEgat_d * __deltaEgat_d) * __deltaEgat_d))) /  316.371504e-36);
      __fbbtbot_d = (__FBBTRBOTD_i * ((__STFBBTBOTD_i * (__tkd - __tkr)) +  1.0));
      __fbbtsti_d = (__FBBTRSTID_i * ((__STFBBTSTID_i * (__tkd - __tkr)) +  1.0));
      __fbbtgat_d = (__FBBTRGATD_i * ((__STFBBTGATD_i * (__tkd - __tkr)) +  1.0));
      __fbbtbot_d = (((__fbbtbot_d >  0.0))? (__fbbtbot_d):( 0.0));
      __fbbtsti_d = (((__fbbtsti_d >  0.0))? (__fbbtsti_d):( 0.0));
      __fbbtgat_d = (((__fbbtgat_d >  0.0))? (__fbbtgat_d):( 0.0));
      __fstopbot_d = ( 1.0 / ( 1.0 - pow(__alphaav, __PBRBOTD_i)));
      __fstopsti_d = ( 1.0 / ( 1.0 - pow(__alphaav, __PBRSTID_i)));
      __fstopgat_d = ( 1.0 / ( 1.0 - pow(__alphaav, __PBRGATD_i)));
      __VBRinvbot_d = ( 1.0 / __VBRBOTD_i);
      __VBRinvsti_d = ( 1.0 / __VBRSTID_i);
      __VBRinvgat_d = ( 1.0 / __VBRGATD_i);
      __slopebot_d = (((- ((__fstopbot_d * __fstopbot_d) * pow(__alphaav, (__PBRBOTD_i -  1.0)))) * __PBRBOTD_i) * __VBRinvbot_d);
      __slopesti_d = (((- ((__fstopsti_d * __fstopsti_d) * pow(__alphaav, (__PBRSTID_i -  1.0)))) * __PBRSTID_i) * __VBRinvsti_d);
      __slopegat_d = (((- ((__fstopgat_d * __fstopgat_d) * pow(__alphaav, (__PBRGATD_i -  1.0)))) * __PBRGATD_i) * __VBRinvgat_d);
      __gmin = $simparam("gmin",  0.0);
    end
    begin : initial_instance
      real Invsa, Invsb, Invsaref, Invsbref, Kstressu0, rhobeta, rhobetaref, Kstressvth0;
      real temp0, temp00, templ, tempw, Lx, Wx, loop, tmpa, tmpb;
      __NF_i =  1.0;
      __invNF =  1.0;
      __LE =  0.0;
      __WE =  0.0;
      __L_i = __L;
      __W_i = __W;
      __SA_i =  0.0;
      __SB_i =  0.0;
      __SD_i =  0.0;
      __SC_i =  0.0;
      __XGW_i =  100.0e-9;
      __ABSOURCE_i =  1.0e-12;
      __LSSOURCE_i =  1.0e-6;
      __LGSOURCE_i =  1.0e-6;
      __ABDRAIN_i =  1.0e-12;
      __LSDRAIN_i =  1.0e-6;
      __LGDRAIN_i =  1.0e-6;
      __AS_i = __AS;
      __PS_i = __PS;
      __AD_i = __AD;
      __PD_i = __PD;
      __JW_i =  1.0e-6;
      if (1) begin
        __NF_i = (((__NF >  1.0))? (__NF):( 1.0));
        __NF_i = $floor((__NF_i +  0.5));
        __invNF = ( 1.0 / __NF_i);
      end
      __W_i = ((((__W_i * __invNF) >  1.0e-9))? ((__W_i * __invNF)):( 1.0e-9));
      __SCA_i =  0.0;
      __SCB_i =  0.0;
      __SCC_i =  0.0;
      __NGCON_i = (((__NGCON <  1.5))? ( 1.0):( 2.0));
      __iL = ( 1.0e-6 / __L_i);
      __iW = ( 1.0e-6 / __W_i);
      __delLPS =  0.0;
      __delWOD =  0.0;
      if (0) begin
      end
      __LE = (((((__L_i + __delLPS) -  58.846e-9) >  1.0e-9))? (((__L_i + __delLPS) -  58.846e-9)):( 1.0e-9));
      __WE = (((((__W_i + __delWOD) - -20.0e-9) >  1.0e-9))? (((__W_i + __delWOD) - -20.0e-9)):( 1.0e-9));
      __LEcv = ((((((__L_i + __delLPS) -  58.846e-9) + __DLQ) >  1.0e-9))? ((((__L_i + __delLPS) -  58.846e-9) + __DLQ)):( 1.0e-9));
      __WEcv = ((((((__W_i + __delWOD) - -20.0e-9) + __DWQ) >  1.0e-9))? ((((__W_i + __delWOD) - -20.0e-9) + __DWQ)):( 1.0e-9));
      __Lcv = (((((__L_i + __delLPS) + __DLQ) >  1.0e-9))? (((__L_i + __delLPS) + __DLQ)):( 1.0e-9));
      __Wcv = (((((__W_i + __delWOD) + __DWQ) >  1.0e-9))? (((__W_i + __delWOD) + __DWQ)):( 1.0e-9));
      __iLE = ( 1.0e-6 / __LE);
      __iWE = ( 1.0e-6 / __WE);
      __L_f = ((((__L_i + __delLPS) >  1.0e-9))? ((__L_i + __delLPS)):( 1.0e-9));
      __L_slif = (((__L_f >  1.0e-9))? (__L_f):( 1.0e-9));
      __W_f = ((((__W_i + __delWOD) >  1.0e-9))? ((__W_i + __delWOD)):( 1.0e-9));
      __XGWE = ((((__XGW_i - (__delWOD *  0.5)) >  1.0e-9))? ((__XGW_i - (__delWOD *  0.5))):( 1.0e-9));
      __VFB_p = -1.0;
      __STVFB_p =  500.0e-6;
      __ST2VFB_p =  0.0;
      __TOX_p =  2.0e-9;
      __EPSROX_p =  3.9;
      __NEFF_p =  500.0e+21;
      __FACNEFFAC_p =  1.0;
      __GFACNUD_p =  1.0;
      __VSBNUD_p =  0.0;
      __DVSBNUD_p =  1.0;
      __VNSUB_p =  0.0;
      __NSLP_p =  0.05;
      __DNSUB_p =  0.0;
      __DPHIB_p =  0.0;
      __DELVTAC_p =  0.0;
      __NP_p =  100.0e+24;
      __TOXOV_p =  2.0e-9;
      __TOXOVD_p =  2.0e-9;
      __NOV_p =  50.0e+24;
      __NOVD_p =  50.0e+24;
      __CT_p =  0.0;
      __CTG_p =  0.0;
      __CTB_p =  0.0;
      __STCT_p =  1.0;
      __PSCE_p =  0.0;
      __PSCED_p =  0.0;
      __PSCEB_p =  0.0;
      __CF_p =  0.0;
      __CFAC_p =  0.0;
      if (0) begin
      end
      __CFD_p =  0.0;
      __CFB_p =  0.0;
      __BETN_p =  0.07;
      __STBET_p =  1.0;
      __MUE_p =  0.5;
      __STMUE_p =  0.0;
      __THEMU_p =  1.5;
      __STTHEMU_p =  1.5;
      __CS_p =  0.0;
      __STCS_p =  0.0;
      __THECS_p =  2.0;
      __STTHECS_p =  0.0;
      __XCOR_p =  0.0;
      __STXCOR_p =  0.0;
      __FETA_p =  1.0;
      __RS_p =  30.0;
      __STRS_p =  1.0;
      __RSB_p =  0.0;
      __RSG_p =  0.0;
      __THESAT_p =  1.0;
      __THESATAC_p =  1.0;
      if (0) begin
      end
      __STTHESAT_p =  1.0;
      __THESATB_p =  0.0;
      __THESATG_p =  0.0;
      __AX_p =  3.0;
      __AXAC_p =  3.0;
      if (0) begin
      end
      __ALP_p =  0.01;
      __ALPAC_p =  0.01;
      if (0) begin
      end
      __ALP1_p =  0.0;
      __ALP2_p =  0.0;
      __VP_p =  0.05;
      __A1_p =  1.0;
      __A2_p =  10.0;
      __STA2_p =  0.0;
      __A3_p =  1.0;
      __A4_p =  0.0;
      __GCO_p =  0.0;
      __IGINV_p =  0.0;
      __IGOV_p =  0.0;
      __IGOVD_p =  0.0;
      __STIG_p =  2.0;
      __GC2_p =  0.375;
      __GC3_p =  0.063;
      __GC2OV_p =  0.375;
      __GC3OV_p =  0.063;
      __CHIB_p =  3.1;
      __AGIDL_p =  0.0;
      __AGIDLD_p =  0.0;
      __BGIDL_p =  41.0;
      __BGIDLD_p =  41.0;
      __STBGIDL_p =  0.0;
      __STBGIDLD_p =  0.0;
      __CGIDL_p =  0.0;
      __CGIDLD_p =  0.0;
      __COX_p =  10.0e-15;
      __CGOV_p =  1.0e-15;
      __CGOVD_p =  1.0e-15;
      __FCGOVACC_p =  0.0;
      __FCGOVACCD_p =  0.0;
      __CGOVACCG_p =  1.0;
      __CGBOV_p =  0.0;
      __CINR_p =  0.0;
      __CINRD_p =  0.0;
      __DVFBINR_p =  0.0;
      __FCINRDEP_p =  0.3;
      __FCINRACC_p =  0.5;
      __AXINR_p =  0.5;
      __CFR_p =  0.0;
      __CFRD_p =  0.0;
      __FNT_p =  1.0;
      __FNTEXC_p =  0.0;
      __NFA_p =  80.0e+21;
      __NFB_p =  30.0e+6;
      __NFC_p =  0.0;
      __EF_p =  1.0;
      __VFBEDGE_p = -1.0;
      __STVFBEDGE_p =  500.0e-6;
      __DPHIBEDGE_p =  0.0;
      __NEFFEDGE_p =  500.0e+21;
      __CTEDGE_p =  0.0;
      __BETNEDGE_p =  500.0e-6;
      __STBETEDGE_p =  1.0;
      __PSCEEDGE_p =  0.0;
      __PSCEBEDGE_p =  0.0;
      __PSCEDEDGE_p =  0.0;
      __CFEDGE_p =  0.0;
      __CFDEDGE_p =  0.0;
      __CFBEDGE_p =  0.0;
      __FNTEDGE_p =  1.0;
      __NFAEDGE_p =  80.0e+21;
      __NFBEDGE_p =  30.0e+6;
      __NFCEDGE_p =  0.0;
      __EFEDGE_p =  1.0;
      __RG_p =  0.0;
      __RSE_p =  0.0;
      __RDE_p =  0.0;
      __RWELL_p =  0.0;
      __RBULK_p =  0.0;
      __RJUNS_p =  0.0;
      __RJUND_p =  0.0;
      __MUNQS_p =  1.0;
      if (1) begin
        __VFB_p = ((((__iLE *  0.013965) + -0.94312) + (__iWE * -0.027122)) + ((__iLE *  0.0044814) * __iWE));
        __STVFB_p = ((((__iLE *  28.624e-6) +  687.85e-6) + (__iWE * -18.689e-6)) + ((__iLE *  514.35e-9) * __iWE));
        __ST2VFB_p =  0.0;
        __TOX_p =  2.2404e-9;
        __EPSROX_p =  3.9;
        __NSUB0e = (((((((__iWE *  7.5708) * ln(((__WE /  5.3426e-6) +  1.0))) +  1.0) >  0.001))? ((((__iWE *  7.5708) * ln(((__WE /  5.3426e-6) +  1.0))) +  1.0)):( 0.001)) *  104.83e+21);
        __NPCKe = (((((((__iWE * -1.484) * ln(((__WE /  10.0e-9) +  1.0))) +  1.0) >  0.001))? ((((__iWE * -1.484) * ln(((__WE /  10.0e-9) +  1.0))) +  1.0)):( 0.001)) *  1.743e+21);
        __LPCKe =  317.1e-9;
        if ((__LE > (__LPCKe *  2.0))) begin
          __AA =  75.0e+9;
          __BB = (sqrt((__NSUB0e + (__NPCKe *  0.5))) - sqrt(__NSUB0e));
          __NSUB = (sqrt(__NSUB0e) + (__AA * ln(((((__LPCKe *  2.0) / __LE) * (exp((__BB / __AA)) -  1.0)) +  1.0))));
          __NSUB = (__NSUB * __NSUB);
        end
        else begin
          if ((__LE >= __LPCKe)) begin
            __NSUB = (__NSUB0e + ((__NPCKe * __LPCKe) / __LE));
          end
          else begin
            __NSUB = (__NSUB0e + (__NPCKe * ( 2.0 - (__LE / __LPCKe))));
          end
        end
        __NEFF_p = (__NSUB * (( 1.0 - (__iLE * -0.0091066)) - ((__iLE *  0.0021139) * __iLE)));
        __FACNEFFAC_p =  1.0;
        __GFACNUD_p =  1.0;
        __VSBNUD_p =  0.0;
        __DVSBNUD_p =  1.0;
        __VNSUB_p =  0.0;
        __NSLP_p =  0.05;
        __DNSUB_p =  444.09e-18;
        __DPHIB_p = ((((pow(__iLE,  0.068979) *  0.232893711) + -0.255182355) + (__iWE *  0.01637832)) + ((__iLE * -0.00360498086) * __iWE));
        __DELVTAC_p =  0.0;
        __NP_p =  464.57e+24;
        __TOXOV_p =  2.2404e-9;
        __TOXOVD_p =  2.0e-9;
        __NOV_p =  35.714e+24;
        __NOVD_p =  50.0e+24;
        __CT_p = ((((pow(__iLE,  0.85719) *  0.018190064) +  0.054556) * ((__iWE * -0.096878) +  1.0)) * (((__iLE *  0.008767) * __iWE) +  1.0));
        __CTG_p =  0.0;
        __CTB_p =  0.0;
        __STCT_p =  1.0;
        __CF_p = ((pow(__iLE,  3.9688) *  89.001e-9) * ((__iWE * -0.17956) +  1.0));
        __CFAC_p = ((__CFACL_i * pow(__iLE, __CFACLEXP_i)) * ((__CFACW_i * __iWE) +  1.0));
        __CFD_p =  0.0;
        __CFB_p =  0.6952;
        __PSCE_p =  0.0;
        __PSCED_p =  0.0;
        __PSCEB_p =  0.0;
        __FBET1e = (((__iWE *  0.38931) +  1.0) *  12.168);
        __LP1e = ((((((__iWE * -0.1544) +  1.0) >  0.001))? (((__iWE * -0.1544) +  1.0)):( 0.001)) *  5.1674e-9);
        __GPE = (((((__FBET1e * __LP1e) / __LE) * ( 1.0 - exp(((- __LE) / __LP1e)))) +  1.0) + ((-44.753182e-9 / __LE) * ( 1.0 - exp(((- __LE) /  19.441e-9)))));
        __GPE = (((__GPE >  1.0e-15))? (__GPE):( 1.0e-15));
        __GWE = (((__iWE * -0.020925) +  1.0) + ((__iWE *  0.0087681) * ln(((__WE /  59.171e-9) +  1.0))));
        __BETN_p = (((__WE *  0.045582) / (__GPE * __LE)) * __GWE);
        __STBET_p = ((((__iLE * -0.036997) +  2.4165) + (__iWE *  0.0046613)) + ((__iLE *  0.0062828) * __iWE));
        __MUE_p = (((__iWE *  0.02630155) +  1.0) *  0.77874);
        __STMUE_p =  0.98971;
        __THEMU_p =  1.79921322;
        __STTHEMU_p =  4.441e-15;
        __CS_p = ((((pow(__iLE,  1.1398) *  0.12341) +  0.3164) * ((__iWE *  0.19805) +  1.0)) * (((__iLE * -441.84e-6) * __iWE) +  1.0));
        __STCS_p =  2.9406;
        __THECS_p =  1.1822;
        __STTHECS_p =  0.0;
        __XCOR_p = (((((__iLE * -0.11292) +  1.0) *  0.053934) * ((__iWE * -0.10913) +  1.0)) * (((__iLE * -0.014959) * __iWE) +  1.0));
        __STXCOR_p =  2.0;
        __FETA_p =  1.0;
        __RS_p = (__iWE *  93.6);
        __STRS_p = -0.49693;
        __RSB_p = -0.099725;
        __RSG_p =  0.074518;
        __THESAT_p = ((((((__GWE *  0.3405958) / __GPE) * pow(__iLE,  1.0316)) +  0.39843) * ((__iWE *  0.192375) +  1.0)) * (((__iLE * -0.00269588) * __iWE) +  1.0));
        __THESATAC_p = (((__THESATACO_i + (((__THESATACL_i * __GWE) / __GPE) * pow(__iLE, __THESATACLEXP_i))) * ((__THESATACW_i * __iWE) +  1.0)) * (((__THESATACLW_i * __iLE) * __iWE) +  1.0));
        __STTHESAT_p = ((((__iLE * -0.091893) +  2.7784) + (__iWE * -0.065908)) + ((__iLE *  0.01292) * __iWE));
        __THESATB_p =  0.08213;
        __THESATG_p =  0.1146;
        __AX_p = ( 13.547 / ((__iLE *  1.0186) +  1.0));
        __AXAC_p = (__AXACO_i / ((__AXACL_i * __iLE) +  1.0));
        __ALP_p = ((pow(__iLE,  0.68143) *  0.0088345) * ((__iWE *  1.0825) +  1.0));
        __ALPAC_p = ((__ALPACL_i * pow(__iLE, __ALPACLEXP_i)) * ((__ALPACW_i * __iWE) +  1.0));
        __tmpx = pow(__iLE,  0.25);
        __ALP1_p = (((__tmpx *  0.021138) * ((__iWE * -0.077622) +  1.0)) / (((__iLE *  0.04044) * __tmpx) +  1.0));
        __tmpx = pow(__iLE,  0.25);
        __ALP2_p = ((__tmpx *  2.6817) * ((__iWE * -0.13012) +  1.0));
        __VP_p =  0.32224;
        __A1_p = ((((__iLE *  0.052176) +  1.0) *  6.239) * ((__iWE * -0.052179) +  1.0));
        __A2_p =  17.75;
        __STA2_p =  0.068723;
        __A3_p = ((((__iLE * -0.045201) +  1.0) *  0.708) * ((__iWE * -0.041992) +  1.0));
        __A4_p = (((__iWE *  158.1e-18) +  1.0) *  0.04649);
        __GCO_p =  10.0;
        __IGINV_p = (__IGINVLW / (__iWE * __iLE));
        __IGOV_p = ((__LOV *  3.0268e+3) / (__iWE *  1.0e-6));
        __IGOVD_p = ( 0.0 / (__iWE *  1.0e-6));
        __STIG_p =  2.9949;
        __GC2_p =  0.8413;
        __GC3_p = -0.4698;
        __GC2OV_p =  0.375;
        __GC3OV_p =  0.063;
        __CHIB_p =  3.1;
        __AGIDL_p = ((__LOV *  0.001262) / (__iWE *  1.0e-6));
        __AGIDLD_p = ( 0.0 / (__iWE *  1.0e-6));
        __BGIDL_p =  19.92;
        __BGIDLD_p =  41.0;
        __STBGIDL_p =  0.0;
        __STBGIDLD_p =  0.0;
        __CGIDL_p =  0.06641;
        __CGIDLD_p =  0.0;
        __COX_p = (((__WEcv *  34.53133248864e-12) * __LEcv) /  2.2404e-9);
        __CGOV_p = (((__WEcv *  34.53133248864e-12) * __LOV) /  2.2404e-9);
        __CGOVD_p =  0.0;
        __FCGOVACC_p =  0.0;
        __FCGOVACCD_p =  0.0;
        __CGOVACCG_p =  1.0;
        __CGBOV_p = (__Lcv *  444.09e-24);
        __CINR_p =  0.0;
        __CINRD_p =  0.0;
        __DVFBINR_p =  0.0;
        __FCINRDEP_p =  0.3;
        __FCINRACC_p =  0.5;
        __AXINR_p =  0.5;
        __CFR_p = ((__CFRW * __Wcv) /  1.0e-6);
        __CFRD_p =  0.0;
        temp0 = ( 1.0 - (__iLE * -0.074));
        __Lnoi = (((temp0 >  0.001))? (temp0):( 0.001));
        __Lred = ( 1.0 / pow(__Lnoi,  1.869));
        __FNT_p =  1.0;
        __FNTEXC_p =  0.0;
        __NFA_p = (((__Lred * __iWE) * __iLE) *  76.16e+24);
        __NFB_p = (((__Lred * __iWE) * __iLE) *  1.026e+9);
        __NFC_p = (((__Lred * __iWE) * __iLE) * -50.0e-9);
        __EF_p =  1.0;
        __WE_edge =  20.0e-9;
        __iWE_edge = ( 1.0e-6 / __WE_edge);
        __VFBEDGE_p = -1.0;
        __STVFBEDGE_p =  500.0e-6;
        __DPHIBEDGE_p =  0.0;
        __NEFFEDGE_p =  500.0e+21;
        __CTEDGE_p =  0.0;
        __GPE_edge = ((( 0.0 / __LE) * ( 1.0 - exp(((- __LE) /  10.0e-9)))) +  1.0);
        __GPE_edge = (((__GPE_edge >  1.0e-15))? (__GPE_edge):( 1.0e-15));
        __BETNEDGE_p = ((__WE_edge *  0.045582) / (__GPE_edge * __LE));
        __STBETEDGE_p =  1.0;
        __PSCEEDGE_p =  0.0;
        __PSCEBEDGE_p =  0.0;
        __PSCEDEDGE_p =  0.0;
        __CFEDGE_p =  0.0;
        __CFDEDGE_p =  0.0;
        __CFBEDGE_p =  0.0;
        __FNTEDGE_p =  1.0;
        __NFAEDGE_p = ((__iWE_edge * __iLE) *  80.0e+21);
        __NFBEDGE_p = ((__iWE_edge * __iLE) *  30.0e+6);
        __NFCEDGE_p =  0.0;
        __EFEDGE_p =  1.0;
      end
      __KVTHOWE =  0.0;
      __KUOWE =  0.0;
      if (0) begin
      end
      if (1) begin
        __RG_p = ((((__RSHG * (((__W_f *  0.333333333333333) / __NGCON_i) + __XGWE)) / (__NGCON_i * __L_slif)) + ( 13.025e-12 / (__W_f * __L_f))) + (__NF_i * __RGO));
        __RSH_i =  0.0;
        __RSHD_i =  0.0;
        if (1) begin
          __RSHD_i = __RSH_i;
        end
        __RSE_p =  0.0;
        __RDE_p =  0.0;
        __RWELL_p = (__NF_i * __RWELLO);
        __RBULK_p = (__NF_i * __RBULKO);
        __RJUNS_p = (__NF_i * __RJUNSO);
        __RJUND_p = (__NF_i * __RJUNDO);
        __MUNQS_p =  1.0;
        tmpa =  0.0;
        tmpb =  0.0;
        loop =  0.0;
        if ((((__SA_i >  0.0) && (__SB_i >  0.0)) && ((__NF_i ==  1.0) || ((__NF_i >  1.0) && (__SD_i >  0.0))))) begin
          while ((loop < (__NF_i -  0.5))) begin
            tmpa = (tmpa + ( 1.0 / ((__SA_i + (__L_i *  0.5)) + (loop * (__SD_i + __L_i)))));
            tmpb = (tmpb + ( 1.0 / ((__SB_i + (__L_i *  0.5)) + (loop * (__SD_i + __L_i)))));
            loop = (loop +  1.0);
          end
          Invsa = (tmpa * __invNF);
          Invsb = (tmpb * __invNF);
          Invsaref = ( 1.0 / ((__L_i *  0.5) +  1.0e-6));
          Invsbref = ( 1.0 / ((__L_i *  0.5) +  1.0e-6));
          Lx = ((((__L_i + __delLPS) >  1.0e-9))? ((__L_i + __delLPS)):( 1.0e-9));
          Wx = ((((__W_i + __delWOD) >  1.0e-9))? ((__W_i + __delWOD)):( 1.0e-9));
          templ = ( 1.0 / pow(Lx,  0.0));
          tempw = ( 1.0 / pow(Wx,  0.0));
          Kstressu0 =  1.0;
          rhobeta = ( 0.0 / Kstressu0);
          rhobetaref = ( 0.0 / Kstressu0);
          templ = ( 1.0 / pow(Lx,  0.0));
          tempw = ( 1.0 / pow(Wx,  0.0));
          Kstressvth0 =  1.0;
          temp0 = (((Invsa + Invsb) - Invsaref) - Invsbref);
          temp00 = ((rhobeta +  1.0) / (rhobetaref +  1.0));
          __BETN_p = (__BETN_p * temp00);
          __THESAT_p = (__THESAT_p * temp00);
          __THESATAC_p = (((__THESATAC_p * temp00) * ((__KVSATAC_i * rhobetaref) +  1.0)) / ((__KVSATAC_i * rhobeta) +  1.0));
          __BETNEDGE_p = (__BETNEDGE_p * temp00);
          temp00 = ( 0.0 / Kstressvth0);
          __VFB_p = (__VFB_p + temp00);
          __VFBEDGE_p = (__VFBEDGE_p + temp00);
          temp00 = ( 0.0 / pow(Kstressvth0,  1.0));
          __CF_p = (__CF_p + temp00);
          __CFAC_p = (__CFAC_p + temp00);
          __CFEDGE_p = (__CFEDGE_p + temp00);
        end
        if (((((__SCA_i >  0.0) || (__SCB_i >  0.0)) || (__SCC_i >  0.0)) || (__SC_i >  0.0))) begin
          if ((((__SCA_i ==  0.0) && (__SCB_i ==  0.0)) && (__SCC_i ==  0.0))) begin
            temp0 = (__SC_i + __W_i);
            temp00 =  1.0e+6;
            __SCA_i = ( 1.0e-12 / (__SC_i * temp0));
            __SCB_i = (((((__SC_i *  0.1) +  10.0e-9) * exp(((__SC_i * -10.0) * temp00))) - (((temp0 *  0.1) +  10.0e-9) * exp(((temp0 * -10.0) * temp00)))) / __W_i);
            __SCC_i = (((((__SC_i *  0.05) +  2.5e-9) * exp(((__SC_i * -20.0) * temp00))) - (((temp0 *  0.05) +  2.5e-9) * exp(((temp0 * -20.0) * temp00)))) / __W_i);
          end
          temp0 = __SCA_i;
          __VFB_p = (__VFB_p + (__KVTHOWE * temp0));
          __BETN_p = (__BETN_p * ((__KUOWE * temp0) +  1.0));
          __VFBEDGE_p = (__VFBEDGE_p + (__KVTHOWE * temp0));
          __BETNEDGE_p = (__BETNEDGE_p * ((__KUOWE * temp0) +  1.0));
        end
      end
      __VFB_i = __VFB_p;
      __STVFB_i = __STVFB_p;
      __ST2VFB_i = __ST2VFB_p;
      __TOX_i = (((__TOX_p >  100.0e-12))? (__TOX_p):( 100.0e-12));
      __EPSROX_i = (((__EPSROX_p >  1.0))? (__EPSROX_p):( 1.0));
      __NEFF_i = (((__NEFF_p >  100.0e+18))? ((((__NEFF_p <  100.0e+24))? (__NEFF_p):( 100.0e+24))):( 100.0e+18));
      __FACNEFFAC_i = (((__FACNEFFAC_p >  0.0))? (__FACNEFFAC_p):( 0.0));
      __GFACNUD_i = (((__GFACNUD_p >  0.01))? (__GFACNUD_p):( 0.01));
      __VSBNUD_i = (((__VSBNUD_p >  0.0))? (__VSBNUD_p):( 0.0));
      __DVSBNUD_i = (((__DVSBNUD_p >  0.1))? (__DVSBNUD_p):( 0.1));
      __VNSUB_i = __VNSUB_p;
      __NSLP_i = (((__NSLP_p >  0.001))? (__NSLP_p):( 0.001));
      __DNSUB_i = (((__DNSUB_p >  0.0))? ((((__DNSUB_p <  1.0))? (__DNSUB_p):( 1.0))):( 0.0));
      __DPHIB_i = __DPHIB_p;
      __DELVTAC_i = __DELVTAC_p;
      __NP_i = (((__NP_p >  0.0))? (__NP_p):( 0.0));
      __TOXOV_i = (((__TOXOV_p >  100.0e-12))? (__TOXOV_p):( 100.0e-12));
      __TOXOVD_i = (((__TOXOVD_p >  100.0e-12))? (__TOXOVD_p):( 100.0e-12));
      __NOV_i = (((__NOV_p >  100.0e+21))? ((((__NOV_p <  1.0e+27))? (__NOV_p):( 1.0e+27))):( 100.0e+21));
      __NOVD_i = (((__NOVD_p >  100.0e+21))? ((((__NOVD_p <  1.0e+27))? (__NOVD_p):( 1.0e+27))):( 100.0e+21));
      __CT_i = (((__CT_p >  0.0))? (__CT_p):( 0.0));
      __CTG_i = (((__CTG_p >  0.0))? (__CTG_p):( 0.0));
      __CTB_i = __CTB_p;
      __STCT_i = __STCT_p;
      __CF_i = (((__CF_p >  0.0))? (__CF_p):( 0.0));
      __CFAC_i = (((__CFAC_p >  0.0))? (__CFAC_p):( 0.0));
      __CFD_i = (((__CFD_p >  0.0))? (__CFD_p):( 0.0));
      __CFB_i = (((__CFB_p >  0.0))? ((((__CFB_p <  1.0))? (__CFB_p):( 1.0))):( 0.0));
      __PSCE_i = (((__PSCE_p >  0.0))? (__PSCE_p):( 0.0));
      __PSCEB_i = (((__PSCEB_p >  0.0))? ((((__PSCEB_p <  1.0))? (__PSCEB_p):( 1.0))):( 0.0));
      __PSCED_i = (((__PSCED_p >  0.0))? (__PSCED_p):( 0.0));
      __BETN_i = (((__BETN_p >  0.0))? (__BETN_p):( 0.0));
      __STBET_i = __STBET_p;
      __MUE_i = (((__MUE_p >  0.0))? (__MUE_p):( 0.0));
      __STMUE_i = __STMUE_p;
      __THEMU_i = (((__THEMU_p >  0.0))? (__THEMU_p):( 0.0));
      __STTHEMU_i = __STTHEMU_p;
      __CS_i = (((__CS_p >  0.0))? (__CS_p):( 0.0));
      __STCS_i = __STCS_p;
      __THECS_i = (((__THECS_p >  0.0))? (__THECS_p):( 0.0));
      __STTHECS_i = __STTHECS_p;
      __XCOR_i = (((__XCOR_p >  0.0))? (__XCOR_p):( 0.0));
      __STXCOR_i = __STXCOR_p;
      __FETA_i = (((__FETA_p >  0.0))? (__FETA_p):( 0.0));
      __RS_i = (((__RS_p >  0.0))? (__RS_p):( 0.0));
      __STRS_i = __STRS_p;
      __RSB_i = (((__RSB_p > -0.5))? ((((__RSB_p <  1.0))? (__RSB_p):( 1.0))):(-0.5));
      __RSG_i = (((__RSG_p > -0.5))? (__RSG_p):(-0.5));
      __THESAT_i = (((__THESAT_p >  0.0))? (__THESAT_p):( 0.0));
      __THESATAC_i = (((__THESATAC_p >  0.0))? (__THESATAC_p):( 0.0));
      __STTHESAT_i = __STTHESAT_p;
      __THESATB_i = (((__THESATB_p > -0.5))? ((((__THESATB_p <  1.0))? (__THESATB_p):( 1.0))):(-0.5));
      __THESATG_i = (((__THESATG_p > -0.5))? (__THESATG_p):(-0.5));
      __AX_i = (((__AX_p >  2.0))? (__AX_p):( 2.0));
      __AXAC_i = (((__AXAC_p >  2.0))? (__AXAC_p):( 2.0));
      __ALP_i = (((__ALP_p >  0.0))? (__ALP_p):( 0.0));
      __ALPAC_i = (((__ALPAC_p >  0.0))? (__ALPAC_p):( 0.0));
      __ALP1_i = (((__ALP1_p >  0.0))? (__ALP1_p):( 0.0));
      __ALP2_i = (((__ALP2_p >  0.0))? (__ALP2_p):( 0.0));
      __VP_i = (((__VP_p >  100.0e-12))? (__VP_p):( 100.0e-12));
      __A1_i = (((__A1_p >  0.0))? (__A1_p):( 0.0));
      __A2_i = (((__A2_p >  0.0))? (__A2_p):( 0.0));
      __STA2_i = __STA2_p;
      __A3_i = (((__A3_p >  0.0))? (__A3_p):( 0.0));
      __A4_i = (((__A4_p >  0.0))? (__A4_p):( 0.0));
      __GCO_i = (((__GCO_p > -10.0))? ((((__GCO_p <  10.0))? (__GCO_p):( 10.0))):(-10.0));
      __IGINV_i = (((__IGINV_p >  0.0))? (__IGINV_p):( 0.0));
      __IGOV_i = (((__IGOV_p >  0.0))? (__IGOV_p):( 0.0));
      __IGOVD_i = (((__IGOVD_p >  0.0))? (__IGOVD_p):( 0.0));
      __STIG_i = __STIG_p;
      __GC2_i = (((__GC2_p >  0.0))? ((((__GC2_p <  10.0))? (__GC2_p):( 10.0))):( 0.0));
      __GC3_i = (((__GC3_p > -10.0))? ((((__GC3_p <  10.0))? (__GC3_p):( 10.0))):(-10.0));
      __GC2OV_i = __GC2_i;
      __GC3OV_i = __GC3_i;
      if (0) begin
      end
      __CHIB_i = (((__CHIB_p >  1.0))? (__CHIB_p):( 1.0));
      __AGIDL_i = (((__AGIDL_p >  0.0))? (__AGIDL_p):( 0.0));
      __AGIDLD_i = (((__AGIDLD_p >  0.0))? (__AGIDLD_p):( 0.0));
      __BGIDL_i = (((__BGIDL_p >  0.0))? (__BGIDL_p):( 0.0));
      __BGIDLD_i = (((__BGIDLD_p >  0.0))? (__BGIDLD_p):( 0.0));
      __STBGIDL_i = __STBGIDL_p;
      __STBGIDLD_i = __STBGIDLD_p;
      __CGIDL_i = __CGIDL_p;
      __CGIDLD_i = __CGIDLD_p;
      __COX_i = (((__COX_p >  0.0))? (__COX_p):( 0.0));
      __CGOV_i = (((__CGOV_p >  0.0))? (__CGOV_p):( 0.0));
      __CGOVD_i = (((__CGOVD_p >  0.0))? (__CGOVD_p):( 0.0));
      __FCGOVACC_i = (((__FCGOVACC_p >  0.0))? ((((__FCGOVACC_p <  1.0))? (__FCGOVACC_p):( 1.0))):( 0.0));
      __FCGOVACCD_i = (((__FCGOVACCD_p >  0.0))? ((((__FCGOVACCD_p <  1.0))? (__FCGOVACCD_p):( 1.0))):( 0.0));
      __CGOVACCG_i = (((__CGOVACCG_p >  0.1))? ((((__CGOVACCG_p <  1.0))? (__CGOVACCG_p):( 1.0))):( 0.1));
      __CGBOV_i = (((__CGBOV_p >  0.0))? (__CGBOV_p):( 0.0));
      __CINR_i = (((__CINR_p >  0.0))? (__CINR_p):( 0.0));
      __CINRD_i = (((__CINRD_p >  0.0))? (__CINRD_p):( 0.0));
      __DVFBINR_i = __DVFBINR_p;
      __FCINRDEP_i = (((__FCINRDEP_p >  0.0))? ((((__FCINRDEP_p <  1.0))? (__FCINRDEP_p):( 1.0))):( 0.0));
      __FCINRACC_i = (((__FCINRACC_p >  0.0))? ((((__FCINRACC_p <  1.0))? (__FCINRACC_p):( 1.0))):( 0.0));
      __AXINR_i = (((__AXINR_p >  0.01))? ((((__AXINR_p <  1.0))? (__AXINR_p):( 1.0))):( 0.01));
      __CFR_i = (((__CFR_p >  0.0))? (__CFR_p):( 0.0));
      __CFRD_i = (((__CFRD_p >  0.0))? (__CFRD_p):( 0.0));
      __FNT_i = (((__FNT_p >  0.0))? (__FNT_p):( 0.0));
      __FNTEXC_i = (((__FNTEXC_p >  0.0))? (__FNTEXC_p):( 0.0));
      __NFA_i = (((__NFA_p >  0.0))? (__NFA_p):( 0.0));
      __NFB_i = (((__NFB_p >  0.0))? (__NFB_p):( 0.0));
      __NFC_i = (((__NFC_p >  0.0))? (__NFC_p):( 0.0));
      __EF_i = (((__EF_p >  0.0))? (__EF_p):( 0.0));
      __VFBEDGE_i = __VFBEDGE_p;
      __STVFBEDGE_i = __STVFBEDGE_p;
      __DPHIBEDGE_i = __DPHIBEDGE_p;
      __NEFFEDGE_i = (((__NEFFEDGE_p >  100.0e+18))? ((((__NEFFEDGE_p <  100.0e+24))? (__NEFFEDGE_p):( 100.0e+24))):( 100.0e+18));
      __CTEDGE_i = (((__CTEDGE_p >  0.0))? (__CTEDGE_p):( 0.0));
      __BETNEDGE_i = (((__BETNEDGE_p >  0.0))? (__BETNEDGE_p):( 0.0));
      __STBETEDGE_i = __STBETEDGE_p;
      __PSCEEDGE_i = (((__PSCEEDGE_p >  0.0))? (__PSCEEDGE_p):( 0.0));
      __PSCEBEDGE_i = (((__PSCEBEDGE_p >  0.0))? ((((__PSCEBEDGE_p <  1.0))? (__PSCEBEDGE_p):( 1.0))):( 0.0));
      __PSCEDEDGE_i = (((__PSCEDEDGE_p >  0.0))? (__PSCEDEDGE_p):( 0.0));
      __CFEDGE_i = (((__CFEDGE_p >  0.0))? (__CFEDGE_p):( 0.0));
      __CFDEDGE_i = (((__CFDEDGE_p >  0.0))? (__CFDEDGE_p):( 0.0));
      __CFBEDGE_i = (((__CFBEDGE_p >  0.0))? ((((__CFBEDGE_p <  1.0))? (__CFBEDGE_p):( 1.0))):( 0.0));
      __FNTEDGE_i = (((__FNTEDGE_p >  0.0))? (__FNTEDGE_p):( 0.0));
      __NFAEDGE_i = (((__NFAEDGE_p >  0.0))? (__NFAEDGE_p):( 0.0));
      __NFBEDGE_i = (((__NFBEDGE_p >  0.0))? (__NFBEDGE_p):( 0.0));
      __NFCEDGE_i = (((__NFCEDGE_p >  0.0))? (__NFCEDGE_p):( 0.0));
      __EFEDGE_i = (((__EFEDGE_p >  0.0))? (__EFEDGE_p):( 0.0));
      __RG_i = (((__RG_p >  0.0))? (__RG_p):( 0.0));
      __RSE_i = (((__RSE_p >  0.0))? (__RSE_p):( 0.0));
      __RDE_i = (((__RDE_p >  0.0))? (__RDE_p):( 0.0));
      __RBULK_i = (((__RBULK_p >  0.0))? (__RBULK_p):( 0.0));
      __RJUNS_i = (((__RJUNS_p >  0.0))? (__RJUNS_p):( 0.0));
      __RJUND_i = (((__RJUND_p >  0.0))? (__RJUND_p):( 0.0));
      __RWELL_i = (((__RWELL_p >  0.0))? (__RWELL_p):( 0.0));
      __MULT_i = ((((__MULT * __NF_i) >  0.0))? ((__MULT * __NF_i)):( 0.0));
      __FACTUO_i = __FACTUO;
      __DELVTO_i = __DELVTO;
      __FACTUOEDGE_i =  1.0;
      __DELVTOEDGE_i =  0.0;
      __MUNQS_i = (((__MUNQS_p >  0.0))? (__MUNQS_p):( 0.0));
      if (1) begin
        __TOXOVD_i = __TOXOV_i;
        __NOVD_i = __NOV_i;
        __AGIDLD_i = __AGIDL_i;
        __BGIDLD_i = __BGIDL_i;
        __STBGIDLD_i = __STBGIDL_i;
        __CGIDLD_i = __CGIDL_i;
        __IGOVD_i = __IGOV_i;
        __CGOVD_i = __CGOV_i;
        __FCGOVACCD_i = __FCGOVACC_i;
        __CINRD_i = __CINR_i;
        __CFRD_i = __CFR_i;
      end
      __EPSOX = (__EPSROX_i *  8.8541878176e-12);
      __CoxPrime = (__EPSOX / __TOX_i);
      __tox_sq = (__TOX_i * __TOX_i);
      __Cox_over_q = (__CoxPrime /  160.21918e-21);
      __NEFFAC_i = (__FACNEFFAC_i * __NEFF_i);
      __NEFFAC_i = (((__NEFFAC_i >  100.0e+18))? ((((__NEFFAC_i <  100.0e+24))? (__NEFFAC_i):( 100.0e+24))):( 100.0e+18));
      __qq =  0.0;
      if (1) begin
        __qq = (pow(__CoxPrime,  0.666666666666667) *  2.3807972);
        if ((__CHNL_TYPE == -1)) begin
          __qq = (__qq *  1.25146501348372);
        end
      end
      __E_eff0 = ((__CoxPrime *  10.0e-9) / __EPSSI);
      __eta_mu = (__FETA_i *  0.5);
      __eta_mu1 =  0.5;
      if ((__CHNL_TYPE == -1)) begin
        __eta_mu = (__FETA_i *  0.333333333333333);
        __eta_mu1 =  0.333333333333333;
      end
      __inv_AX = ( 1.0 / __AX_i);
      __inv_VP = ( 1.0 / __VP_i);
      __CoxovPrime = (__EPSOX / __TOXOV_i);
      __CoxovPrime_d = (__EPSOX / __TOXOVD_i);
      __GOV_s = (sqrt((((__NOV_i *  320.43836e-21) * __EPSSI) * __inv_phita)) / __CoxovPrime);
      __GOV_d = (sqrt((((__NOVD_i *  320.43836e-21) * __EPSSI) * __inv_phita)) / __CoxovPrime_d);
      __GOV2_s = (__GOV_s * __GOV_s);
      __GOV2_d = (__GOV_d * __GOV_d);
      __dxgb_ov_th = ((ln((exp(((__CGOVACCG_i *  0.005) * __inv_phita)) -  1.0)) / __CGOVACCG_i) - ln((exp((__inv_phita *  0.005)) -  1.0)));
      __dxgb_ov_s = (ln((__GOV_s *  0.5)) + __dxgb_ov_th);
      __dxgb_ov_d = (ln((__GOV_d *  0.5)) + __dxgb_ov_th);
      __inv_GOV = ( 1.0 / __GOV_s);
      __SP_OV_eps = ((__GOV_s *  3.1) +  8.5);
      __SP_OV_eps2_s = (__SP_OV_eps * __SP_OV_eps);
      __SP_OV_delta = (__SP_OV_eps *  0.5);
      if ((__inv_GOV <  0.06)) begin
        __SP_OV_a_s = (__inv_GOV *  64.0);
      end
      else begin
        if ((__inv_GOV <=  0.45)) begin
          __SP_OV_a_s = ((__inv_GOV *  22.0) +  3.0);
        end
        else begin
          if ((__inv_GOV <=  1.6)) begin
            __SP_OV_a_s = ((__inv_GOV * -7.2) +  15.5);
          end
          else begin
            __SP_OV_a_s = __GOV_s;
          end
        end
      end
      __SP_OV_delta1_s = ((__SP_OV_delta + (__GOV2_s *  0.5)) - (__GOV_s * sqrt(((__SP_OV_delta + (__GOV2_s *  0.25)) + __SP_OV_a_s))));
      __inv_GOV = ( 1.0 / __GOV_d);
      __SP_OV_eps = ((__GOV_d *  3.1) +  8.5);
      __SP_OV_eps2_d = (__SP_OV_eps * __SP_OV_eps);
      __SP_OV_delta = (__SP_OV_eps *  0.5);
      if ((__inv_GOV <  0.06)) begin
        __SP_OV_a_d = (__inv_GOV *  64.0);
      end
      else begin
        if ((__inv_GOV <=  0.45)) begin
          __SP_OV_a_d = ((__inv_GOV *  22.0) +  3.0);
        end
        else begin
          if ((__inv_GOV <=  1.6)) begin
            __SP_OV_a_d = ((__inv_GOV * -7.2) +  15.5);
          end
          else begin
            __SP_OV_a_d = __GOV_d;
          end
        end
      end
      __SP_OV_delta1_d = ((__SP_OV_delta + (__GOV2_d *  0.5)) - (__GOV_d * sqrt(((__SP_OV_delta + (__GOV2_d *  0.25)) + __SP_OV_a_d))));
      __phib_dc = ((__Eg + __DPHIB_i) + ((__phit *  2.0) * ln(((__NEFF_i * pow(__phibFac, -0.75)) *  40.0e-27))));
      __phib_dc = (((__phib_dc >  0.05))? (__phib_dc):( 0.05));
      __G_0_dc = (sqrt((((__NEFF_i *  320.43836e-21) * __EPSSI) * __inv_phit)) / __CoxPrime);
      __kp =  0.0;
      __np =  0.0;
      if ((__NP_i >  0.0)) begin
        __arg2max = ( 80.0e+6 / __tox_sq);
        __np = (((__NP_i > __arg2max))? (__NP_i):(__arg2max));
        __np = ((( 5.0e+24 > __np))? ( 5.0e+24):(__np));
        __kp = ((((__CoxPrime *  2.0) * __CoxPrime) * __phit) / ((__np *  160.21918e-21) * __EPSSI));
      end
      __qlim2 = ((__phit *  100.0) * __phit);
      if (1) begin
        __qb0 = sqrt((((__phit * __G_0_dc) * __G_0_dc) * __phib_dc));
        __dphibq = ((__qq *  0.75) * pow(__qb0,  0.666666666666667));
        __phib_dc = (__phib_dc + __dphibq);
        __G_0_dc = (__G_0_dc * (((__dphibq *  1.33333333333333) / __qb0) +  1.0));
      end
      __sqrt_phib_dc = sqrt(__phib_dc);
      __phix_dc = (__phib_dc *  0.95);
      __aphi_dc = ((__phib_dc *  0.0025) * __phib_dc);
      __bphi_dc = __aphi_dc;
      __phix2 = (sqrt(__bphi_dc) *  0.5);
      __phix1_dc = (((__phix_dc - __phix2) - sqrt((((__phix_dc - __phix2) * (__phix_dc - __phix2)) + __aphi_dc))) *  0.5);
      __alpha_b = ((__phib_dc + __Eg) *  0.5);
      __us1 = (sqrt((__VSBNUD_i + __phib_dc)) - __sqrt_phib_dc);
      __us21 = ((sqrt(((__VSBNUD_i + __DVSBNUD_i) + __phib_dc)) - __sqrt_phib_dc) - __us1);
      __phib_ac = (((__Eg + __DPHIB_i) + __DELVTAC_i) + ((__phit *  2.0) * ln(((__NEFFAC_i * pow(__phibFac, -0.75)) *  40.0e-27))));
      __phib_ac = (((__phib_ac >  0.05))? (__phib_ac):( 0.05));
      __G_0_ac = (sqrt((((__NEFFAC_i *  320.43836e-21) * __EPSSI) * __inv_phit)) / __CoxPrime);
      if (1) begin
        __qb0 = sqrt((((__phit * __G_0_ac) * __G_0_ac) * __phib_ac));
        __dphibq = ((__qq *  0.75) * pow(__qb0,  0.666666666666667));
        __phib_ac = (__phib_ac + __dphibq);
        __G_0_ac = (__G_0_ac * (((__dphibq *  1.33333333333333) / __qb0) +  1.0));
      end
      __phix_ac = (__phib_ac *  0.95);
      __aphi_ac = ((__phib_ac *  0.0025) * __phib_ac);
      __bphi_ac = __aphi_ac;
      __phix2 = (sqrt(__bphi_ac) *  0.5);
      __phix1_ac = (((__phix_ac - __phix2) - sqrt((((__phix_ac - __phix2) * (__phix_ac - __phix2)) + __aphi_ac))) *  0.5);
      __VFB_T = ((__VFB_i + ((__STVFB_i * __delT) * ((__ST2VFB_i * __delT) +  1.0))) + __DELVTO_i);
      __tf_ct = exp((__STCT_i * __ln_rTn));
      __CT_T = (__CT_i * __tf_ct);
      __CTG_T = (__CTG_i / __rTn);
      __tf_bet = exp((__STBET_i * __ln_rTn));
      __BETN_T = (__BETN_i * __tf_bet);
      __BET_i = ((__FACTUO_i * __BETN_T) * __CoxPrime);
      __THEMU_T = (__THEMU_i * exp((__STTHEMU_i * __ln_rTn)));
      __tf_mue = exp((__STMUE_i * __ln_rTn));
      __MUE_T = (__MUE_i * __tf_mue);
      __THECS_T = (__THECS_i * exp((__STTHECS_i * __ln_rTn)));
      __tf_cs = exp((__STCS_i * __ln_rTn));
      __CS_T = (__CS_i * __tf_cs);
      __tf_xcor = exp((__STXCOR_i * __ln_rTn));
      __XCOR_T = (__XCOR_i * __tf_xcor);
      __tf_ther = exp((__STRS_i * __ln_rTn));
      __RS_T = (__RS_i * __tf_ther);
      __THER_i = ((__BET_i *  2.0) * __RS_T);
      __tf_thesat = exp((__STTHESAT_i * __ln_rTn));
      __THESAT_T = (__THESAT_i * __tf_thesat);
      __THESATAC_T = (__THESATAC_i * __tf_thesat);
      __A2_T = (__A2_i * exp(((- __STA2_i) * __ln_rTn)));
      __nt = ((__FNT_i *  55.22602e-24) * __TKD);
      __Sfl_prefac = (((__phit * __phit) * __BET_i) / __Cox_over_q);
      if (0) begin
      end
      else begin
        __VFBEDGE_T =  0.0;
        __tf_betedge =  1.0;
        __BETNEDGE_T =  0.0;
        __BETEDGE_i =  0.0;
        __phit0edge = __phit;
        __phibedge =  0.0;
        __Gfedge =  1.0;
        __Gfedge2 =  1.0;
        __lnGfedge2 =  0.0;
        __phixedge =  0.0;
        __aphiedge =  0.0;
        __bphiedge =  0.0;
        __phix2edge =  0.0;
        __phix1edge =  0.0;
        __Sfl_prefac_edge =  0.0;
        __ntedge =  1.0;
      end
      __inv_CHIB = ( 1.0 / __CHIB_i);
      __B_fact = (sqrt((__CHIB_i *  291.89956209565e-51)) *  12.643363733543e+33);
      __BCH = (__B_fact * __TOX_i);
      __BOV = (__B_fact * __TOXOV_i);
      __BOV_d = (__B_fact * __TOXOVD_i);
      __GCQ =  0.0;
      if ((__GC3_i <  0.0)) begin
        __GCQ = ((__GC2_i * -0.495) / __GC3_i);
      end
      __GCQOV = __GCQ;
      if (0) begin
        if ((__GC3OV_i <  0.0)) begin
        end
      end
      __tf_ig = pow(__rTa, __STIG_i);
      __IGINV_i = (__IGINV_i * __tf_ig);
      __IGOV_i = (__IGOV_i * __tf_ig);
      __IGOVD_i = (__IGOVD_i * __tf_ig);
      __AGIDLs = ((__AGIDL_i *  4.0e-18) / (__TOXOV_i * __TOXOV_i));
      __AGIDLDs = ((__AGIDLD_i *  4.0e-18) / (__TOXOVD_i * __TOXOVD_i));
      __B_fact = (((((__STBGIDL_i * __delTa) +  1.0) >  0.0))? (((__STBGIDL_i * __delTa) +  1.0)):( 0.0));
      __BGIDL_T = (__BGIDL_i * __B_fact);
      __BGIDLs = ((__BGIDL_T * __TOXOV_i) *  500.0e+6);
      __B_fact = (((((__STBGIDLD_i * __delTa) +  1.0) >  0.0))? (((__STBGIDLD_i * __delTa) +  1.0)):( 0.0));
      __BGIDLD_T = (__BGIDLD_i * __B_fact);
      __BGIDLDs = ((__BGIDLD_T * __TOXOVD_i) *  500.0e+6);
      __Vinr_max =  0.0;
      if ((__FCINRACC_i >  100.0e-12)) begin
        __Vinr_max = ( 0.75 / __FCINRACC_i);
      end
      __ainr = (__AXINR_i * __AXINR_i);
      __fac_exc = (__FNTEXC_i *  910.93826e-24);
      if ((__RG_i >  0.0)) begin
        __ggate = ( 1.0 / __RG_i);
      end
      else begin
        __ggate =  0.0;
      end
      if ((__RSE_i >  0.0)) begin
        __gsource = ( 1.0 / __RSE_i);
      end
      else begin
        __gsource =  0.0;
      end
      if ((__RDE_i >  0.0)) begin
        __gdrain = ( 1.0 / __RDE_i);
      end
      else begin
        __gdrain =  0.0;
      end
      if ((__RBULK_i >  0.0)) begin
        __gbulk = ( 1.0 / __RBULK_i);
      end
      else begin
        __gbulk =  0.0;
      end
      if ((__RJUNS_i >  0.0)) begin
        __gjuns = ( 1.0 / __RJUNS_i);
      end
      else begin
        __gjuns =  0.0;
      end
      if ((__RJUND_i >  0.0)) begin
        __gjund = ( 1.0 / __RJUND_i);
      end
      else begin
        __gjund =  0.0;
      end
      if ((__RWELL_i >  0.0)) begin
        __gwell = ( 1.0 / __RWELL_i);
      end
      else begin
        __gwell =  0.0;
      end
      __ABS_i =  0.0;
      __LSS_i =  0.0;
      __LGS_i =  0.0;
      __ABD_i =  0.0;
      __LSD_i =  0.0;
      __LGD_i =  0.0;
      __jwcorr =  0.0;
      __jww = __WE;
      if (0) begin
      end
      if (1) begin
        __jwcorr =  1.0;
      end
      __ABS_i = (__ABSOURCE_i * __invNF);
      __LSS_i = (__LSSOURCE_i * __invNF);
      __LGS_i = (__LGSOURCE_i * __invNF);
      __ABD_i = (__ABDRAIN_i * __invNF);
      __LSD_i = (__LSDRAIN_i * __invNF);
      __LGD_i = (__LGDRAIN_i * __invNF);
      if (1) begin
        __ABS_i = (__AS_i * __invNF);
        __LSS_i = ((__PS_i * __invNF) - (__jwcorr * __jww));
        __LGS_i = __jww;
        __ABD_i = (__AD_i * __invNF);
        __LSD_i = ((__PD_i * __invNF) - (__jwcorr * __jww));
        __LGD_i = __jww;
      end
      if (1) begin
        __ABSOURCE_i = (((__ABS_i >  0.0))? (__ABS_i):( 0.0));
        __LSSOURCE_i = (((__LSS_i >  0.0))? (__LSS_i):( 0.0));
        __LGSOURCE_i = (((__LGS_i >  0.0))? (__LGS_i):( 0.0));
        __ABDRAIN_i = (((__ABD_i >  0.0))? (__ABD_i):( 0.0));
        __LSDRAIN_i = (((__LSD_i >  0.0))? (__LSD_i):( 0.0));
        __LGDRAIN_i = (((__LGD_i >  0.0))? (__LGD_i):( 0.0));
      end
      else begin
      end
      __vbimin_s =  0.0;
      __vbimin_d =  0.0;
      __vfmin_s =  0.0;
      __vfmin_d =  0.0;
      __vch_s =  0.0;
      __vch_d =  0.0;
      __vbbtlim_s =  0.0;
      __vbbtlim_d =  0.0;
      __VMAX_s =  0.0;
      __VMAX_d =  0.0;
      __exp_VMAX_over_phitd_s =  0.0;
      __exp_VMAX_over_phitd_d =  0.0;
      __ISATFOR1_s =  0.0;
      __ISATFOR1_d =  0.0;
      __MFOR1_s =  1.0;
      __MFOR1_d =  1.0;
      __ISATFOR2_s =  0.0;
      __ISATFOR2_d =  0.0;
      __MFOR2_s =  1.0;
      __MFOR2_d =  1.0;
      __ISATREV_s =  0.0;
      __ISATREV_d =  0.0;
      __MREV_s =  1.0;
      __MREV_d =  1.0;
      __m0flag_s =  0.0;
      __m0flag_d =  0.0;
      __xhighf1_s =  0.0;
      __xhighf1_d =  0.0;
      __expxhf1_s =  0.0;
      __expxhf1_d =  0.0;
      __xhighf2_s =  0.0;
      __xhighf2_d =  0.0;
      __expxhf2_s =  0.0;
      __expxhf2_d =  0.0;
      __xhighr_s =  0.0;
      __xhighr_d =  0.0;
      __expxhr_s =  0.0;
      __expxhr_d =  0.0;
      __zflagbot_s =  1.0;
      __zflagbot_d =  1.0;
      __zflagsti_s =  1.0;
      __zflagsti_d =  1.0;
      __zflaggat_s =  1.0;
      __zflaggat_d =  1.0;
      __m0_rev =  0.0;
      __mcor_rev =  0.0;
      __I1_cor =  0.0;
      __I2_cor =  0.0;
      __I3_cor =  0.0;
      __I4_cor =  0.0;
      __I5_cor =  0.0;
      __tt0 =  0.0;
      __tt1 =  0.0;
      __tt2 =  0.0;
      __zfrac =  0.0;
      __alphaje =  0.0;
      if (1) begin
        if (((__idsatbot * __ABSOURCE_i) >  0.0)) begin
          __vmaxbot = (__phitd * ln((( 0.0015358 / (__idsatbot * __ABSOURCE_i)) +  1.0)));
        end
        else begin
          __vmaxbot =  100.0e+6;
        end
        if (((__idsatsti * __LSSOURCE_i) >  0.0)) begin
          __vmaxsti = (__phitd * ln((( 0.0015358 / (__idsatsti * __LSSOURCE_i)) +  1.0)));
        end
        else begin
          __vmaxsti =  100.0e+6;
        end
        if (((__idsatgat * __LGSOURCE_i) >  0.0)) begin
          __vmaxgat = (__phitd * ln((( 0.0015358 / (__idsatgat * __LGSOURCE_i)) +  1.0)));
        end
        else begin
          __vmaxgat =  100.0e+6;
        end
        __VMAX_s = min(min(__vmaxbot, __vmaxsti), __vmaxgat);
        if ((abs((__VMAX_s * __phitdinv)) <  230.258509299405)) begin
          __exp_VMAX_over_phitd_s = exp((__VMAX_s * __phitdinv));
        end
        else begin
          if (((__VMAX_s * __phitdinv) <  0.0)) begin
            __exp_VMAX_over_phitd_s = ( 100.0e-102 / (((-230.258509299405 - (__VMAX_s * __phitdinv)) * ((((-230.258509299405 - (__VMAX_s * __phitdinv)) * (((-230.258509299405 - (__VMAX_s * __phitdinv)) *  0.333333333333333) +  1.0)) *  0.5) +  1.0)) +  1.0));
          end
          else begin
            __exp_VMAX_over_phitd_s = (((((__VMAX_s * __phitdinv) -  230.258509299405) * (((((__VMAX_s * __phitdinv) -  230.258509299405) * ((((__VMAX_s * __phitdinv) -  230.258509299405) *  0.333333333333333) +  1.0)) *  0.5) +  1.0)) +  1.0) *  10.0e+99);
          end
        end
        __vbibot2 = __vbibot;
        __vbisti2 = __vbisti;
        __vbigat2 = __vbigat;
        __pbot2 =  0.31309;
        __psti2 =  0.27362;
        __pgat2 =  0.5424;
        __vbibot2r =  0.70829;
        __vbisti2r =  0.79368;
        __vbigat2r =  2.0;
        if ((__ABSOURCE_i ==  0.0)) begin
          __vbibot2 = (__vbisti + __vbigat);
          __pbot2 =  0.246258;
          __vbibot2r =  2.79368;
        end
        if ((__LSSOURCE_i ==  0.0)) begin
          __vbisti2 = (__vbibot + __vbigat);
          __psti2 =  0.281781;
          __vbisti2r =  2.70829;
        end
        if ((__LGSOURCE_i ==  0.0)) begin
          __vbigat2 = (__vbibot + __vbisti);
          __pgat2 =  0.246258;
          __vbigat2r =  1.50197;
        end
        __vbimin_s = min(min(__vbibot2, __vbisti2), __vbigat2);
        __vch_s = (__vbimin_s *  0.1);
        __pmax = max(max(__pbot2, __psti2), __pgat2);
        __vfmin_s = (__vbimin_s * ( 1.0 - pow( 2.0, (-1.0 / __pmax))));
        __vbbtlim_s = (min(min(__vbibot2r, __vbisti2r), __vbigat2r) -  0.05);
        if (((__idsatbot_d * __ABDRAIN_i) >  0.0)) begin
          __vmaxbot = (__phitd * ln((( 0.0015358 / (__idsatbot_d * __ABDRAIN_i)) +  1.0)));
        end
        else begin
          __vmaxbot =  100.0e+6;
        end
        if (((__idsatsti_d * __LSDRAIN_i) >  0.0)) begin
          __vmaxsti = (__phitd * ln((( 0.0015358 / (__idsatsti_d * __LSDRAIN_i)) +  1.0)));
        end
        else begin
          __vmaxsti =  100.0e+6;
        end
        if (((__idsatgat_d * __LGDRAIN_i) >  0.0)) begin
          __vmaxgat = (__phitd * ln((( 0.0015358 / (__idsatgat_d * __LGDRAIN_i)) +  1.0)));
        end
        else begin
          __vmaxgat =  100.0e+6;
        end
        __VMAX_d = min(min(__vmaxbot, __vmaxsti), __vmaxgat);
        if ((abs((__VMAX_d * __phitdinv)) <  230.258509299405)) begin
          __exp_VMAX_over_phitd_d = exp((__VMAX_d * __phitdinv));
        end
        else begin
          if (((__VMAX_d * __phitdinv) <  0.0)) begin
            __exp_VMAX_over_phitd_d = ( 100.0e-102 / (((-230.258509299405 - (__VMAX_d * __phitdinv)) * ((((-230.258509299405 - (__VMAX_d * __phitdinv)) * (((-230.258509299405 - (__VMAX_d * __phitdinv)) *  0.333333333333333) +  1.0)) *  0.5) +  1.0)) +  1.0));
          end
          else begin
            __exp_VMAX_over_phitd_d = (((((__VMAX_d * __phitdinv) -  230.258509299405) * (((((__VMAX_d * __phitdinv) -  230.258509299405) * ((((__VMAX_d * __phitdinv) -  230.258509299405) *  0.333333333333333) +  1.0)) *  0.5) +  1.0)) +  1.0) *  10.0e+99);
          end
        end
        __vbibot2 = __vbibot_d;
        __vbisti2 = __vbisti_d;
        __vbigat2 = __vbigat_d;
        __pbot2 = __PBOTD_i;
        __psti2 = __PSTID_i;
        __pgat2 = __PGATD_i;
        __vbibot2r = __VBIRBOTD_i;
        __vbisti2r = __VBIRSTID_i;
        __vbigat2r = __VBIRGATD_i;
        if ((__ABDRAIN_i ==  0.0)) begin
          __vbibot2 = (__vbisti_d + __vbigat_d);
          __pbot2 = (min(__PSTID_i, __PGATD_i) *  0.9);
          __vbibot2r = (__VBIRSTID_i + __VBIRGATD_i);
        end
        if ((__LSDRAIN_i ==  0.0)) begin
          __vbisti2 = (__vbibot_d + __vbigat_d);
          __psti2 = (min(__PBOTD_i, __PGATD_i) *  0.9);
          __vbisti2r = (__VBIRBOTD_i + __VBIRGATD_i);
        end
        if ((__LGDRAIN_i ==  0.0)) begin
          __vbigat2 = (__vbibot_d + __vbisti_d);
          __pgat2 = (min(__PBOTD_i, __PSTID_i) *  0.9);
          __vbigat2r = (__VBIRBOTD_i + __VBIRSTID_i);
        end
        __vbimin_d = min(min(__vbibot2, __vbisti2), __vbigat2);
        __vch_d = (__vbimin_d *  0.1);
        __pmax = max(max(__pbot2, __psti2), __pgat2);
        __vfmin_d = (__vbimin_d * ( 1.0 - pow( 2.0, (-1.0 / __pmax))));
        __vbbtlim_d = (min(min(__vbibot2r, __vbisti2r), __vbigat2r) -  0.05);
        if ((__SWJUNEXP_i == 1)) begin : JUNCAPexpressInit
          real ysq, terfc, erfcpos;
          real h1, h2, h2d, h3, h4, h5;
          real idmult, vj, z, zinv, two_psistar, vjlim, vjsrh, vbbt, vav;
          real tmp, id;
          real isrh, vbi_minus_vjsrh, wsrhstep, dwsrh, wsrh, wdep, asrh;
          real itat, btat, twoatatoverthreebtat, umaxbeforelimiting, umax, sqrtumax, umaxpoweronepointfive;
          real wgamma, wtat, ktat, ltat, mtat, xerfc, erfctimesexpmtat, gammamax;
          real ibbt, Fmaxr;
          real fbreakdown;
          real ijunbot, ijunsti, ijungat, qjunbot, qjunsti, qjungat;
          ysq =  0.0;
          terfc =  0.0;
          erfcpos =  0.0;
          h1 =  0.0;
          h2 =  0.0;
          h2d =  0.0;
          h3 =  0.0;
          h4 =  0.0;
          h5 =  0.0;
          idmult =  0.0;
          vj =  0.0;
          z =  0.0;
          zinv =  0.0;
          two_psistar =  0.0;
          vjlim =  0.0;
          vjsrh =  0.0;
          vbbt =  0.0;
          vav =  0.0;
          tmp =  0.0;
          id =  0.0;
          isrh =  0.0;
          vbi_minus_vjsrh =  0.0;
          wsrhstep =  0.0;
          dwsrh =  0.0;
          wsrh =  0.0;
          wdep =  0.0;
          asrh =  0.0;
          itat =  0.0;
          btat =  0.0;
          twoatatoverthreebtat =  0.0;
          umaxbeforelimiting =  0.0;
          umax =  0.0;
          sqrtumax =  0.0;
          umaxpoweronepointfive =  0.0;
          wgamma =  0.0;
          wtat =  0.0;
          ktat =  0.0;
          ltat =  0.0;
          mtat =  0.0;
          xerfc =  0.0;
          erfctimesexpmtat =  0.0;
          gammamax =  0.0;
          ibbt =  0.0;
          Fmaxr =  0.0;
          fbreakdown =  0.0;
          __FRACNA =  0.4;
          __FRACNB =  0.65;
          __FRACI =  0.8;
          __V1 = ((- __FRACNA) *  2.5);
          __V2 = ((- __FRACNB) *  2.5);
          __V3 = ((- __FRACI) *  2.5);
          __V4 =  0.1;
          __V5 =  0.2;
          vbbt =  0.0;
          two_psistar =  0.0;
          if ((! (((__ABSOURCE_i ==  0.0) && (__LSSOURCE_i ==  0.0)) && (__LGSOURCE_i ==  0.0)))) begin
            h1 = ((__vch_s *  4.0) * __vch_s);
            h2 = (__vch_s / __vfmin_s);
            h2d = (__V1 + (__vch_s * h2));
            h3 = (__vfmin_s + h2d);
            h4 = (__vfmin_s - h2d);
            h5 = sqrt(((h4 * h4) + h1));
            vj = (((__V1 * __vfmin_s) / (h3 + h5)) *  2.0);
            if ((__V1 < __VMAX_s)) begin
              if ((abs(((__V1 * __phitdinv) *  0.5)) <  230.258509299405)) begin
                zinv = exp(((__V1 * __phitdinv) *  0.5));
              end
              else begin
                if ((((__V1 * __phitdinv) *  0.5) <  0.0)) begin
                  zinv = ( 100.0e-102 / (((-230.258509299405 - ((__V1 * __phitdinv) *  0.5)) * ((((-230.258509299405 - ((__V1 * __phitdinv) *  0.5)) * (((-230.258509299405 - ((__V1 * __phitdinv) *  0.5)) *  0.333333333333333) +  1.0)) *  0.5) +  1.0)) +  1.0));
                end
                else begin
                  zinv = ((((((__V1 * __phitdinv) *  0.5) -  230.258509299405) * ((((((__V1 * __phitdinv) *  0.5) -  230.258509299405) * (((((__V1 * __phitdinv) *  0.5) -  230.258509299405) *  0.333333333333333) +  1.0)) *  0.5) +  1.0)) +  1.0) *  10.0e+99);
                end
              end
              idmult = (zinv * zinv);
            end
            else begin
              idmult = ((((__V1 - __VMAX_s) * __phitdinv) +  1.0) * __exp_VMAX_over_phitd_s);
              zinv = sqrt(idmult);
            end
            idmult = (idmult -  1.0);
            z = ( 1.0 / zinv);
            if ((__V1 >  0.0)) begin
              two_psistar = ((__phitd * ln(((z +  2.0) + sqrt(((z +  1.0) * (z +  3.0)))))) *  2.0);
            end
            else begin
              two_psistar = ((- __V1) + ((__phitd * ln((((zinv *  2.0) +  1.0) + sqrt(((zinv +  1.0) * ((zinv *  3.0) +  1.0)))))) *  2.0));
            end
            vjlim = (__vbimin_s - two_psistar);
            vjsrh = (((__V1 + vjlim) - sqrt((((__V1 - vjlim) * (__V1 - vjlim)) + ((__phitd *  4.0) * __phitd)))) *  0.5);
            vbbt = (((__V1 + __vbbtlim_s) - sqrt((((__V1 - __vbbtlim_s) * (__V1 - __vbbtlim_s)) + ((__phitr *  4.0) * __phitr)))) *  0.5);
            vav = ((__V1 - sqrt(((__V1 * __V1) +  4.0e-12))) *  0.5);
          end
          if ((__ABSOURCE_i ==  0.0)) begin
            ijunbot =  0.0;
            qjunbot =  0.0;
          end
          else begin
            if ((__one_minus_PBOT ==  0.5)) begin
              tmp = sqrt(( 1.0 - (vj * __vbiinvbot)));
            end
            else begin
              tmp = pow(( 1.0 - (vj * __vbiinvbot)), __one_minus_PBOT);
            end
            qjunbot = ((__qprefbot * ( 1.0 - tmp)) + (__qpref2bot * (__V1 - vj)));
            id = (__idsatbot * idmult);
            if (0) begin
            end
            else begin
              vbi_minus_vjsrh = (__vbibot - vjsrh);
              wsrhstep = ( 1.0 - sqrt(( 1.0 - (two_psistar / vbi_minus_vjsrh))));
              if (0) begin
              end
              else begin
                dwsrh = (((((wsrhstep * wsrhstep) * ln(wsrhstep)) / ( 1.0 - wsrhstep)) + wsrhstep) *  0.37382);
              end
              wsrh = (wsrhstep + dwsrh);
              if (0) begin
              end
              else begin
                tmp = pow((vbi_minus_vjsrh * __VBIRBOTinv),  0.31309);
              end
              wdep = (__wdepnulrbot * tmp);
              asrh = (__ftdbot * ((zinv -  1.0) * wdep));
              isrh = ((asrh * wsrh) *  100.0);
            end
            if (0) begin
            end
            else begin
              btat = (__btatpartbot * ((wdep * __one_minus_PBOT) / vbi_minus_vjsrh));
              twoatatoverthreebtat = ((__atatbot *  0.666666666666667) / btat);
              umaxbeforelimiting = (twoatatoverthreebtat * twoatatoverthreebtat);
              umax = sqrt(((umaxbeforelimiting * umaxbeforelimiting) / ((umaxbeforelimiting * umaxbeforelimiting) +  1.0)));
              sqrtumax = sqrt(umax);
              umaxpoweronepointfive = (umax * sqrtumax);
              if (((__one_over_one_minus_PBOT * -0.31309) == -1.0)) begin
                wgamma = ( 1.0 / ((btat * umaxpoweronepointfive) +  1.0));
              end
              else begin
                wgamma = pow(((btat * umaxpoweronepointfive) +  1.0), (__one_over_one_minus_PBOT * -0.31309));
              end
              wtat = ((wsrh * wgamma) / (wsrh + wgamma));
              ktat = sqrt(((btat / sqrtumax) *  0.375));
              ltat = (((twoatatoverthreebtat * sqrtumax) *  2.0) - umax);
              mtat = ((((__atatbot * twoatatoverthreebtat) * sqrtumax) - (__atatbot * umax)) + ((btat * umaxpoweronepointfive) *  0.5));
              xerfc = ((ltat -  1.0) * ktat);
              ysq = (xerfc * xerfc);
              if ((xerfc >  0.0)) begin
                terfc = ( 1.0 / ((__perfc * xerfc) +  1.0));
              end
              else begin
                terfc = ( 1.0 / ( 1.0 - (__perfc * xerfc)));
              end
              if ((((- ysq) + mtat) > -230.258509299405)) begin
                tmp = exp(((- ysq) + mtat));
              end
              else begin
                tmp = ( 100.0e-102 / (((-230.258509299405 - ((- ysq) + mtat)) * ((((-230.258509299405 - ((- ysq) + mtat)) * (((-230.258509299405 - ((- ysq) + mtat)) *  0.333333333333333) +  1.0)) *  0.5) +  1.0)) +  1.0));
              end
              erfcpos = ((((terfc *  0.29214664) + (__berfc * (terfc * terfc))) + (__cerfc * ((terfc * terfc) * terfc))) * tmp);
              if ((xerfc >  0.0)) begin
                erfctimesexpmtat = erfcpos;
              end
              else begin
                if ((mtat > -230.258509299405)) begin
                  tmp = exp(mtat);
                end
                else begin
                  tmp = ( 100.0e-102 / (((-230.258509299405 - mtat) * ((((-230.258509299405 - mtat) * (((-230.258509299405 - mtat) *  0.333333333333333) +  1.0)) *  0.5) +  1.0)) +  1.0));
                end
                erfctimesexpmtat = ((tmp *  2.0) - erfcpos);
              end
              gammamax = (((__atatbot * erfctimesexpmtat) / ktat) *  0.886226925452758);
              itat = (((asrh * gammamax) * wtat) *  100.0);
            end
            if (0) begin
            end
            else begin
              if (0) begin
              end
              else begin
                tmp = pow((( 0.70829 - vbbt) * __VBIRBOTinv),  0.31309);
              end
              Fmaxr = (__one_over_one_minus_PBOT * ((( 0.70829 - vbbt) * __wdepnulrinvbot) / tmp));
              if ((abs(((- __fbbtbot) / Fmaxr)) <  230.258509299405)) begin
                tmp = exp(((- __fbbtbot) / Fmaxr));
              end
              else begin
                if ((((- __fbbtbot) / Fmaxr) <  0.0)) begin
                  tmp = ( 100.0e-102 / (((-230.258509299405 - ((- __fbbtbot) / Fmaxr)) * ((((-230.258509299405 - ((- __fbbtbot) / Fmaxr)) * (((-230.258509299405 - ((- __fbbtbot) / Fmaxr)) *  0.333333333333333) +  1.0)) *  0.5) +  1.0)) +  1.0));
                end
                else begin
                  tmp = ((((((- __fbbtbot) / Fmaxr) -  230.258509299405) * ((((((- __fbbtbot) / Fmaxr) -  230.258509299405) * (((((- __fbbtbot) / Fmaxr) -  230.258509299405) *  0.333333333333333) +  1.0)) *  0.5) +  1.0)) +  1.0) *  10.0e+99);
                end
              end
              ibbt = ((((__V1 * Fmaxr) * Fmaxr) * tmp) *  1.0e-12);
            end
            if (0) begin
            end
            else begin
              if ((vav > ((- __alphaav) *  10.0))) begin
                if (1) begin
                  tmp = ((((vav * __VBRinvbot) * (vav * __VBRinvbot)) * (vav * __VBRinvbot)) * (vav * __VBRinvbot));
                end
                else begin
                end
                fbreakdown = ( 1.0 / ( 1.0 - tmp));
              end
              else begin
                fbreakdown = (__fstopbot + ((vav + (__alphaav *  10.0)) * __slopebot));
              end
            end
            ijunbot = ((((id + isrh) + itat) + ibbt) * fbreakdown);
          end
          if ((__LSSOURCE_i ==  0.0)) begin
            ijunsti =  0.0;
            qjunsti =  0.0;
          end
          else begin
            if ((__one_minus_PSTI ==  0.5)) begin
              tmp = sqrt(( 1.0 - (vj * __vbiinvsti)));
            end
            else begin
              tmp = pow(( 1.0 - (vj * __vbiinvsti)), __one_minus_PSTI);
            end
            qjunsti = ((__qprefsti * ( 1.0 - tmp)) + (__qpref2sti * (__V1 - vj)));
            id = (__idsatsti * idmult);
            if (0) begin
            end
            else begin
              vbi_minus_vjsrh = (__vbisti - vjsrh);
              wsrhstep = ( 1.0 - sqrt(( 1.0 - (two_psistar / vbi_minus_vjsrh))));
              if (0) begin
              end
              else begin
                dwsrh = (((((wsrhstep * wsrhstep) * ln(wsrhstep)) / ( 1.0 - wsrhstep)) + wsrhstep) *  0.45276);
              end
              wsrh = (wsrhstep + dwsrh);
              if (0) begin
              end
              else begin
                tmp = pow((vbi_minus_vjsrh * __VBIRSTIinv),  0.27362);
              end
              wdep = (__wdepnulrsti * tmp);
              asrh = (__ftdsti * ((zinv -  1.0) * wdep));
              isrh = ((asrh * wsrh) *  100.0e-6);
            end
            if (0) begin
            end
            else begin
              btat = (__btatpartsti * ((wdep * __one_minus_PSTI) / vbi_minus_vjsrh));
              twoatatoverthreebtat = ((__atatsti *  0.666666666666667) / btat);
              umaxbeforelimiting = (twoatatoverthreebtat * twoatatoverthreebtat);
              umax = sqrt(((umaxbeforelimiting * umaxbeforelimiting) / ((umaxbeforelimiting * umaxbeforelimiting) +  1.0)));
              sqrtumax = sqrt(umax);
              umaxpoweronepointfive = (umax * sqrtumax);
              if (((__one_over_one_minus_PSTI * -0.27362) == -1.0)) begin
                wgamma = ( 1.0 / ((btat * umaxpoweronepointfive) +  1.0));
              end
              else begin
                wgamma = pow(((btat * umaxpoweronepointfive) +  1.0), (__one_over_one_minus_PSTI * -0.27362));
              end
              wtat = ((wsrh * wgamma) / (wsrh + wgamma));
              ktat = sqrt(((btat / sqrtumax) *  0.375));
              ltat = (((twoatatoverthreebtat * sqrtumax) *  2.0) - umax);
              mtat = ((((__atatsti * twoatatoverthreebtat) * sqrtumax) - (__atatsti * umax)) + ((btat * umaxpoweronepointfive) *  0.5));
              xerfc = ((ltat -  1.0) * ktat);
              ysq = (xerfc * xerfc);
              if ((xerfc >  0.0)) begin
                terfc = ( 1.0 / ((__perfc * xerfc) +  1.0));
              end
              else begin
                terfc = ( 1.0 / ( 1.0 - (__perfc * xerfc)));
              end
              if ((((- ysq) + mtat) > -230.258509299405)) begin
                tmp = exp(((- ysq) + mtat));
              end
              else begin
                tmp = ( 100.0e-102 / (((-230.258509299405 - ((- ysq) + mtat)) * ((((-230.258509299405 - ((- ysq) + mtat)) * (((-230.258509299405 - ((- ysq) + mtat)) *  0.333333333333333) +  1.0)) *  0.5) +  1.0)) +  1.0));
              end
              erfcpos = ((((terfc *  0.29214664) + (__berfc * (terfc * terfc))) + (__cerfc * ((terfc * terfc) * terfc))) * tmp);
              if ((xerfc >  0.0)) begin
                erfctimesexpmtat = erfcpos;
              end
              else begin
                if ((mtat > -230.258509299405)) begin
                  tmp = exp(mtat);
                end
                else begin
                  tmp = ( 100.0e-102 / (((-230.258509299405 - mtat) * ((((-230.258509299405 - mtat) * (((-230.258509299405 - mtat) *  0.333333333333333) +  1.0)) *  0.5) +  1.0)) +  1.0));
                end
                erfctimesexpmtat = ((tmp *  2.0) - erfcpos);
              end
              gammamax = (((__atatsti * erfctimesexpmtat) / ktat) *  0.886226925452758);
              itat = (((asrh * gammamax) * wtat) *  100.0e-6);
            end
            if (0) begin
            end
            else begin
              if (0) begin
              end
              else begin
                tmp = pow((( 0.79368 - vbbt) * __VBIRSTIinv),  0.27362);
              end
              Fmaxr = (__one_over_one_minus_PSTI * ((( 0.79368 - vbbt) * __wdepnulrinvsti) / tmp));
              if ((abs(((- __fbbtsti) / Fmaxr)) <  230.258509299405)) begin
                tmp = exp(((- __fbbtsti) / Fmaxr));
              end
              else begin
                if ((((- __fbbtsti) / Fmaxr) <  0.0)) begin
                  tmp = ( 100.0e-102 / (((-230.258509299405 - ((- __fbbtsti) / Fmaxr)) * ((((-230.258509299405 - ((- __fbbtsti) / Fmaxr)) * (((-230.258509299405 - ((- __fbbtsti) / Fmaxr)) *  0.333333333333333) +  1.0)) *  0.5) +  1.0)) +  1.0));
                end
                else begin
                  tmp = ((((((- __fbbtsti) / Fmaxr) -  230.258509299405) * ((((((- __fbbtsti) / Fmaxr) -  230.258509299405) * (((((- __fbbtsti) / Fmaxr) -  230.258509299405) *  0.333333333333333) +  1.0)) *  0.5) +  1.0)) +  1.0) *  10.0e+99);
                end
              end
              ibbt = ((((__V1 * Fmaxr) * Fmaxr) * tmp) *  1.0e-21);
            end
            if (0) begin
            end
            else begin
              if ((vav > ((- __alphaav) *  10.0))) begin
                if (1) begin
                  tmp = ((((vav * __VBRinvsti) * (vav * __VBRinvsti)) * (vav * __VBRinvsti)) * (vav * __VBRinvsti));
                end
                else begin
                end
                fbreakdown = ( 1.0 / ( 1.0 - tmp));
              end
              else begin
                fbreakdown = (__fstopsti + ((vav + (__alphaav *  10.0)) * __slopesti));
              end
            end
            ijunsti = ((((id + isrh) + itat) + ibbt) * fbreakdown);
          end
          if ((__LGSOURCE_i ==  0.0)) begin
            ijungat =  0.0;
            qjungat =  0.0;
          end
          else begin
            if ((__one_minus_PGAT ==  0.5)) begin
              tmp = sqrt(( 1.0 - (vj * __vbiinvgat)));
            end
            else begin
              tmp = pow(( 1.0 - (vj * __vbiinvgat)), __one_minus_PGAT);
            end
            qjungat = ((__qprefgat * ( 1.0 - tmp)) + (__qpref2gat * (__V1 - vj)));
            id = (__idsatgat * idmult);
            if (0) begin
            end
            else begin
              vbi_minus_vjsrh = (__vbigat - vjsrh);
              wsrhstep = ( 1.0 - sqrt(( 1.0 - (two_psistar / vbi_minus_vjsrh))));
              if (0) begin
              end
              else begin
                dwsrh = (((((wsrhstep * wsrhstep) * ln(wsrhstep)) / ( 1.0 - wsrhstep)) + wsrhstep) * -0.0848);
              end
              wsrh = (wsrhstep + dwsrh);
              if (0) begin
              end
              else begin
                tmp = pow((vbi_minus_vjsrh * __VBIRGATinv),  0.5424);
              end
              wdep = (__wdepnulrgat * tmp);
              asrh = (__ftdgat * ((zinv -  1.0) * wdep));
              isrh = ((asrh * wsrh) *  6.682e-6);
            end
            if (0) begin
            end
            else begin
              btat = (__btatpartgat * ((wdep * __one_minus_PGAT) / vbi_minus_vjsrh));
              twoatatoverthreebtat = ((__atatgat *  0.666666666666667) / btat);
              umaxbeforelimiting = (twoatatoverthreebtat * twoatatoverthreebtat);
              umax = sqrt(((umaxbeforelimiting * umaxbeforelimiting) / ((umaxbeforelimiting * umaxbeforelimiting) +  1.0)));
              sqrtumax = sqrt(umax);
              umaxpoweronepointfive = (umax * sqrtumax);
              if (((__one_over_one_minus_PGAT * -0.5424) == -1.0)) begin
                wgamma = ( 1.0 / ((btat * umaxpoweronepointfive) +  1.0));
              end
              else begin
                wgamma = pow(((btat * umaxpoweronepointfive) +  1.0), (__one_over_one_minus_PGAT * -0.5424));
              end
              wtat = ((wsrh * wgamma) / (wsrh + wgamma));
              ktat = sqrt(((btat / sqrtumax) *  0.375));
              ltat = (((twoatatoverthreebtat * sqrtumax) *  2.0) - umax);
              mtat = ((((__atatgat * twoatatoverthreebtat) * sqrtumax) - (__atatgat * umax)) + ((btat * umaxpoweronepointfive) *  0.5));
              xerfc = ((ltat -  1.0) * ktat);
              ysq = (xerfc * xerfc);
              if ((xerfc >  0.0)) begin
                terfc = ( 1.0 / ((__perfc * xerfc) +  1.0));
              end
              else begin
                terfc = ( 1.0 / ( 1.0 - (__perfc * xerfc)));
              end
              if ((((- ysq) + mtat) > -230.258509299405)) begin
                tmp = exp(((- ysq) + mtat));
              end
              else begin
                tmp = ( 100.0e-102 / (((-230.258509299405 - ((- ysq) + mtat)) * ((((-230.258509299405 - ((- ysq) + mtat)) * (((-230.258509299405 - ((- ysq) + mtat)) *  0.333333333333333) +  1.0)) *  0.5) +  1.0)) +  1.0));
              end
              erfcpos = ((((terfc *  0.29214664) + (__berfc * (terfc * terfc))) + (__cerfc * ((terfc * terfc) * terfc))) * tmp);
              if ((xerfc >  0.0)) begin
                erfctimesexpmtat = erfcpos;
              end
              else begin
                if ((mtat > -230.258509299405)) begin
                  tmp = exp(mtat);
                end
                else begin
                  tmp = ( 100.0e-102 / (((-230.258509299405 - mtat) * ((((-230.258509299405 - mtat) * (((-230.258509299405 - mtat) *  0.333333333333333) +  1.0)) *  0.5) +  1.0)) +  1.0));
                end
                erfctimesexpmtat = ((tmp *  2.0) - erfcpos);
              end
              gammamax = (((__atatgat * erfctimesexpmtat) / ktat) *  0.886226925452758);
              itat = (((asrh * gammamax) * wtat) *  100.0e-6);
            end
            if (0) begin
            end
            else begin
              if (0) begin
              end
              else begin
                tmp = pow((( 2.0 - vbbt) * __VBIRGATinv),  0.5424);
              end
              Fmaxr = (__one_over_one_minus_PGAT * ((( 2.0 - vbbt) * __wdepnulrinvgat) / tmp));
              if ((abs(((- __fbbtgat) / Fmaxr)) <  230.258509299405)) begin
                tmp = exp(((- __fbbtgat) / Fmaxr));
              end
              else begin
                if ((((- __fbbtgat) / Fmaxr) <  0.0)) begin
                  tmp = ( 100.0e-102 / (((-230.258509299405 - ((- __fbbtgat) / Fmaxr)) * ((((-230.258509299405 - ((- __fbbtgat) / Fmaxr)) * (((-230.258509299405 - ((- __fbbtgat) / Fmaxr)) *  0.333333333333333) +  1.0)) *  0.5) +  1.0)) +  1.0));
                end
                else begin
                  tmp = ((((((- __fbbtgat) / Fmaxr) -  230.258509299405) * ((((((- __fbbtgat) / Fmaxr) -  230.258509299405) * (((((- __fbbtgat) / Fmaxr) -  230.258509299405) *  0.333333333333333) +  1.0)) *  0.5) +  1.0)) +  1.0) *  10.0e+99);
                end
              end
              ibbt = ((((__V1 * Fmaxr) * Fmaxr) * tmp) *  1.0e-18);
            end
            if (0) begin
            end
            else begin
              if ((vav > ((- __alphaav) *  10.0))) begin
                if (1) begin
                  tmp = ((((vav * __VBRinvgat) * (vav * __VBRinvgat)) * (vav * __VBRinvgat)) * (vav * __VBRinvgat));
                end
                else begin
                end
                fbreakdown = ( 1.0 / ( 1.0 - tmp));
              end
              else begin
                fbreakdown = (__fstopgat + ((vav + (__alphaav *  10.0)) * __slopegat));
              end
            end
            ijungat = ((((id + isrh) + itat) + ibbt) * fbreakdown);
          end
          __I1 = (((__ABSOURCE_i * ijunbot) + (__LSSOURCE_i * ijunsti)) + (__LGSOURCE_i * ijungat));
          vbbt =  0.0;
          two_psistar =  0.0;
          if ((! (((__ABSOURCE_i ==  0.0) && (__LSSOURCE_i ==  0.0)) && (__LGSOURCE_i ==  0.0)))) begin
            h1 = ((__vch_s *  4.0) * __vch_s);
            h2 = (__vch_s / __vfmin_s);
            h2d = (__V2 + (__vch_s * h2));
            h3 = (__vfmin_s + h2d);
            h4 = (__vfmin_s - h2d);
            h5 = sqrt(((h4 * h4) + h1));
            vj = (((__V2 * __vfmin_s) / (h3 + h5)) *  2.0);
            if ((__V2 < __VMAX_s)) begin
              if ((abs(((__V2 * __phitdinv) *  0.5)) <  230.258509299405)) begin
                zinv = exp(((__V2 * __phitdinv) *  0.5));
              end
              else begin
                if ((((__V2 * __phitdinv) *  0.5) <  0.0)) begin
                  zinv = ( 100.0e-102 / (((-230.258509299405 - ((__V2 * __phitdinv) *  0.5)) * ((((-230.258509299405 - ((__V2 * __phitdinv) *  0.5)) * (((-230.258509299405 - ((__V2 * __phitdinv) *  0.5)) *  0.333333333333333) +  1.0)) *  0.5) +  1.0)) +  1.0));
                end
                else begin
                  zinv = ((((((__V2 * __phitdinv) *  0.5) -  230.258509299405) * ((((((__V2 * __phitdinv) *  0.5) -  230.258509299405) * (((((__V2 * __phitdinv) *  0.5) -  230.258509299405) *  0.333333333333333) +  1.0)) *  0.5) +  1.0)) +  1.0) *  10.0e+99);
                end
              end
              idmult = (zinv * zinv);
            end
            else begin
              idmult = ((((__V2 - __VMAX_s) * __phitdinv) +  1.0) * __exp_VMAX_over_phitd_s);
              zinv = sqrt(idmult);
            end
            idmult = (idmult -  1.0);
            z = ( 1.0 / zinv);
            if ((__V2 >  0.0)) begin
              two_psistar = ((__phitd * ln(((z +  2.0) + sqrt(((z +  1.0) * (z +  3.0)))))) *  2.0);
            end
            else begin
              two_psistar = ((- __V2) + ((__phitd * ln((((zinv *  2.0) +  1.0) + sqrt(((zinv +  1.0) * ((zinv *  3.0) +  1.0)))))) *  2.0));
            end
            vjlim = (__vbimin_s - two_psistar);
            vjsrh = (((__V2 + vjlim) - sqrt((((__V2 - vjlim) * (__V2 - vjlim)) + ((__phitd *  4.0) * __phitd)))) *  0.5);
            vbbt = (((__V2 + __vbbtlim_s) - sqrt((((__V2 - __vbbtlim_s) * (__V2 - __vbbtlim_s)) + ((__phitr *  4.0) * __phitr)))) *  0.5);
            vav = ((__V2 - sqrt(((__V2 * __V2) +  4.0e-12))) *  0.5);
          end
          if ((__ABSOURCE_i ==  0.0)) begin
            ijunbot =  0.0;
            qjunbot =  0.0;
          end
          else begin
            if ((__one_minus_PBOT ==  0.5)) begin
              tmp = sqrt(( 1.0 - (vj * __vbiinvbot)));
            end
            else begin
              tmp = pow(( 1.0 - (vj * __vbiinvbot)), __one_minus_PBOT);
            end
            qjunbot = ((__qprefbot * ( 1.0 - tmp)) + (__qpref2bot * (__V2 - vj)));
            id = (__idsatbot * idmult);
            if (0) begin
            end
            else begin
              vbi_minus_vjsrh = (__vbibot - vjsrh);
              wsrhstep = ( 1.0 - sqrt(( 1.0 - (two_psistar / vbi_minus_vjsrh))));
              if (0) begin
              end
              else begin
                dwsrh = (((((wsrhstep * wsrhstep) * ln(wsrhstep)) / ( 1.0 - wsrhstep)) + wsrhstep) *  0.37382);
              end
              wsrh = (wsrhstep + dwsrh);
              if (0) begin
              end
              else begin
                tmp = pow((vbi_minus_vjsrh * __VBIRBOTinv),  0.31309);
              end
              wdep = (__wdepnulrbot * tmp);
              asrh = (__ftdbot * ((zinv -  1.0) * wdep));
              isrh = ((asrh * wsrh) *  100.0);
            end
            if (0) begin
            end
            else begin
              btat = (__btatpartbot * ((wdep * __one_minus_PBOT) / vbi_minus_vjsrh));
              twoatatoverthreebtat = ((__atatbot *  0.666666666666667) / btat);
              umaxbeforelimiting = (twoatatoverthreebtat * twoatatoverthreebtat);
              umax = sqrt(((umaxbeforelimiting * umaxbeforelimiting) / ((umaxbeforelimiting * umaxbeforelimiting) +  1.0)));
              sqrtumax = sqrt(umax);
              umaxpoweronepointfive = (umax * sqrtumax);
              if (((__one_over_one_minus_PBOT * -0.31309) == -1.0)) begin
                wgamma = ( 1.0 / ((btat * umaxpoweronepointfive) +  1.0));
              end
              else begin
                wgamma = pow(((btat * umaxpoweronepointfive) +  1.0), (__one_over_one_minus_PBOT * -0.31309));
              end
              wtat = ((wsrh * wgamma) / (wsrh + wgamma));
              ktat = sqrt(((btat / sqrtumax) *  0.375));
              ltat = (((twoatatoverthreebtat * sqrtumax) *  2.0) - umax);
              mtat = ((((__atatbot * twoatatoverthreebtat) * sqrtumax) - (__atatbot * umax)) + ((btat * umaxpoweronepointfive) *  0.5));
              xerfc = ((ltat -  1.0) * ktat);
              ysq = (xerfc * xerfc);
              if ((xerfc >  0.0)) begin
                terfc = ( 1.0 / ((__perfc * xerfc) +  1.0));
              end
              else begin
                terfc = ( 1.0 / ( 1.0 - (__perfc * xerfc)));
              end
              if ((((- ysq) + mtat) > -230.258509299405)) begin
                tmp = exp(((- ysq) + mtat));
              end
              else begin
                tmp = ( 100.0e-102 / (((-230.258509299405 - ((- ysq) + mtat)) * ((((-230.258509299405 - ((- ysq) + mtat)) * (((-230.258509299405 - ((- ysq) + mtat)) *  0.333333333333333) +  1.0)) *  0.5) +  1.0)) +  1.0));
              end
              erfcpos = ((((terfc *  0.29214664) + (__berfc * (terfc * terfc))) + (__cerfc * ((terfc * terfc) * terfc))) * tmp);
              if ((xerfc >  0.0)) begin
                erfctimesexpmtat = erfcpos;
              end
              else begin
                if ((mtat > -230.258509299405)) begin
                  tmp = exp(mtat);
                end
                else begin
                  tmp = ( 100.0e-102 / (((-230.258509299405 - mtat) * ((((-230.258509299405 - mtat) * (((-230.258509299405 - mtat) *  0.333333333333333) +  1.0)) *  0.5) +  1.0)) +  1.0));
                end
                erfctimesexpmtat = ((tmp *  2.0) - erfcpos);
              end
              gammamax = (((__atatbot * erfctimesexpmtat) / ktat) *  0.886226925452758);
              itat = (((asrh * gammamax) * wtat) *  100.0);
            end
            if (0) begin
            end
            else begin
              if (0) begin
              end
              else begin
                tmp = pow((( 0.70829 - vbbt) * __VBIRBOTinv),  0.31309);
              end
              Fmaxr = (__one_over_one_minus_PBOT * ((( 0.70829 - vbbt) * __wdepnulrinvbot) / tmp));
              if ((abs(((- __fbbtbot) / Fmaxr)) <  230.258509299405)) begin
                tmp = exp(((- __fbbtbot) / Fmaxr));
              end
              else begin
                if ((((- __fbbtbot) / Fmaxr) <  0.0)) begin
                  tmp = ( 100.0e-102 / (((-230.258509299405 - ((- __fbbtbot) / Fmaxr)) * ((((-230.258509299405 - ((- __fbbtbot) / Fmaxr)) * (((-230.258509299405 - ((- __fbbtbot) / Fmaxr)) *  0.333333333333333) +  1.0)) *  0.5) +  1.0)) +  1.0));
                end
                else begin
                  tmp = ((((((- __fbbtbot) / Fmaxr) -  230.258509299405) * ((((((- __fbbtbot) / Fmaxr) -  230.258509299405) * (((((- __fbbtbot) / Fmaxr) -  230.258509299405) *  0.333333333333333) +  1.0)) *  0.5) +  1.0)) +  1.0) *  10.0e+99);
                end
              end
              ibbt = ((((__V2 * Fmaxr) * Fmaxr) * tmp) *  1.0e-12);
            end
            if (0) begin
            end
            else begin
              if ((vav > ((- __alphaav) *  10.0))) begin
                if (1) begin
                  tmp = ((((vav * __VBRinvbot) * (vav * __VBRinvbot)) * (vav * __VBRinvbot)) * (vav * __VBRinvbot));
                end
                else begin
                end
                fbreakdown = ( 1.0 / ( 1.0 - tmp));
              end
              else begin
                fbreakdown = (__fstopbot + ((vav + (__alphaav *  10.0)) * __slopebot));
              end
            end
            ijunbot = ((((id + isrh) + itat) + ibbt) * fbreakdown);
          end
          if ((__LSSOURCE_i ==  0.0)) begin
            ijunsti =  0.0;
            qjunsti =  0.0;
          end
          else begin
            if ((__one_minus_PSTI ==  0.5)) begin
              tmp = sqrt(( 1.0 - (vj * __vbiinvsti)));
            end
            else begin
              tmp = pow(( 1.0 - (vj * __vbiinvsti)), __one_minus_PSTI);
            end
            qjunsti = ((__qprefsti * ( 1.0 - tmp)) + (__qpref2sti * (__V2 - vj)));
            id = (__idsatsti * idmult);
            if (0) begin
            end
            else begin
              vbi_minus_vjsrh = (__vbisti - vjsrh);
              wsrhstep = ( 1.0 - sqrt(( 1.0 - (two_psistar / vbi_minus_vjsrh))));
              if (0) begin
              end
              else begin
                dwsrh = (((((wsrhstep * wsrhstep) * ln(wsrhstep)) / ( 1.0 - wsrhstep)) + wsrhstep) *  0.45276);
              end
              wsrh = (wsrhstep + dwsrh);
              if (0) begin
              end
              else begin
                tmp = pow((vbi_minus_vjsrh * __VBIRSTIinv),  0.27362);
              end
              wdep = (__wdepnulrsti * tmp);
              asrh = (__ftdsti * ((zinv -  1.0) * wdep));
              isrh = ((asrh * wsrh) *  100.0e-6);
            end
            if (0) begin
            end
            else begin
              btat = (__btatpartsti * ((wdep * __one_minus_PSTI) / vbi_minus_vjsrh));
              twoatatoverthreebtat = ((__atatsti *  0.666666666666667) / btat);
              umaxbeforelimiting = (twoatatoverthreebtat * twoatatoverthreebtat);
              umax = sqrt(((umaxbeforelimiting * umaxbeforelimiting) / ((umaxbeforelimiting * umaxbeforelimiting) +  1.0)));
              sqrtumax = sqrt(umax);
              umaxpoweronepointfive = (umax * sqrtumax);
              if (((__one_over_one_minus_PSTI * -0.27362) == -1.0)) begin
                wgamma = ( 1.0 / ((btat * umaxpoweronepointfive) +  1.0));
              end
              else begin
                wgamma = pow(((btat * umaxpoweronepointfive) +  1.0), (__one_over_one_minus_PSTI * -0.27362));
              end
              wtat = ((wsrh * wgamma) / (wsrh + wgamma));
              ktat = sqrt(((btat / sqrtumax) *  0.375));
              ltat = (((twoatatoverthreebtat * sqrtumax) *  2.0) - umax);
              mtat = ((((__atatsti * twoatatoverthreebtat) * sqrtumax) - (__atatsti * umax)) + ((btat * umaxpoweronepointfive) *  0.5));
              xerfc = ((ltat -  1.0) * ktat);
              ysq = (xerfc * xerfc);
              if ((xerfc >  0.0)) begin
                terfc = ( 1.0 / ((__perfc * xerfc) +  1.0));
              end
              else begin
                terfc = ( 1.0 / ( 1.0 - (__perfc * xerfc)));
              end
              if ((((- ysq) + mtat) > -230.258509299405)) begin
                tmp = exp(((- ysq) + mtat));
              end
              else begin
                tmp = ( 100.0e-102 / (((-230.258509299405 - ((- ysq) + mtat)) * ((((-230.258509299405 - ((- ysq) + mtat)) * (((-230.258509299405 - ((- ysq) + mtat)) *  0.333333333333333) +  1.0)) *  0.5) +  1.0)) +  1.0));
              end
              erfcpos = ((((terfc *  0.29214664) + (__berfc * (terfc * terfc))) + (__cerfc * ((terfc * terfc) * terfc))) * tmp);
              if ((xerfc >  0.0)) begin
                erfctimesexpmtat = erfcpos;
              end
              else begin
                if ((mtat > -230.258509299405)) begin
                  tmp = exp(mtat);
                end
                else begin
                  tmp = ( 100.0e-102 / (((-230.258509299405 - mtat) * ((((-230.258509299405 - mtat) * (((-230.258509299405 - mtat) *  0.333333333333333) +  1.0)) *  0.5) +  1.0)) +  1.0));
                end
                erfctimesexpmtat = ((tmp *  2.0) - erfcpos);
              end
              gammamax = (((__atatsti * erfctimesexpmtat) / ktat) *  0.886226925452758);
              itat = (((asrh * gammamax) * wtat) *  100.0e-6);
            end
            if (0) begin
            end
            else begin
              if (0) begin
              end
              else begin
                tmp = pow((( 0.79368 - vbbt) * __VBIRSTIinv),  0.27362);
              end
              Fmaxr = (__one_over_one_minus_PSTI * ((( 0.79368 - vbbt) * __wdepnulrinvsti) / tmp));
              if ((abs(((- __fbbtsti) / Fmaxr)) <  230.258509299405)) begin
                tmp = exp(((- __fbbtsti) / Fmaxr));
              end
              else begin
                if ((((- __fbbtsti) / Fmaxr) <  0.0)) begin
                  tmp = ( 100.0e-102 / (((-230.258509299405 - ((- __fbbtsti) / Fmaxr)) * ((((-230.258509299405 - ((- __fbbtsti) / Fmaxr)) * (((-230.258509299405 - ((- __fbbtsti) / Fmaxr)) *  0.333333333333333) +  1.0)) *  0.5) +  1.0)) +  1.0));
                end
                else begin
                  tmp = ((((((- __fbbtsti) / Fmaxr) -  230.258509299405) * ((((((- __fbbtsti) / Fmaxr) -  230.258509299405) * (((((- __fbbtsti) / Fmaxr) -  230.258509299405) *  0.333333333333333) +  1.0)) *  0.5) +  1.0)) +  1.0) *  10.0e+99);
                end
              end
              ibbt = ((((__V2 * Fmaxr) * Fmaxr) * tmp) *  1.0e-21);
            end
            if (0) begin
            end
            else begin
              if ((vav > ((- __alphaav) *  10.0))) begin
                if (1) begin
                  tmp = ((((vav * __VBRinvsti) * (vav * __VBRinvsti)) * (vav * __VBRinvsti)) * (vav * __VBRinvsti));
                end
                else begin
                end
                fbreakdown = ( 1.0 / ( 1.0 - tmp));
              end
              else begin
                fbreakdown = (__fstopsti + ((vav + (__alphaav *  10.0)) * __slopesti));
              end
            end
            ijunsti = ((((id + isrh) + itat) + ibbt) * fbreakdown);
          end
          if ((__LGSOURCE_i ==  0.0)) begin
            ijungat =  0.0;
            qjungat =  0.0;
          end
          else begin
            if ((__one_minus_PGAT ==  0.5)) begin
              tmp = sqrt(( 1.0 - (vj * __vbiinvgat)));
            end
            else begin
              tmp = pow(( 1.0 - (vj * __vbiinvgat)), __one_minus_PGAT);
            end
            qjungat = ((__qprefgat * ( 1.0 - tmp)) + (__qpref2gat * (__V2 - vj)));
            id = (__idsatgat * idmult);
            if (0) begin
            end
            else begin
              vbi_minus_vjsrh = (__vbigat - vjsrh);
              wsrhstep = ( 1.0 - sqrt(( 1.0 - (two_psistar / vbi_minus_vjsrh))));
              if (0) begin
              end
              else begin
                dwsrh = (((((wsrhstep * wsrhstep) * ln(wsrhstep)) / ( 1.0 - wsrhstep)) + wsrhstep) * -0.0848);
              end
              wsrh = (wsrhstep + dwsrh);
              if (0) begin
              end
              else begin
                tmp = pow((vbi_minus_vjsrh * __VBIRGATinv),  0.5424);
              end
              wdep = (__wdepnulrgat * tmp);
              asrh = (__ftdgat * ((zinv -  1.0) * wdep));
              isrh = ((asrh * wsrh) *  6.682e-6);
            end
            if (0) begin
            end
            else begin
              btat = (__btatpartgat * ((wdep * __one_minus_PGAT) / vbi_minus_vjsrh));
              twoatatoverthreebtat = ((__atatgat *  0.666666666666667) / btat);
              umaxbeforelimiting = (twoatatoverthreebtat * twoatatoverthreebtat);
              umax = sqrt(((umaxbeforelimiting * umaxbeforelimiting) / ((umaxbeforelimiting * umaxbeforelimiting) +  1.0)));
              sqrtumax = sqrt(umax);
              umaxpoweronepointfive = (umax * sqrtumax);
              if (((__one_over_one_minus_PGAT * -0.5424) == -1.0)) begin
                wgamma = ( 1.0 / ((btat * umaxpoweronepointfive) +  1.0));
              end
              else begin
                wgamma = pow(((btat * umaxpoweronepointfive) +  1.0), (__one_over_one_minus_PGAT * -0.5424));
              end
              wtat = ((wsrh * wgamma) / (wsrh + wgamma));
              ktat = sqrt(((btat / sqrtumax) *  0.375));
              ltat = (((twoatatoverthreebtat * sqrtumax) *  2.0) - umax);
              mtat = ((((__atatgat * twoatatoverthreebtat) * sqrtumax) - (__atatgat * umax)) + ((btat * umaxpoweronepointfive) *  0.5));
              xerfc = ((ltat -  1.0) * ktat);
              ysq = (xerfc * xerfc);
              if ((xerfc >  0.0)) begin
                terfc = ( 1.0 / ((__perfc * xerfc) +  1.0));
              end
              else begin
                terfc = ( 1.0 / ( 1.0 - (__perfc * xerfc)));
              end
              if ((((- ysq) + mtat) > -230.258509299405)) begin
                tmp = exp(((- ysq) + mtat));
              end
              else begin
                tmp = ( 100.0e-102 / (((-230.258509299405 - ((- ysq) + mtat)) * ((((-230.258509299405 - ((- ysq) + mtat)) * (((-230.258509299405 - ((- ysq) + mtat)) *  0.333333333333333) +  1.0)) *  0.5) +  1.0)) +  1.0));
              end
              erfcpos = ((((terfc *  0.29214664) + (__berfc * (terfc * terfc))) + (__cerfc * ((terfc * terfc) * terfc))) * tmp);
              if ((xerfc >  0.0)) begin
                erfctimesexpmtat = erfcpos;
              end
              else begin
                if ((mtat > -230.258509299405)) begin
                  tmp = exp(mtat);
                end
                else begin
                  tmp = ( 100.0e-102 / (((-230.258509299405 - mtat) * ((((-230.258509299405 - mtat) * (((-230.258509299405 - mtat) *  0.333333333333333) +  1.0)) *  0.5) +  1.0)) +  1.0));
                end
                erfctimesexpmtat = ((tmp *  2.0) - erfcpos);
              end
              gammamax = (((__atatgat * erfctimesexpmtat) / ktat) *  0.886226925452758);
              itat = (((asrh * gammamax) * wtat) *  100.0e-6);
            end
            if (0) begin
            end
            else begin
              if (0) begin
              end
              else begin
                tmp = pow((( 2.0 - vbbt) * __VBIRGATinv),  0.5424);
              end
              Fmaxr = (__one_over_one_minus_PGAT * ((( 2.0 - vbbt) * __wdepnulrinvgat) / tmp));
              if ((abs(((- __fbbtgat) / Fmaxr)) <  230.258509299405)) begin
                tmp = exp(((- __fbbtgat) / Fmaxr));
              end
              else begin
                if ((((- __fbbtgat) / Fmaxr) <  0.0)) begin
                  tmp = ( 100.0e-102 / (((-230.258509299405 - ((- __fbbtgat) / Fmaxr)) * ((((-230.258509299405 - ((- __fbbtgat) / Fmaxr)) * (((-230.258509299405 - ((- __fbbtgat) / Fmaxr)) *  0.333333333333333) +  1.0)) *  0.5) +  1.0)) +  1.0));
                end
                else begin
                  tmp = ((((((- __fbbtgat) / Fmaxr) -  230.258509299405) * ((((((- __fbbtgat) / Fmaxr) -  230.258509299405) * (((((- __fbbtgat) / Fmaxr) -  230.258509299405) *  0.333333333333333) +  1.0)) *  0.5) +  1.0)) +  1.0) *  10.0e+99);
                end
              end
              ibbt = ((((__V2 * Fmaxr) * Fmaxr) * tmp) *  1.0e-18);
            end
            if (0) begin
            end
            else begin
              if ((vav > ((- __alphaav) *  10.0))) begin
                if (1) begin
                  tmp = ((((vav * __VBRinvgat) * (vav * __VBRinvgat)) * (vav * __VBRinvgat)) * (vav * __VBRinvgat));
                end
                else begin
                end
                fbreakdown = ( 1.0 / ( 1.0 - tmp));
              end
              else begin
                fbreakdown = (__fstopgat + ((vav + (__alphaav *  10.0)) * __slopegat));
              end
            end
            ijungat = ((((id + isrh) + itat) + ibbt) * fbreakdown);
          end
          __I2 = (((__ABSOURCE_i * ijunbot) + (__LSSOURCE_i * ijunsti)) + (__LGSOURCE_i * ijungat));
          vbbt =  0.0;
          two_psistar =  0.0;
          if ((! (((__ABSOURCE_i ==  0.0) && (__LSSOURCE_i ==  0.0)) && (__LGSOURCE_i ==  0.0)))) begin
            h1 = ((__vch_s *  4.0) * __vch_s);
            h2 = (__vch_s / __vfmin_s);
            h2d = (__V3 + (__vch_s * h2));
            h3 = (__vfmin_s + h2d);
            h4 = (__vfmin_s - h2d);
            h5 = sqrt(((h4 * h4) + h1));
            vj = (((__V3 * __vfmin_s) / (h3 + h5)) *  2.0);
            if ((__V3 < __VMAX_s)) begin
              if ((abs(((__V3 * __phitdinv) *  0.5)) <  230.258509299405)) begin
                zinv = exp(((__V3 * __phitdinv) *  0.5));
              end
              else begin
                if ((((__V3 * __phitdinv) *  0.5) <  0.0)) begin
                  zinv = ( 100.0e-102 / (((-230.258509299405 - ((__V3 * __phitdinv) *  0.5)) * ((((-230.258509299405 - ((__V3 * __phitdinv) *  0.5)) * (((-230.258509299405 - ((__V3 * __phitdinv) *  0.5)) *  0.333333333333333) +  1.0)) *  0.5) +  1.0)) +  1.0));
                end
                else begin
                  zinv = ((((((__V3 * __phitdinv) *  0.5) -  230.258509299405) * ((((((__V3 * __phitdinv) *  0.5) -  230.258509299405) * (((((__V3 * __phitdinv) *  0.5) -  230.258509299405) *  0.333333333333333) +  1.0)) *  0.5) +  1.0)) +  1.0) *  10.0e+99);
                end
              end
              idmult = (zinv * zinv);
            end
            else begin
              idmult = ((((__V3 - __VMAX_s) * __phitdinv) +  1.0) * __exp_VMAX_over_phitd_s);
              zinv = sqrt(idmult);
            end
            idmult = (idmult -  1.0);
            z = ( 1.0 / zinv);
            if ((__V3 >  0.0)) begin
              two_psistar = ((__phitd * ln(((z +  2.0) + sqrt(((z +  1.0) * (z +  3.0)))))) *  2.0);
            end
            else begin
              two_psistar = ((- __V3) + ((__phitd * ln((((zinv *  2.0) +  1.0) + sqrt(((zinv +  1.0) * ((zinv *  3.0) +  1.0)))))) *  2.0));
            end
            vjlim = (__vbimin_s - two_psistar);
            vjsrh = (((__V3 + vjlim) - sqrt((((__V3 - vjlim) * (__V3 - vjlim)) + ((__phitd *  4.0) * __phitd)))) *  0.5);
            vbbt = (((__V3 + __vbbtlim_s) - sqrt((((__V3 - __vbbtlim_s) * (__V3 - __vbbtlim_s)) + ((__phitr *  4.0) * __phitr)))) *  0.5);
            vav = ((__V3 - sqrt(((__V3 * __V3) +  4.0e-12))) *  0.5);
          end
          if ((__ABSOURCE_i ==  0.0)) begin
            ijunbot =  0.0;
            qjunbot =  0.0;
          end
          else begin
            if ((__one_minus_PBOT ==  0.5)) begin
              tmp = sqrt(( 1.0 - (vj * __vbiinvbot)));
            end
            else begin
              tmp = pow(( 1.0 - (vj * __vbiinvbot)), __one_minus_PBOT);
            end
            qjunbot = ((__qprefbot * ( 1.0 - tmp)) + (__qpref2bot * (__V3 - vj)));
            id = (__idsatbot * idmult);
            if (0) begin
            end
            else begin
              vbi_minus_vjsrh = (__vbibot - vjsrh);
              wsrhstep = ( 1.0 - sqrt(( 1.0 - (two_psistar / vbi_minus_vjsrh))));
              if (0) begin
              end
              else begin
                dwsrh = (((((wsrhstep * wsrhstep) * ln(wsrhstep)) / ( 1.0 - wsrhstep)) + wsrhstep) *  0.37382);
              end
              wsrh = (wsrhstep + dwsrh);
              if (0) begin
              end
              else begin
                tmp = pow((vbi_minus_vjsrh * __VBIRBOTinv),  0.31309);
              end
              wdep = (__wdepnulrbot * tmp);
              asrh = (__ftdbot * ((zinv -  1.0) * wdep));
              isrh = ((asrh * wsrh) *  100.0);
            end
            if (0) begin
            end
            else begin
              btat = (__btatpartbot * ((wdep * __one_minus_PBOT) / vbi_minus_vjsrh));
              twoatatoverthreebtat = ((__atatbot *  0.666666666666667) / btat);
              umaxbeforelimiting = (twoatatoverthreebtat * twoatatoverthreebtat);
              umax = sqrt(((umaxbeforelimiting * umaxbeforelimiting) / ((umaxbeforelimiting * umaxbeforelimiting) +  1.0)));
              sqrtumax = sqrt(umax);
              umaxpoweronepointfive = (umax * sqrtumax);
              if (((__one_over_one_minus_PBOT * -0.31309) == -1.0)) begin
                wgamma = ( 1.0 / ((btat * umaxpoweronepointfive) +  1.0));
              end
              else begin
                wgamma = pow(((btat * umaxpoweronepointfive) +  1.0), (__one_over_one_minus_PBOT * -0.31309));
              end
              wtat = ((wsrh * wgamma) / (wsrh + wgamma));
              ktat = sqrt(((btat / sqrtumax) *  0.375));
              ltat = (((twoatatoverthreebtat * sqrtumax) *  2.0) - umax);
              mtat = ((((__atatbot * twoatatoverthreebtat) * sqrtumax) - (__atatbot * umax)) + ((btat * umaxpoweronepointfive) *  0.5));
              xerfc = ((ltat -  1.0) * ktat);
              ysq = (xerfc * xerfc);
              if ((xerfc >  0.0)) begin
                terfc = ( 1.0 / ((__perfc * xerfc) +  1.0));
              end
              else begin
                terfc = ( 1.0 / ( 1.0 - (__perfc * xerfc)));
              end
              if ((((- ysq) + mtat) > -230.258509299405)) begin
                tmp = exp(((- ysq) + mtat));
              end
              else begin
                tmp = ( 100.0e-102 / (((-230.258509299405 - ((- ysq) + mtat)) * ((((-230.258509299405 - ((- ysq) + mtat)) * (((-230.258509299405 - ((- ysq) + mtat)) *  0.333333333333333) +  1.0)) *  0.5) +  1.0)) +  1.0));
              end
              erfcpos = ((((terfc *  0.29214664) + (__berfc * (terfc * terfc))) + (__cerfc * ((terfc * terfc) * terfc))) * tmp);
              if ((xerfc >  0.0)) begin
                erfctimesexpmtat = erfcpos;
              end
              else begin
                if ((mtat > -230.258509299405)) begin
                  tmp = exp(mtat);
                end
                else begin
                  tmp = ( 100.0e-102 / (((-230.258509299405 - mtat) * ((((-230.258509299405 - mtat) * (((-230.258509299405 - mtat) *  0.333333333333333) +  1.0)) *  0.5) +  1.0)) +  1.0));
                end
                erfctimesexpmtat = ((tmp *  2.0) - erfcpos);
              end
              gammamax = (((__atatbot * erfctimesexpmtat) / ktat) *  0.886226925452758);
              itat = (((asrh * gammamax) * wtat) *  100.0);
            end
            if (0) begin
            end
            else begin
              if (0) begin
              end
              else begin
                tmp = pow((( 0.70829 - vbbt) * __VBIRBOTinv),  0.31309);
              end
              Fmaxr = (__one_over_one_minus_PBOT * ((( 0.70829 - vbbt) * __wdepnulrinvbot) / tmp));
              if ((abs(((- __fbbtbot) / Fmaxr)) <  230.258509299405)) begin
                tmp = exp(((- __fbbtbot) / Fmaxr));
              end
              else begin
                if ((((- __fbbtbot) / Fmaxr) <  0.0)) begin
                  tmp = ( 100.0e-102 / (((-230.258509299405 - ((- __fbbtbot) / Fmaxr)) * ((((-230.258509299405 - ((- __fbbtbot) / Fmaxr)) * (((-230.258509299405 - ((- __fbbtbot) / Fmaxr)) *  0.333333333333333) +  1.0)) *  0.5) +  1.0)) +  1.0));
                end
                else begin
                  tmp = ((((((- __fbbtbot) / Fmaxr) -  230.258509299405) * ((((((- __fbbtbot) / Fmaxr) -  230.258509299405) * (((((- __fbbtbot) / Fmaxr) -  230.258509299405) *  0.333333333333333) +  1.0)) *  0.5) +  1.0)) +  1.0) *  10.0e+99);
                end
              end
              ibbt = ((((__V3 * Fmaxr) * Fmaxr) * tmp) *  1.0e-12);
            end
            if (0) begin
            end
            else begin
              if ((vav > ((- __alphaav) *  10.0))) begin
                if (1) begin
                  tmp = ((((vav * __VBRinvbot) * (vav * __VBRinvbot)) * (vav * __VBRinvbot)) * (vav * __VBRinvbot));
                end
                else begin
                end
                fbreakdown = ( 1.0 / ( 1.0 - tmp));
              end
              else begin
                fbreakdown = (__fstopbot + ((vav + (__alphaav *  10.0)) * __slopebot));
              end
            end
            ijunbot = ((((id + isrh) + itat) + ibbt) * fbreakdown);
          end
          if ((__LSSOURCE_i ==  0.0)) begin
            ijunsti =  0.0;
            qjunsti =  0.0;
          end
          else begin
            if ((__one_minus_PSTI ==  0.5)) begin
              tmp = sqrt(( 1.0 - (vj * __vbiinvsti)));
            end
            else begin
              tmp = pow(( 1.0 - (vj * __vbiinvsti)), __one_minus_PSTI);
            end
            qjunsti = ((__qprefsti * ( 1.0 - tmp)) + (__qpref2sti * (__V3 - vj)));
            id = (__idsatsti * idmult);
            if (0) begin
            end
            else begin
              vbi_minus_vjsrh = (__vbisti - vjsrh);
              wsrhstep = ( 1.0 - sqrt(( 1.0 - (two_psistar / vbi_minus_vjsrh))));
              if (0) begin
              end
              else begin
                dwsrh = (((((wsrhstep * wsrhstep) * ln(wsrhstep)) / ( 1.0 - wsrhstep)) + wsrhstep) *  0.45276);
              end
              wsrh = (wsrhstep + dwsrh);
              if (0) begin
              end
              else begin
                tmp = pow((vbi_minus_vjsrh * __VBIRSTIinv),  0.27362);
              end
              wdep = (__wdepnulrsti * tmp);
              asrh = (__ftdsti * ((zinv -  1.0) * wdep));
              isrh = ((asrh * wsrh) *  100.0e-6);
            end
            if (0) begin
            end
            else begin
              btat = (__btatpartsti * ((wdep * __one_minus_PSTI) / vbi_minus_vjsrh));
              twoatatoverthreebtat = ((__atatsti *  0.666666666666667) / btat);
              umaxbeforelimiting = (twoatatoverthreebtat * twoatatoverthreebtat);
              umax = sqrt(((umaxbeforelimiting * umaxbeforelimiting) / ((umaxbeforelimiting * umaxbeforelimiting) +  1.0)));
              sqrtumax = sqrt(umax);
              umaxpoweronepointfive = (umax * sqrtumax);
              if (((__one_over_one_minus_PSTI * -0.27362) == -1.0)) begin
                wgamma = ( 1.0 / ((btat * umaxpoweronepointfive) +  1.0));
              end
              else begin
                wgamma = pow(((btat * umaxpoweronepointfive) +  1.0), (__one_over_one_minus_PSTI * -0.27362));
              end
              wtat = ((wsrh * wgamma) / (wsrh + wgamma));
              ktat = sqrt(((btat / sqrtumax) *  0.375));
              ltat = (((twoatatoverthreebtat * sqrtumax) *  2.0) - umax);
              mtat = ((((__atatsti * twoatatoverthreebtat) * sqrtumax) - (__atatsti * umax)) + ((btat * umaxpoweronepointfive) *  0.5));
              xerfc = ((ltat -  1.0) * ktat);
              ysq = (xerfc * xerfc);
              if ((xerfc >  0.0)) begin
                terfc = ( 1.0 / ((__perfc * xerfc) +  1.0));
              end
              else begin
                terfc = ( 1.0 / ( 1.0 - (__perfc * xerfc)));
              end
              if ((((- ysq) + mtat) > -230.258509299405)) begin
                tmp = exp(((- ysq) + mtat));
              end
              else begin
                tmp = ( 100.0e-102 / (((-230.258509299405 - ((- ysq) + mtat)) * ((((-230.258509299405 - ((- ysq) + mtat)) * (((-230.258509299405 - ((- ysq) + mtat)) *  0.333333333333333) +  1.0)) *  0.5) +  1.0)) +  1.0));
              end
              erfcpos = ((((terfc *  0.29214664) + (__berfc * (terfc * terfc))) + (__cerfc * ((terfc * terfc) * terfc))) * tmp);
              if ((xerfc >  0.0)) begin
                erfctimesexpmtat = erfcpos;
              end
              else begin
                if ((mtat > -230.258509299405)) begin
                  tmp = exp(mtat);
                end
                else begin
                  tmp = ( 100.0e-102 / (((-230.258509299405 - mtat) * ((((-230.258509299405 - mtat) * (((-230.258509299405 - mtat) *  0.333333333333333) +  1.0)) *  0.5) +  1.0)) +  1.0));
                end
                erfctimesexpmtat = ((tmp *  2.0) - erfcpos);
              end
              gammamax = (((__atatsti * erfctimesexpmtat) / ktat) *  0.886226925452758);
              itat = (((asrh * gammamax) * wtat) *  100.0e-6);
            end
            if (0) begin
            end
            else begin
              if (0) begin
              end
              else begin
                tmp = pow((( 0.79368 - vbbt) * __VBIRSTIinv),  0.27362);
              end
              Fmaxr = (__one_over_one_minus_PSTI * ((( 0.79368 - vbbt) * __wdepnulrinvsti) / tmp));
              if ((abs(((- __fbbtsti) / Fmaxr)) <  230.258509299405)) begin
                tmp = exp(((- __fbbtsti) / Fmaxr));
              end
              else begin
                if ((((- __fbbtsti) / Fmaxr) <  0.0)) begin
                  tmp = ( 100.0e-102 / (((-230.258509299405 - ((- __fbbtsti) / Fmaxr)) * ((((-230.258509299405 - ((- __fbbtsti) / Fmaxr)) * (((-230.258509299405 - ((- __fbbtsti) / Fmaxr)) *  0.333333333333333) +  1.0)) *  0.5) +  1.0)) +  1.0));
                end
                else begin
                  tmp = ((((((- __fbbtsti) / Fmaxr) -  230.258509299405) * ((((((- __fbbtsti) / Fmaxr) -  230.258509299405) * (((((- __fbbtsti) / Fmaxr) -  230.258509299405) *  0.333333333333333) +  1.0)) *  0.5) +  1.0)) +  1.0) *  10.0e+99);
                end
              end
              ibbt = ((((__V3 * Fmaxr) * Fmaxr) * tmp) *  1.0e-21);
            end
            if (0) begin
            end
            else begin
              if ((vav > ((- __alphaav) *  10.0))) begin
                if (1) begin
                  tmp = ((((vav * __VBRinvsti) * (vav * __VBRinvsti)) * (vav * __VBRinvsti)) * (vav * __VBRinvsti));
                end
                else begin
                end
                fbreakdown = ( 1.0 / ( 1.0 - tmp));
              end
              else begin
                fbreakdown = (__fstopsti + ((vav + (__alphaav *  10.0)) * __slopesti));
              end
            end
            ijunsti = ((((id + isrh) + itat) + ibbt) * fbreakdown);
          end
          if ((__LGSOURCE_i ==  0.0)) begin
            ijungat =  0.0;
            qjungat =  0.0;
          end
          else begin
            if ((__one_minus_PGAT ==  0.5)) begin
              tmp = sqrt(( 1.0 - (vj * __vbiinvgat)));
            end
            else begin
              tmp = pow(( 1.0 - (vj * __vbiinvgat)), __one_minus_PGAT);
            end
            qjungat = ((__qprefgat * ( 1.0 - tmp)) + (__qpref2gat * (__V3 - vj)));
            id = (__idsatgat * idmult);
            if (0) begin
            end
            else begin
              vbi_minus_vjsrh = (__vbigat - vjsrh);
              wsrhstep = ( 1.0 - sqrt(( 1.0 - (two_psistar / vbi_minus_vjsrh))));
              if (0) begin
              end
              else begin
                dwsrh = (((((wsrhstep * wsrhstep) * ln(wsrhstep)) / ( 1.0 - wsrhstep)) + wsrhstep) * -0.0848);
              end
              wsrh = (wsrhstep + dwsrh);
              if (0) begin
              end
              else begin
                tmp = pow((vbi_minus_vjsrh * __VBIRGATinv),  0.5424);
              end
              wdep = (__wdepnulrgat * tmp);
              asrh = (__ftdgat * ((zinv -  1.0) * wdep));
              isrh = ((asrh * wsrh) *  6.682e-6);
            end
            if (0) begin
            end
            else begin
              btat = (__btatpartgat * ((wdep * __one_minus_PGAT) / vbi_minus_vjsrh));
              twoatatoverthreebtat = ((__atatgat *  0.666666666666667) / btat);
              umaxbeforelimiting = (twoatatoverthreebtat * twoatatoverthreebtat);
              umax = sqrt(((umaxbeforelimiting * umaxbeforelimiting) / ((umaxbeforelimiting * umaxbeforelimiting) +  1.0)));
              sqrtumax = sqrt(umax);
              umaxpoweronepointfive = (umax * sqrtumax);
              if (((__one_over_one_minus_PGAT * -0.5424) == -1.0)) begin
                wgamma = ( 1.0 / ((btat * umaxpoweronepointfive) +  1.0));
              end
              else begin
                wgamma = pow(((btat * umaxpoweronepointfive) +  1.0), (__one_over_one_minus_PGAT * -0.5424));
              end
              wtat = ((wsrh * wgamma) / (wsrh + wgamma));
              ktat = sqrt(((btat / sqrtumax) *  0.375));
              ltat = (((twoatatoverthreebtat * sqrtumax) *  2.0) - umax);
              mtat = ((((__atatgat * twoatatoverthreebtat) * sqrtumax) - (__atatgat * umax)) + ((btat * umaxpoweronepointfive) *  0.5));
              xerfc = ((ltat -  1.0) * ktat);
              ysq = (xerfc * xerfc);
              if ((xerfc >  0.0)) begin
                terfc = ( 1.0 / ((__perfc * xerfc) +  1.0));
              end
              else begin
                terfc = ( 1.0 / ( 1.0 - (__perfc * xerfc)));
              end
              if ((((- ysq) + mtat) > -230.258509299405)) begin
                tmp = exp(((- ysq) + mtat));
              end
              else begin
                tmp = ( 100.0e-102 / (((-230.258509299405 - ((- ysq) + mtat)) * ((((-230.258509299405 - ((- ysq) + mtat)) * (((-230.258509299405 - ((- ysq) + mtat)) *  0.333333333333333) +  1.0)) *  0.5) +  1.0)) +  1.0));
              end
              erfcpos = ((((terfc *  0.29214664) + (__berfc * (terfc * terfc))) + (__cerfc * ((terfc * terfc) * terfc))) * tmp);
              if ((xerfc >  0.0)) begin
                erfctimesexpmtat = erfcpos;
              end
              else begin
                if ((mtat > -230.258509299405)) begin
                  tmp = exp(mtat);
                end
                else begin
                  tmp = ( 100.0e-102 / (((-230.258509299405 - mtat) * ((((-230.258509299405 - mtat) * (((-230.258509299405 - mtat) *  0.333333333333333) +  1.0)) *  0.5) +  1.0)) +  1.0));
                end
                erfctimesexpmtat = ((tmp *  2.0) - erfcpos);
              end
              gammamax = (((__atatgat * erfctimesexpmtat) / ktat) *  0.886226925452758);
              itat = (((asrh * gammamax) * wtat) *  100.0e-6);
            end
            if (0) begin
            end
            else begin
              if (0) begin
              end
              else begin
                tmp = pow((( 2.0 - vbbt) * __VBIRGATinv),  0.5424);
              end
              Fmaxr = (__one_over_one_minus_PGAT * ((( 2.0 - vbbt) * __wdepnulrinvgat) / tmp));
              if ((abs(((- __fbbtgat) / Fmaxr)) <  230.258509299405)) begin
                tmp = exp(((- __fbbtgat) / Fmaxr));
              end
              else begin
                if ((((- __fbbtgat) / Fmaxr) <  0.0)) begin
                  tmp = ( 100.0e-102 / (((-230.258509299405 - ((- __fbbtgat) / Fmaxr)) * ((((-230.258509299405 - ((- __fbbtgat) / Fmaxr)) * (((-230.258509299405 - ((- __fbbtgat) / Fmaxr)) *  0.333333333333333) +  1.0)) *  0.5) +  1.0)) +  1.0));
                end
                else begin
                  tmp = ((((((- __fbbtgat) / Fmaxr) -  230.258509299405) * ((((((- __fbbtgat) / Fmaxr) -  230.258509299405) * (((((- __fbbtgat) / Fmaxr) -  230.258509299405) *  0.333333333333333) +  1.0)) *  0.5) +  1.0)) +  1.0) *  10.0e+99);
                end
              end
              ibbt = ((((__V3 * Fmaxr) * Fmaxr) * tmp) *  1.0e-18);
            end
            if (0) begin
            end
            else begin
              if ((vav > ((- __alphaav) *  10.0))) begin
                if (1) begin
                  tmp = ((((vav * __VBRinvgat) * (vav * __VBRinvgat)) * (vav * __VBRinvgat)) * (vav * __VBRinvgat));
                end
                else begin
                end
                fbreakdown = ( 1.0 / ( 1.0 - tmp));
              end
              else begin
                fbreakdown = (__fstopgat + ((vav + (__alphaav *  10.0)) * __slopegat));
              end
            end
            ijungat = ((((id + isrh) + itat) + ibbt) * fbreakdown);
          end
          __I3 = (((__ABSOURCE_i * ijunbot) + (__LSSOURCE_i * ijunsti)) + (__LGSOURCE_i * ijungat));
          vbbt =  0.0;
          two_psistar =  0.0;
          if ((! (((__ABSOURCE_i ==  0.0) && (__LSSOURCE_i ==  0.0)) && (__LGSOURCE_i ==  0.0)))) begin
            h1 = ((__vch_s *  4.0) * __vch_s);
            h2 = (__vch_s / __vfmin_s);
            h2d = (__V4 + (__vch_s * h2));
            h3 = (__vfmin_s + h2d);
            h4 = (__vfmin_s - h2d);
            h5 = sqrt(((h4 * h4) + h1));
            vj = (((__V4 * __vfmin_s) / (h3 + h5)) *  2.0);
            if ((__V4 < __VMAX_s)) begin
              if ((abs(((__V4 * __phitdinv) *  0.5)) <  230.258509299405)) begin
                zinv = exp(((__V4 * __phitdinv) *  0.5));
              end
              else begin
                if ((((__V4 * __phitdinv) *  0.5) <  0.0)) begin
                  zinv = ( 100.0e-102 / (((-230.258509299405 - ((__V4 * __phitdinv) *  0.5)) * ((((-230.258509299405 - ((__V4 * __phitdinv) *  0.5)) * (((-230.258509299405 - ((__V4 * __phitdinv) *  0.5)) *  0.333333333333333) +  1.0)) *  0.5) +  1.0)) +  1.0));
                end
                else begin
                  zinv = ((((((__V4 * __phitdinv) *  0.5) -  230.258509299405) * ((((((__V4 * __phitdinv) *  0.5) -  230.258509299405) * (((((__V4 * __phitdinv) *  0.5) -  230.258509299405) *  0.333333333333333) +  1.0)) *  0.5) +  1.0)) +  1.0) *  10.0e+99);
                end
              end
              idmult = (zinv * zinv);
            end
            else begin
              idmult = ((((__V4 - __VMAX_s) * __phitdinv) +  1.0) * __exp_VMAX_over_phitd_s);
              zinv = sqrt(idmult);
            end
            idmult = (idmult -  1.0);
            z = ( 1.0 / zinv);
            if ((__V4 >  0.0)) begin
              two_psistar = ((__phitd * ln(((z +  2.0) + sqrt(((z +  1.0) * (z +  3.0)))))) *  2.0);
            end
            else begin
              two_psistar = ((- __V4) + ((__phitd * ln((((zinv *  2.0) +  1.0) + sqrt(((zinv +  1.0) * ((zinv *  3.0) +  1.0)))))) *  2.0));
            end
            vjlim = (__vbimin_s - two_psistar);
            vjsrh = (((__V4 + vjlim) - sqrt((((__V4 - vjlim) * (__V4 - vjlim)) + ((__phitd *  4.0) * __phitd)))) *  0.5);
            vbbt = (((__V4 + __vbbtlim_s) - sqrt((((__V4 - __vbbtlim_s) * (__V4 - __vbbtlim_s)) + ((__phitr *  4.0) * __phitr)))) *  0.5);
            vav = ((__V4 - sqrt(((__V4 * __V4) +  4.0e-12))) *  0.5);
          end
          if ((__ABSOURCE_i ==  0.0)) begin
            ijunbot =  0.0;
            qjunbot =  0.0;
          end
          else begin
            if ((__one_minus_PBOT ==  0.5)) begin
              tmp = sqrt(( 1.0 - (vj * __vbiinvbot)));
            end
            else begin
              tmp = pow(( 1.0 - (vj * __vbiinvbot)), __one_minus_PBOT);
            end
            qjunbot = ((__qprefbot * ( 1.0 - tmp)) + (__qpref2bot * (__V4 - vj)));
            id = (__idsatbot * idmult);
            if (0) begin
            end
            else begin
              vbi_minus_vjsrh = (__vbibot - vjsrh);
              wsrhstep = ( 1.0 - sqrt(( 1.0 - (two_psistar / vbi_minus_vjsrh))));
              if (0) begin
              end
              else begin
                dwsrh = (((((wsrhstep * wsrhstep) * ln(wsrhstep)) / ( 1.0 - wsrhstep)) + wsrhstep) *  0.37382);
              end
              wsrh = (wsrhstep + dwsrh);
              if (0) begin
              end
              else begin
                tmp = pow((vbi_minus_vjsrh * __VBIRBOTinv),  0.31309);
              end
              wdep = (__wdepnulrbot * tmp);
              asrh = (__ftdbot * ((zinv -  1.0) * wdep));
              isrh = ((asrh * wsrh) *  100.0);
            end
            if (0) begin
            end
            else begin
              btat = (__btatpartbot * ((wdep * __one_minus_PBOT) / vbi_minus_vjsrh));
              twoatatoverthreebtat = ((__atatbot *  0.666666666666667) / btat);
              umaxbeforelimiting = (twoatatoverthreebtat * twoatatoverthreebtat);
              umax = sqrt(((umaxbeforelimiting * umaxbeforelimiting) / ((umaxbeforelimiting * umaxbeforelimiting) +  1.0)));
              sqrtumax = sqrt(umax);
              umaxpoweronepointfive = (umax * sqrtumax);
              if (((__one_over_one_minus_PBOT * -0.31309) == -1.0)) begin
                wgamma = ( 1.0 / ((btat * umaxpoweronepointfive) +  1.0));
              end
              else begin
                wgamma = pow(((btat * umaxpoweronepointfive) +  1.0), (__one_over_one_minus_PBOT * -0.31309));
              end
              wtat = ((wsrh * wgamma) / (wsrh + wgamma));
              ktat = sqrt(((btat / sqrtumax) *  0.375));
              ltat = (((twoatatoverthreebtat * sqrtumax) *  2.0) - umax);
              mtat = ((((__atatbot * twoatatoverthreebtat) * sqrtumax) - (__atatbot * umax)) + ((btat * umaxpoweronepointfive) *  0.5));
              xerfc = ((ltat -  1.0) * ktat);
              ysq = (xerfc * xerfc);
              if ((xerfc >  0.0)) begin
                terfc = ( 1.0 / ((__perfc * xerfc) +  1.0));
              end
              else begin
                terfc = ( 1.0 / ( 1.0 - (__perfc * xerfc)));
              end
              if ((((- ysq) + mtat) > -230.258509299405)) begin
                tmp = exp(((- ysq) + mtat));
              end
              else begin
                tmp = ( 100.0e-102 / (((-230.258509299405 - ((- ysq) + mtat)) * ((((-230.258509299405 - ((- ysq) + mtat)) * (((-230.258509299405 - ((- ysq) + mtat)) *  0.333333333333333) +  1.0)) *  0.5) +  1.0)) +  1.0));
              end
              erfcpos = ((((terfc *  0.29214664) + (__berfc * (terfc * terfc))) + (__cerfc * ((terfc * terfc) * terfc))) * tmp);
              if ((xerfc >  0.0)) begin
                erfctimesexpmtat = erfcpos;
              end
              else begin
                if ((mtat > -230.258509299405)) begin
                  tmp = exp(mtat);
                end
                else begin
                  tmp = ( 100.0e-102 / (((-230.258509299405 - mtat) * ((((-230.258509299405 - mtat) * (((-230.258509299405 - mtat) *  0.333333333333333) +  1.0)) *  0.5) +  1.0)) +  1.0));
                end
                erfctimesexpmtat = ((tmp *  2.0) - erfcpos);
              end
              gammamax = (((__atatbot * erfctimesexpmtat) / ktat) *  0.886226925452758);
              itat = (((asrh * gammamax) * wtat) *  100.0);
            end
            if (0) begin
            end
            else begin
              if (0) begin
              end
              else begin
                tmp = pow((( 0.70829 - vbbt) * __VBIRBOTinv),  0.31309);
              end
              Fmaxr = (__one_over_one_minus_PBOT * ((( 0.70829 - vbbt) * __wdepnulrinvbot) / tmp));
              if ((abs(((- __fbbtbot) / Fmaxr)) <  230.258509299405)) begin
                tmp = exp(((- __fbbtbot) / Fmaxr));
              end
              else begin
                if ((((- __fbbtbot) / Fmaxr) <  0.0)) begin
                  tmp = ( 100.0e-102 / (((-230.258509299405 - ((- __fbbtbot) / Fmaxr)) * ((((-230.258509299405 - ((- __fbbtbot) / Fmaxr)) * (((-230.258509299405 - ((- __fbbtbot) / Fmaxr)) *  0.333333333333333) +  1.0)) *  0.5) +  1.0)) +  1.0));
                end
                else begin
                  tmp = ((((((- __fbbtbot) / Fmaxr) -  230.258509299405) * ((((((- __fbbtbot) / Fmaxr) -  230.258509299405) * (((((- __fbbtbot) / Fmaxr) -  230.258509299405) *  0.333333333333333) +  1.0)) *  0.5) +  1.0)) +  1.0) *  10.0e+99);
                end
              end
              ibbt = ((((__V4 * Fmaxr) * Fmaxr) * tmp) *  1.0e-12);
            end
            if (0) begin
            end
            else begin
              if ((vav > ((- __alphaav) *  10.0))) begin
                if (1) begin
                  tmp = ((((vav * __VBRinvbot) * (vav * __VBRinvbot)) * (vav * __VBRinvbot)) * (vav * __VBRinvbot));
                end
                else begin
                end
                fbreakdown = ( 1.0 / ( 1.0 - tmp));
              end
              else begin
                fbreakdown = (__fstopbot + ((vav + (__alphaav *  10.0)) * __slopebot));
              end
            end
            ijunbot = ((((id + isrh) + itat) + ibbt) * fbreakdown);
          end
          if ((__LSSOURCE_i ==  0.0)) begin
            ijunsti =  0.0;
            qjunsti =  0.0;
          end
          else begin
            if ((__one_minus_PSTI ==  0.5)) begin
              tmp = sqrt(( 1.0 - (vj * __vbiinvsti)));
            end
            else begin
              tmp = pow(( 1.0 - (vj * __vbiinvsti)), __one_minus_PSTI);
            end
            qjunsti = ((__qprefsti * ( 1.0 - tmp)) + (__qpref2sti * (__V4 - vj)));
            id = (__idsatsti * idmult);
            if (0) begin
            end
            else begin
              vbi_minus_vjsrh = (__vbisti - vjsrh);
              wsrhstep = ( 1.0 - sqrt(( 1.0 - (two_psistar / vbi_minus_vjsrh))));
              if (0) begin
              end
              else begin
                dwsrh = (((((wsrhstep * wsrhstep) * ln(wsrhstep)) / ( 1.0 - wsrhstep)) + wsrhstep) *  0.45276);
              end
              wsrh = (wsrhstep + dwsrh);
              if (0) begin
              end
              else begin
                tmp = pow((vbi_minus_vjsrh * __VBIRSTIinv),  0.27362);
              end
              wdep = (__wdepnulrsti * tmp);
              asrh = (__ftdsti * ((zinv -  1.0) * wdep));
              isrh = ((asrh * wsrh) *  100.0e-6);
            end
            if (0) begin
            end
            else begin
              btat = (__btatpartsti * ((wdep * __one_minus_PSTI) / vbi_minus_vjsrh));
              twoatatoverthreebtat = ((__atatsti *  0.666666666666667) / btat);
              umaxbeforelimiting = (twoatatoverthreebtat * twoatatoverthreebtat);
              umax = sqrt(((umaxbeforelimiting * umaxbeforelimiting) / ((umaxbeforelimiting * umaxbeforelimiting) +  1.0)));
              sqrtumax = sqrt(umax);
              umaxpoweronepointfive = (umax * sqrtumax);
              if (((__one_over_one_minus_PSTI * -0.27362) == -1.0)) begin
                wgamma = ( 1.0 / ((btat * umaxpoweronepointfive) +  1.0));
              end
              else begin
                wgamma = pow(((btat * umaxpoweronepointfive) +  1.0), (__one_over_one_minus_PSTI * -0.27362));
              end
              wtat = ((wsrh * wgamma) / (wsrh + wgamma));
              ktat = sqrt(((btat / sqrtumax) *  0.375));
              ltat = (((twoatatoverthreebtat * sqrtumax) *  2.0) - umax);
              mtat = ((((__atatsti * twoatatoverthreebtat) * sqrtumax) - (__atatsti * umax)) + ((btat * umaxpoweronepointfive) *  0.5));
              xerfc = ((ltat -  1.0) * ktat);
              ysq = (xerfc * xerfc);
              if ((xerfc >  0.0)) begin
                terfc = ( 1.0 / ((__perfc * xerfc) +  1.0));
              end
              else begin
                terfc = ( 1.0 / ( 1.0 - (__perfc * xerfc)));
              end
              if ((((- ysq) + mtat) > -230.258509299405)) begin
                tmp = exp(((- ysq) + mtat));
              end
              else begin
                tmp = ( 100.0e-102 / (((-230.258509299405 - ((- ysq) + mtat)) * ((((-230.258509299405 - ((- ysq) + mtat)) * (((-230.258509299405 - ((- ysq) + mtat)) *  0.333333333333333) +  1.0)) *  0.5) +  1.0)) +  1.0));
              end
              erfcpos = ((((terfc *  0.29214664) + (__berfc * (terfc * terfc))) + (__cerfc * ((terfc * terfc) * terfc))) * tmp);
              if ((xerfc >  0.0)) begin
                erfctimesexpmtat = erfcpos;
              end
              else begin
                if ((mtat > -230.258509299405)) begin
                  tmp = exp(mtat);
                end
                else begin
                  tmp = ( 100.0e-102 / (((-230.258509299405 - mtat) * ((((-230.258509299405 - mtat) * (((-230.258509299405 - mtat) *  0.333333333333333) +  1.0)) *  0.5) +  1.0)) +  1.0));
                end
                erfctimesexpmtat = ((tmp *  2.0) - erfcpos);
              end
              gammamax = (((__atatsti * erfctimesexpmtat) / ktat) *  0.886226925452758);
              itat = (((asrh * gammamax) * wtat) *  100.0e-6);
            end
            if (0) begin
            end
            else begin
              if (0) begin
              end
              else begin
                tmp = pow((( 0.79368 - vbbt) * __VBIRSTIinv),  0.27362);
              end
              Fmaxr = (__one_over_one_minus_PSTI * ((( 0.79368 - vbbt) * __wdepnulrinvsti) / tmp));
              if ((abs(((- __fbbtsti) / Fmaxr)) <  230.258509299405)) begin
                tmp = exp(((- __fbbtsti) / Fmaxr));
              end
              else begin
                if ((((- __fbbtsti) / Fmaxr) <  0.0)) begin
                  tmp = ( 100.0e-102 / (((-230.258509299405 - ((- __fbbtsti) / Fmaxr)) * ((((-230.258509299405 - ((- __fbbtsti) / Fmaxr)) * (((-230.258509299405 - ((- __fbbtsti) / Fmaxr)) *  0.333333333333333) +  1.0)) *  0.5) +  1.0)) +  1.0));
                end
                else begin
                  tmp = ((((((- __fbbtsti) / Fmaxr) -  230.258509299405) * ((((((- __fbbtsti) / Fmaxr) -  230.258509299405) * (((((- __fbbtsti) / Fmaxr) -  230.258509299405) *  0.333333333333333) +  1.0)) *  0.5) +  1.0)) +  1.0) *  10.0e+99);
                end
              end
              ibbt = ((((__V4 * Fmaxr) * Fmaxr) * tmp) *  1.0e-21);
            end
            if (0) begin
            end
            else begin
              if ((vav > ((- __alphaav) *  10.0))) begin
                if (1) begin
                  tmp = ((((vav * __VBRinvsti) * (vav * __VBRinvsti)) * (vav * __VBRinvsti)) * (vav * __VBRinvsti));
                end
                else begin
                end
                fbreakdown = ( 1.0 / ( 1.0 - tmp));
              end
              else begin
                fbreakdown = (__fstopsti + ((vav + (__alphaav *  10.0)) * __slopesti));
              end
            end
            ijunsti = ((((id + isrh) + itat) + ibbt) * fbreakdown);
          end
          if ((__LGSOURCE_i ==  0.0)) begin
            ijungat =  0.0;
            qjungat =  0.0;
          end
          else begin
            if ((__one_minus_PGAT ==  0.5)) begin
              tmp = sqrt(( 1.0 - (vj * __vbiinvgat)));
            end
            else begin
              tmp = pow(( 1.0 - (vj * __vbiinvgat)), __one_minus_PGAT);
            end
            qjungat = ((__qprefgat * ( 1.0 - tmp)) + (__qpref2gat * (__V4 - vj)));
            id = (__idsatgat * idmult);
            if (0) begin
            end
            else begin
              vbi_minus_vjsrh = (__vbigat - vjsrh);
              wsrhstep = ( 1.0 - sqrt(( 1.0 - (two_psistar / vbi_minus_vjsrh))));
              if (0) begin
              end
              else begin
                dwsrh = (((((wsrhstep * wsrhstep) * ln(wsrhstep)) / ( 1.0 - wsrhstep)) + wsrhstep) * -0.0848);
              end
              wsrh = (wsrhstep + dwsrh);
              if (0) begin
              end
              else begin
                tmp = pow((vbi_minus_vjsrh * __VBIRGATinv),  0.5424);
              end
              wdep = (__wdepnulrgat * tmp);
              asrh = (__ftdgat * ((zinv -  1.0) * wdep));
              isrh = ((asrh * wsrh) *  6.682e-6);
            end
            if (0) begin
            end
            else begin
              btat = (__btatpartgat * ((wdep * __one_minus_PGAT) / vbi_minus_vjsrh));
              twoatatoverthreebtat = ((__atatgat *  0.666666666666667) / btat);
              umaxbeforelimiting = (twoatatoverthreebtat * twoatatoverthreebtat);
              umax = sqrt(((umaxbeforelimiting * umaxbeforelimiting) / ((umaxbeforelimiting * umaxbeforelimiting) +  1.0)));
              sqrtumax = sqrt(umax);
              umaxpoweronepointfive = (umax * sqrtumax);
              if (((__one_over_one_minus_PGAT * -0.5424) == -1.0)) begin
                wgamma = ( 1.0 / ((btat * umaxpoweronepointfive) +  1.0));
              end
              else begin
                wgamma = pow(((btat * umaxpoweronepointfive) +  1.0), (__one_over_one_minus_PGAT * -0.5424));
              end
              wtat = ((wsrh * wgamma) / (wsrh + wgamma));
              ktat = sqrt(((btat / sqrtumax) *  0.375));
              ltat = (((twoatatoverthreebtat * sqrtumax) *  2.0) - umax);
              mtat = ((((__atatgat * twoatatoverthreebtat) * sqrtumax) - (__atatgat * umax)) + ((btat * umaxpoweronepointfive) *  0.5));
              xerfc = ((ltat -  1.0) * ktat);
              ysq = (xerfc * xerfc);
              if ((xerfc >  0.0)) begin
                terfc = ( 1.0 / ((__perfc * xerfc) +  1.0));
              end
              else begin
                terfc = ( 1.0 / ( 1.0 - (__perfc * xerfc)));
              end
              if ((((- ysq) + mtat) > -230.258509299405)) begin
                tmp = exp(((- ysq) + mtat));
              end
              else begin
                tmp = ( 100.0e-102 / (((-230.258509299405 - ((- ysq) + mtat)) * ((((-230.258509299405 - ((- ysq) + mtat)) * (((-230.258509299405 - ((- ysq) + mtat)) *  0.333333333333333) +  1.0)) *  0.5) +  1.0)) +  1.0));
              end
              erfcpos = ((((terfc *  0.29214664) + (__berfc * (terfc * terfc))) + (__cerfc * ((terfc * terfc) * terfc))) * tmp);
              if ((xerfc >  0.0)) begin
                erfctimesexpmtat = erfcpos;
              end
              else begin
                if ((mtat > -230.258509299405)) begin
                  tmp = exp(mtat);
                end
                else begin
                  tmp = ( 100.0e-102 / (((-230.258509299405 - mtat) * ((((-230.258509299405 - mtat) * (((-230.258509299405 - mtat) *  0.333333333333333) +  1.0)) *  0.5) +  1.0)) +  1.0));
                end
                erfctimesexpmtat = ((tmp *  2.0) - erfcpos);
              end
              gammamax = (((__atatgat * erfctimesexpmtat) / ktat) *  0.886226925452758);
              itat = (((asrh * gammamax) * wtat) *  100.0e-6);
            end
            if (0) begin
            end
            else begin
              if (0) begin
              end
              else begin
                tmp = pow((( 2.0 - vbbt) * __VBIRGATinv),  0.5424);
              end
              Fmaxr = (__one_over_one_minus_PGAT * ((( 2.0 - vbbt) * __wdepnulrinvgat) / tmp));
              if ((abs(((- __fbbtgat) / Fmaxr)) <  230.258509299405)) begin
                tmp = exp(((- __fbbtgat) / Fmaxr));
              end
              else begin
                if ((((- __fbbtgat) / Fmaxr) <  0.0)) begin
                  tmp = ( 100.0e-102 / (((-230.258509299405 - ((- __fbbtgat) / Fmaxr)) * ((((-230.258509299405 - ((- __fbbtgat) / Fmaxr)) * (((-230.258509299405 - ((- __fbbtgat) / Fmaxr)) *  0.333333333333333) +  1.0)) *  0.5) +  1.0)) +  1.0));
                end
                else begin
                  tmp = ((((((- __fbbtgat) / Fmaxr) -  230.258509299405) * ((((((- __fbbtgat) / Fmaxr) -  230.258509299405) * (((((- __fbbtgat) / Fmaxr) -  230.258509299405) *  0.333333333333333) +  1.0)) *  0.5) +  1.0)) +  1.0) *  10.0e+99);
                end
              end
              ibbt = ((((__V4 * Fmaxr) * Fmaxr) * tmp) *  1.0e-18);
            end
            if (0) begin
            end
            else begin
              if ((vav > ((- __alphaav) *  10.0))) begin
                if (1) begin
                  tmp = ((((vav * __VBRinvgat) * (vav * __VBRinvgat)) * (vav * __VBRinvgat)) * (vav * __VBRinvgat));
                end
                else begin
                end
                fbreakdown = ( 1.0 / ( 1.0 - tmp));
              end
              else begin
                fbreakdown = (__fstopgat + ((vav + (__alphaav *  10.0)) * __slopegat));
              end
            end
            ijungat = ((((id + isrh) + itat) + ibbt) * fbreakdown);
          end
          __I4 = (((__ABSOURCE_i * ijunbot) + (__LSSOURCE_i * ijunsti)) + (__LGSOURCE_i * ijungat));
          vbbt =  0.0;
          two_psistar =  0.0;
          if ((! (((__ABSOURCE_i ==  0.0) && (__LSSOURCE_i ==  0.0)) && (__LGSOURCE_i ==  0.0)))) begin
            h1 = ((__vch_s *  4.0) * __vch_s);
            h2 = (__vch_s / __vfmin_s);
            h2d = (__V5 + (__vch_s * h2));
            h3 = (__vfmin_s + h2d);
            h4 = (__vfmin_s - h2d);
            h5 = sqrt(((h4 * h4) + h1));
            vj = (((__V5 * __vfmin_s) / (h3 + h5)) *  2.0);
            if ((__V5 < __VMAX_s)) begin
              if ((abs(((__V5 * __phitdinv) *  0.5)) <  230.258509299405)) begin
                zinv = exp(((__V5 * __phitdinv) *  0.5));
              end
              else begin
                if ((((__V5 * __phitdinv) *  0.5) <  0.0)) begin
                  zinv = ( 100.0e-102 / (((-230.258509299405 - ((__V5 * __phitdinv) *  0.5)) * ((((-230.258509299405 - ((__V5 * __phitdinv) *  0.5)) * (((-230.258509299405 - ((__V5 * __phitdinv) *  0.5)) *  0.333333333333333) +  1.0)) *  0.5) +  1.0)) +  1.0));
                end
                else begin
                  zinv = ((((((__V5 * __phitdinv) *  0.5) -  230.258509299405) * ((((((__V5 * __phitdinv) *  0.5) -  230.258509299405) * (((((__V5 * __phitdinv) *  0.5) -  230.258509299405) *  0.333333333333333) +  1.0)) *  0.5) +  1.0)) +  1.0) *  10.0e+99);
                end
              end
              idmult = (zinv * zinv);
            end
            else begin
              idmult = ((((__V5 - __VMAX_s) * __phitdinv) +  1.0) * __exp_VMAX_over_phitd_s);
              zinv = sqrt(idmult);
            end
            idmult = (idmult -  1.0);
            z = ( 1.0 / zinv);
            if ((__V5 >  0.0)) begin
              two_psistar = ((__phitd * ln(((z +  2.0) + sqrt(((z +  1.0) * (z +  3.0)))))) *  2.0);
            end
            else begin
              two_psistar = ((- __V5) + ((__phitd * ln((((zinv *  2.0) +  1.0) + sqrt(((zinv +  1.0) * ((zinv *  3.0) +  1.0)))))) *  2.0));
            end
            vjlim = (__vbimin_s - two_psistar);
            vjsrh = (((__V5 + vjlim) - sqrt((((__V5 - vjlim) * (__V5 - vjlim)) + ((__phitd *  4.0) * __phitd)))) *  0.5);
            vbbt = (((__V5 + __vbbtlim_s) - sqrt((((__V5 - __vbbtlim_s) * (__V5 - __vbbtlim_s)) + ((__phitr *  4.0) * __phitr)))) *  0.5);
            vav = ((__V5 - sqrt(((__V5 * __V5) +  4.0e-12))) *  0.5);
          end
          if ((__ABSOURCE_i ==  0.0)) begin
            ijunbot =  0.0;
            qjunbot =  0.0;
          end
          else begin
            if ((__one_minus_PBOT ==  0.5)) begin
              tmp = sqrt(( 1.0 - (vj * __vbiinvbot)));
            end
            else begin
              tmp = pow(( 1.0 - (vj * __vbiinvbot)), __one_minus_PBOT);
            end
            qjunbot = ((__qprefbot * ( 1.0 - tmp)) + (__qpref2bot * (__V5 - vj)));
            id = (__idsatbot * idmult);
            if (0) begin
            end
            else begin
              vbi_minus_vjsrh = (__vbibot - vjsrh);
              wsrhstep = ( 1.0 - sqrt(( 1.0 - (two_psistar / vbi_minus_vjsrh))));
              if (0) begin
              end
              else begin
                dwsrh = (((((wsrhstep * wsrhstep) * ln(wsrhstep)) / ( 1.0 - wsrhstep)) + wsrhstep) *  0.37382);
              end
              wsrh = (wsrhstep + dwsrh);
              if (0) begin
              end
              else begin
                tmp = pow((vbi_minus_vjsrh * __VBIRBOTinv),  0.31309);
              end
              wdep = (__wdepnulrbot * tmp);
              asrh = (__ftdbot * ((zinv -  1.0) * wdep));
              isrh = ((asrh * wsrh) *  100.0);
            end
            if (0) begin
            end
            else begin
              btat = (__btatpartbot * ((wdep * __one_minus_PBOT) / vbi_minus_vjsrh));
              twoatatoverthreebtat = ((__atatbot *  0.666666666666667) / btat);
              umaxbeforelimiting = (twoatatoverthreebtat * twoatatoverthreebtat);
              umax = sqrt(((umaxbeforelimiting * umaxbeforelimiting) / ((umaxbeforelimiting * umaxbeforelimiting) +  1.0)));
              sqrtumax = sqrt(umax);
              umaxpoweronepointfive = (umax * sqrtumax);
              if (((__one_over_one_minus_PBOT * -0.31309) == -1.0)) begin
                wgamma = ( 1.0 / ((btat * umaxpoweronepointfive) +  1.0));
              end
              else begin
                wgamma = pow(((btat * umaxpoweronepointfive) +  1.0), (__one_over_one_minus_PBOT * -0.31309));
              end
              wtat = ((wsrh * wgamma) / (wsrh + wgamma));
              ktat = sqrt(((btat / sqrtumax) *  0.375));
              ltat = (((twoatatoverthreebtat * sqrtumax) *  2.0) - umax);
              mtat = ((((__atatbot * twoatatoverthreebtat) * sqrtumax) - (__atatbot * umax)) + ((btat * umaxpoweronepointfive) *  0.5));
              xerfc = ((ltat -  1.0) * ktat);
              ysq = (xerfc * xerfc);
              if ((xerfc >  0.0)) begin
                terfc = ( 1.0 / ((__perfc * xerfc) +  1.0));
              end
              else begin
                terfc = ( 1.0 / ( 1.0 - (__perfc * xerfc)));
              end
              if ((((- ysq) + mtat) > -230.258509299405)) begin
                tmp = exp(((- ysq) + mtat));
              end
              else begin
                tmp = ( 100.0e-102 / (((-230.258509299405 - ((- ysq) + mtat)) * ((((-230.258509299405 - ((- ysq) + mtat)) * (((-230.258509299405 - ((- ysq) + mtat)) *  0.333333333333333) +  1.0)) *  0.5) +  1.0)) +  1.0));
              end
              erfcpos = ((((terfc *  0.29214664) + (__berfc * (terfc * terfc))) + (__cerfc * ((terfc * terfc) * terfc))) * tmp);
              if ((xerfc >  0.0)) begin
                erfctimesexpmtat = erfcpos;
              end
              else begin
                if ((mtat > -230.258509299405)) begin
                  tmp = exp(mtat);
                end
                else begin
                  tmp = ( 100.0e-102 / (((-230.258509299405 - mtat) * ((((-230.258509299405 - mtat) * (((-230.258509299405 - mtat) *  0.333333333333333) +  1.0)) *  0.5) +  1.0)) +  1.0));
                end
                erfctimesexpmtat = ((tmp *  2.0) - erfcpos);
              end
              gammamax = (((__atatbot * erfctimesexpmtat) / ktat) *  0.886226925452758);
              itat = (((asrh * gammamax) * wtat) *  100.0);
            end
            if (0) begin
            end
            else begin
              if (0) begin
              end
              else begin
                tmp = pow((( 0.70829 - vbbt) * __VBIRBOTinv),  0.31309);
              end
              Fmaxr = (__one_over_one_minus_PBOT * ((( 0.70829 - vbbt) * __wdepnulrinvbot) / tmp));
              if ((abs(((- __fbbtbot) / Fmaxr)) <  230.258509299405)) begin
                tmp = exp(((- __fbbtbot) / Fmaxr));
              end
              else begin
                if ((((- __fbbtbot) / Fmaxr) <  0.0)) begin
                  tmp = ( 100.0e-102 / (((-230.258509299405 - ((- __fbbtbot) / Fmaxr)) * ((((-230.258509299405 - ((- __fbbtbot) / Fmaxr)) * (((-230.258509299405 - ((- __fbbtbot) / Fmaxr)) *  0.333333333333333) +  1.0)) *  0.5) +  1.0)) +  1.0));
                end
                else begin
                  tmp = ((((((- __fbbtbot) / Fmaxr) -  230.258509299405) * ((((((- __fbbtbot) / Fmaxr) -  230.258509299405) * (((((- __fbbtbot) / Fmaxr) -  230.258509299405) *  0.333333333333333) +  1.0)) *  0.5) +  1.0)) +  1.0) *  10.0e+99);
                end
              end
              ibbt = ((((__V5 * Fmaxr) * Fmaxr) * tmp) *  1.0e-12);
            end
            if (0) begin
            end
            else begin
              if ((vav > ((- __alphaav) *  10.0))) begin
                if (1) begin
                  tmp = ((((vav * __VBRinvbot) * (vav * __VBRinvbot)) * (vav * __VBRinvbot)) * (vav * __VBRinvbot));
                end
                else begin
                end
                fbreakdown = ( 1.0 / ( 1.0 - tmp));
              end
              else begin
                fbreakdown = (__fstopbot + ((vav + (__alphaav *  10.0)) * __slopebot));
              end
            end
            ijunbot = ((((id + isrh) + itat) + ibbt) * fbreakdown);
          end
          if ((__LSSOURCE_i ==  0.0)) begin
            ijunsti =  0.0;
            qjunsti =  0.0;
          end
          else begin
            if ((__one_minus_PSTI ==  0.5)) begin
              tmp = sqrt(( 1.0 - (vj * __vbiinvsti)));
            end
            else begin
              tmp = pow(( 1.0 - (vj * __vbiinvsti)), __one_minus_PSTI);
            end
            qjunsti = ((__qprefsti * ( 1.0 - tmp)) + (__qpref2sti * (__V5 - vj)));
            id = (__idsatsti * idmult);
            if (0) begin
            end
            else begin
              vbi_minus_vjsrh = (__vbisti - vjsrh);
              wsrhstep = ( 1.0 - sqrt(( 1.0 - (two_psistar / vbi_minus_vjsrh))));
              if (0) begin
              end
              else begin
                dwsrh = (((((wsrhstep * wsrhstep) * ln(wsrhstep)) / ( 1.0 - wsrhstep)) + wsrhstep) *  0.45276);
              end
              wsrh = (wsrhstep + dwsrh);
              if (0) begin
              end
              else begin
                tmp = pow((vbi_minus_vjsrh * __VBIRSTIinv),  0.27362);
              end
              wdep = (__wdepnulrsti * tmp);
              asrh = (__ftdsti * ((zinv -  1.0) * wdep));
              isrh = ((asrh * wsrh) *  100.0e-6);
            end
            if (0) begin
            end
            else begin
              btat = (__btatpartsti * ((wdep * __one_minus_PSTI) / vbi_minus_vjsrh));
              twoatatoverthreebtat = ((__atatsti *  0.666666666666667) / btat);
              umaxbeforelimiting = (twoatatoverthreebtat * twoatatoverthreebtat);
              umax = sqrt(((umaxbeforelimiting * umaxbeforelimiting) / ((umaxbeforelimiting * umaxbeforelimiting) +  1.0)));
              sqrtumax = sqrt(umax);
              umaxpoweronepointfive = (umax * sqrtumax);
              if (((__one_over_one_minus_PSTI * -0.27362) == -1.0)) begin
                wgamma = ( 1.0 / ((btat * umaxpoweronepointfive) +  1.0));
              end
              else begin
                wgamma = pow(((btat * umaxpoweronepointfive) +  1.0), (__one_over_one_minus_PSTI * -0.27362));
              end
              wtat = ((wsrh * wgamma) / (wsrh + wgamma));
              ktat = sqrt(((btat / sqrtumax) *  0.375));
              ltat = (((twoatatoverthreebtat * sqrtumax) *  2.0) - umax);
              mtat = ((((__atatsti * twoatatoverthreebtat) * sqrtumax) - (__atatsti * umax)) + ((btat * umaxpoweronepointfive) *  0.5));
              xerfc = ((ltat -  1.0) * ktat);
              ysq = (xerfc * xerfc);
              if ((xerfc >  0.0)) begin
                terfc = ( 1.0 / ((__perfc * xerfc) +  1.0));
              end
              else begin
                terfc = ( 1.0 / ( 1.0 - (__perfc * xerfc)));
              end
              if ((((- ysq) + mtat) > -230.258509299405)) begin
                tmp = exp(((- ysq) + mtat));
              end
              else begin
                tmp = ( 100.0e-102 / (((-230.258509299405 - ((- ysq) + mtat)) * ((((-230.258509299405 - ((- ysq) + mtat)) * (((-230.258509299405 - ((- ysq) + mtat)) *  0.333333333333333) +  1.0)) *  0.5) +  1.0)) +  1.0));
              end
              erfcpos = ((((terfc *  0.29214664) + (__berfc * (terfc * terfc))) + (__cerfc * ((terfc * terfc) * terfc))) * tmp);
              if ((xerfc >  0.0)) begin
                erfctimesexpmtat = erfcpos;
              end
              else begin
                if ((mtat > -230.258509299405)) begin
                  tmp = exp(mtat);
                end
                else begin
                  tmp = ( 100.0e-102 / (((-230.258509299405 - mtat) * ((((-230.258509299405 - mtat) * (((-230.258509299405 - mtat) *  0.333333333333333) +  1.0)) *  0.5) +  1.0)) +  1.0));
                end
                erfctimesexpmtat = ((tmp *  2.0) - erfcpos);
              end
              gammamax = (((__atatsti * erfctimesexpmtat) / ktat) *  0.886226925452758);
              itat = (((asrh * gammamax) * wtat) *  100.0e-6);
            end
            if (0) begin
            end
            else begin
              if (0) begin
              end
              else begin
                tmp = pow((( 0.79368 - vbbt) * __VBIRSTIinv),  0.27362);
              end
              Fmaxr = (__one_over_one_minus_PSTI * ((( 0.79368 - vbbt) * __wdepnulrinvsti) / tmp));
              if ((abs(((- __fbbtsti) / Fmaxr)) <  230.258509299405)) begin
                tmp = exp(((- __fbbtsti) / Fmaxr));
              end
              else begin
                if ((((- __fbbtsti) / Fmaxr) <  0.0)) begin
                  tmp = ( 100.0e-102 / (((-230.258509299405 - ((- __fbbtsti) / Fmaxr)) * ((((-230.258509299405 - ((- __fbbtsti) / Fmaxr)) * (((-230.258509299405 - ((- __fbbtsti) / Fmaxr)) *  0.333333333333333) +  1.0)) *  0.5) +  1.0)) +  1.0));
                end
                else begin
                  tmp = ((((((- __fbbtsti) / Fmaxr) -  230.258509299405) * ((((((- __fbbtsti) / Fmaxr) -  230.258509299405) * (((((- __fbbtsti) / Fmaxr) -  230.258509299405) *  0.333333333333333) +  1.0)) *  0.5) +  1.0)) +  1.0) *  10.0e+99);
                end
              end
              ibbt = ((((__V5 * Fmaxr) * Fmaxr) * tmp) *  1.0e-21);
            end
            if (0) begin
            end
            else begin
              if ((vav > ((- __alphaav) *  10.0))) begin
                if (1) begin
                  tmp = ((((vav * __VBRinvsti) * (vav * __VBRinvsti)) * (vav * __VBRinvsti)) * (vav * __VBRinvsti));
                end
                else begin
                end
                fbreakdown = ( 1.0 / ( 1.0 - tmp));
              end
              else begin
                fbreakdown = (__fstopsti + ((vav + (__alphaav *  10.0)) * __slopesti));
              end
            end
            ijunsti = ((((id + isrh) + itat) + ibbt) * fbreakdown);
          end
          if ((__LGSOURCE_i ==  0.0)) begin
            ijungat =  0.0;
            qjungat =  0.0;
          end
          else begin
            if ((__one_minus_PGAT ==  0.5)) begin
              tmp = sqrt(( 1.0 - (vj * __vbiinvgat)));
            end
            else begin
              tmp = pow(( 1.0 - (vj * __vbiinvgat)), __one_minus_PGAT);
            end
            qjungat = ((__qprefgat * ( 1.0 - tmp)) + (__qpref2gat * (__V5 - vj)));
            id = (__idsatgat * idmult);
            if (0) begin
            end
            else begin
              vbi_minus_vjsrh = (__vbigat - vjsrh);
              wsrhstep = ( 1.0 - sqrt(( 1.0 - (two_psistar / vbi_minus_vjsrh))));
              if (0) begin
              end
              else begin
                dwsrh = (((((wsrhstep * wsrhstep) * ln(wsrhstep)) / ( 1.0 - wsrhstep)) + wsrhstep) * -0.0848);
              end
              wsrh = (wsrhstep + dwsrh);
              if (0) begin
              end
              else begin
                tmp = pow((vbi_minus_vjsrh * __VBIRGATinv),  0.5424);
              end
              wdep = (__wdepnulrgat * tmp);
              asrh = (__ftdgat * ((zinv -  1.0) * wdep));
              isrh = ((asrh * wsrh) *  6.682e-6);
            end
            if (0) begin
            end
            else begin
              btat = (__btatpartgat * ((wdep * __one_minus_PGAT) / vbi_minus_vjsrh));
              twoatatoverthreebtat = ((__atatgat *  0.666666666666667) / btat);
              umaxbeforelimiting = (twoatatoverthreebtat * twoatatoverthreebtat);
              umax = sqrt(((umaxbeforelimiting * umaxbeforelimiting) / ((umaxbeforelimiting * umaxbeforelimiting) +  1.0)));
              sqrtumax = sqrt(umax);
              umaxpoweronepointfive = (umax * sqrtumax);
              if (((__one_over_one_minus_PGAT * -0.5424) == -1.0)) begin
                wgamma = ( 1.0 / ((btat * umaxpoweronepointfive) +  1.0));
              end
              else begin
                wgamma = pow(((btat * umaxpoweronepointfive) +  1.0), (__one_over_one_minus_PGAT * -0.5424));
              end
              wtat = ((wsrh * wgamma) / (wsrh + wgamma));
              ktat = sqrt(((btat / sqrtumax) *  0.375));
              ltat = (((twoatatoverthreebtat * sqrtumax) *  2.0) - umax);
              mtat = ((((__atatgat * twoatatoverthreebtat) * sqrtumax) - (__atatgat * umax)) + ((btat * umaxpoweronepointfive) *  0.5));
              xerfc = ((ltat -  1.0) * ktat);
              ysq = (xerfc * xerfc);
              if ((xerfc >  0.0)) begin
                terfc = ( 1.0 / ((__perfc * xerfc) +  1.0));
              end
              else begin
                terfc = ( 1.0 / ( 1.0 - (__perfc * xerfc)));
              end
              if ((((- ysq) + mtat) > -230.258509299405)) begin
                tmp = exp(((- ysq) + mtat));
              end
              else begin
                tmp = ( 100.0e-102 / (((-230.258509299405 - ((- ysq) + mtat)) * ((((-230.258509299405 - ((- ysq) + mtat)) * (((-230.258509299405 - ((- ysq) + mtat)) *  0.333333333333333) +  1.0)) *  0.5) +  1.0)) +  1.0));
              end
              erfcpos = ((((terfc *  0.29214664) + (__berfc * (terfc * terfc))) + (__cerfc * ((terfc * terfc) * terfc))) * tmp);
              if ((xerfc >  0.0)) begin
                erfctimesexpmtat = erfcpos;
              end
              else begin
                if ((mtat > -230.258509299405)) begin
                  tmp = exp(mtat);
                end
                else begin
                  tmp = ( 100.0e-102 / (((-230.258509299405 - mtat) * ((((-230.258509299405 - mtat) * (((-230.258509299405 - mtat) *  0.333333333333333) +  1.0)) *  0.5) +  1.0)) +  1.0));
                end
                erfctimesexpmtat = ((tmp *  2.0) - erfcpos);
              end
              gammamax = (((__atatgat * erfctimesexpmtat) / ktat) *  0.886226925452758);
              itat = (((asrh * gammamax) * wtat) *  100.0e-6);
            end
            if (0) begin
            end
            else begin
              if (0) begin
              end
              else begin
                tmp = pow((( 2.0 - vbbt) * __VBIRGATinv),  0.5424);
              end
              Fmaxr = (__one_over_one_minus_PGAT * ((( 2.0 - vbbt) * __wdepnulrinvgat) / tmp));
              if ((abs(((- __fbbtgat) / Fmaxr)) <  230.258509299405)) begin
                tmp = exp(((- __fbbtgat) / Fmaxr));
              end
              else begin
                if ((((- __fbbtgat) / Fmaxr) <  0.0)) begin
                  tmp = ( 100.0e-102 / (((-230.258509299405 - ((- __fbbtgat) / Fmaxr)) * ((((-230.258509299405 - ((- __fbbtgat) / Fmaxr)) * (((-230.258509299405 - ((- __fbbtgat) / Fmaxr)) *  0.333333333333333) +  1.0)) *  0.5) +  1.0)) +  1.0));
                end
                else begin
                  tmp = ((((((- __fbbtgat) / Fmaxr) -  230.258509299405) * ((((((- __fbbtgat) / Fmaxr) -  230.258509299405) * (((((- __fbbtgat) / Fmaxr) -  230.258509299405) *  0.333333333333333) +  1.0)) *  0.5) +  1.0)) +  1.0) *  10.0e+99);
                end
              end
              ibbt = ((((__V5 * Fmaxr) * Fmaxr) * tmp) *  1.0e-18);
            end
            if (0) begin
            end
            else begin
              if ((vav > ((- __alphaav) *  10.0))) begin
                if (1) begin
                  tmp = ((((vav * __VBRinvgat) * (vav * __VBRinvgat)) * (vav * __VBRinvgat)) * (vav * __VBRinvgat));
                end
                else begin
                end
                fbreakdown = ( 1.0 / ( 1.0 - tmp));
              end
              else begin
                fbreakdown = (__fstopgat + ((vav + (__alphaav *  10.0)) * __slopegat));
              end
            end
            ijungat = ((((id + isrh) + itat) + ibbt) * fbreakdown);
          end
          __I5 = (((__ABSOURCE_i * ijunbot) + (__LSSOURCE_i * ijunsti)) + (__LGSOURCE_i * ijungat));
          __ISATFOR1_s = (((__ABSOURCE_i * __idsatbot) + (__LSSOURCE_i * __idsatsti)) + (__LGSOURCE_i * __idsatgat));
          __I4_cor = (__I4 - (__ISATFOR1_s * (exp(((__V4 * __phitdinv) * __MFOR1_s)) -  1.0)));
          __I5_cor = (__I5 - (__ISATFOR1_s * (exp(((__V5 * __phitdinv) * __MFOR1_s)) -  1.0)));
          if ((! (((__ABSOURCE_i ==  0.0) && (__LSSOURCE_i ==  0.0)) && (__LGSOURCE_i ==  0.0)))) begin
            if (((__I4 >  0.0) && (__I5 >  0.0))) begin
              if (((((((__I4_cor / __I4) >  0.001) || ((__I5_cor / __I5) >  0.001)) && (__I4_cor >  0.0)) && (__I5_cor >  0.0)) && (__I5_cor > __I4_cor))) begin
                __alphaje = (__I4_cor / __I5_cor);
                __MFOR2_s = ((__phitd * ln(__alphaje)) / (__V4 - __V5));
                __ISATFOR2_s = (__I4_cor / (exp(((__V4 * __phitdinv) * __MFOR2_s)) -  1.0));
              end
            end
            __I1_cor = ((__I1 - (__ISATFOR1_s * (exp(((__V1 * __phitdinv) * __MFOR1_s)) -  1.0))) - (__ISATFOR2_s * (exp(((__V1 * __phitdinv) * __MFOR2_s)) -  1.0)));
            __I2_cor = ((__I2 - (__ISATFOR1_s * (exp(((__V2 * __phitdinv) * __MFOR1_s)) -  1.0))) - (__ISATFOR2_s * (exp(((__V2 * __phitdinv) * __MFOR2_s)) -  1.0)));
            __I3_cor = ((__I3 - (__ISATFOR1_s * (exp(((__V3 * __phitdinv) * __MFOR1_s)) -  1.0))) - (__ISATFOR2_s * (exp(((__V3 * __phitdinv) * __MFOR2_s)) -  1.0)));
            if ((((__I1 <  0.0) && (__I2 <  0.0)) && (__I3 <  0.0))) begin
              if ((((((((__I1_cor / __I1) >  0.001) || ((__I2_cor / __I2) >  0.001)) || ((__I3_cor / __I3) >  0.001)) && (__I1_cor <  0.0)) && (__I2_cor <  0.0)) && (__I3_cor <  0.0))) begin
                __alphaje = (__I1_cor / __I2_cor);
                __m0_rev = (((- __phitd) * ln(__alphaje)) / (__V1 - __V2));
                __tt0 = (__V2 / (__V2 - __V1));
                __tt1 = ((__phitd * (__alphaje -  1.0)) * (pow(__alphaje, __tt0) -  1.0));
                __tt0 = (__V1 / (__V1 - __V2));
                __tt2 = (((pow(__alphaje, __tt0) * (__V2 - __V1)) + (__alphaje * __V1)) - __V2);
                __mcor_rev = (__tt1 / __tt2);
                __MREV_s = (__m0_rev + __mcor_rev);
                if ((abs(((__V3 * __phitdinv) * __MREV_s)) <  1.0e-6)) begin
                  __m0flag_s =  1.0;
                  __ISATREV_s = (__I3_cor * (( 1.0 / __V3) + ((__phitdinv *  0.5) * __MREV_s)));
                  __MREV_s = ((((__I3_cor * -0.5) * __MREV_s) * __phitdinv) / __V3);
                end
                else begin
                  __m0flag_s =  0.0;
                  __ISATREV_s = ((- __I3_cor) / (exp((((- __V3) * __phitdinv) * __MREV_s)) -  1.0));
                end
              end
            end
          end
          __zfrac = ((((__ABSOURCE_i * __cjobot) + (__LSSOURCE_i * __cjosti)) + (__LGSOURCE_i * __cjogat)) *  0.03);
          if (((__ABSOURCE_i * __cjobot) <= __zfrac)) begin
            __zflagbot_s =  0.0;
          end
          if (((__LSSOURCE_i * __cjosti) <= __zfrac)) begin
            __zflagsti_s =  0.0;
          end
          if (((__LGSOURCE_i * __cjogat) <= __zfrac)) begin
            __zflaggat_s =  0.0;
          end
          if ((! (((__ABSOURCE_i ==  0.0) && (__LSSOURCE_i ==  0.0)) && (__LGSOURCE_i ==  0.0)))) begin
            __xhighf1_s = ln(( 767.9e-6 / (__ISATFOR1_s +  1.0e-21)));
            __xhighf2_s = ln(( 767.9e-6 / (__ISATFOR2_s +  1.0e-21)));
            __xhighr_s = ln(( 767.9e-6 / (abs(__ISATREV_s) +  1.0e-21)));
          end
          __xhighf1_s = min(__xhighf1_s,  230.258509299405);
          __expxhf1_s = exp(__xhighf1_s);
          __xhighf2_s = min(__xhighf2_s,  230.258509299405);
          __expxhf2_s = exp(__xhighf2_s);
          __xhighr_s = min(__xhighr_s,  230.258509299405);
          __expxhr_s = exp(__xhighr_s);
          __FRACNA =  0.4;
          __FRACNB =  0.65;
          __FRACI =  0.8;
          __V1 = ((- __FRACNA) * __VJUNREFD_i);
          __V2 = ((- __FRACNB) * __VJUNREFD_i);
          __V3 = ((- __FRACI) * __VJUNREFD_i);
          __V4 =  0.1;
          __V5 =  0.2;
          vbbt =  0.0;
          two_psistar =  0.0;
          if ((! (((__ABDRAIN_i ==  0.0) && (__LSDRAIN_i ==  0.0)) && (__LGDRAIN_i ==  0.0)))) begin
            h1 = ((__vch_d *  4.0) * __vch_d);
            h2 = (__vch_d / __vfmin_d);
            h2d = (__V1 + (__vch_d * h2));
            h3 = (__vfmin_d + h2d);
            h4 = (__vfmin_d - h2d);
            h5 = sqrt(((h4 * h4) + h1));
            vj = (((__V1 * __vfmin_d) / (h3 + h5)) *  2.0);
            if ((__V1 < __VMAX_d)) begin
              if ((abs(((__V1 * __phitdinv) *  0.5)) <  230.258509299405)) begin
                zinv = exp(((__V1 * __phitdinv) *  0.5));
              end
              else begin
                if ((((__V1 * __phitdinv) *  0.5) <  0.0)) begin
                  zinv = ( 100.0e-102 / (((-230.258509299405 - ((__V1 * __phitdinv) *  0.5)) * ((((-230.258509299405 - ((__V1 * __phitdinv) *  0.5)) * (((-230.258509299405 - ((__V1 * __phitdinv) *  0.5)) *  0.333333333333333) +  1.0)) *  0.5) +  1.0)) +  1.0));
                end
                else begin
                  zinv = ((((((__V1 * __phitdinv) *  0.5) -  230.258509299405) * ((((((__V1 * __phitdinv) *  0.5) -  230.258509299405) * (((((__V1 * __phitdinv) *  0.5) -  230.258509299405) *  0.333333333333333) +  1.0)) *  0.5) +  1.0)) +  1.0) *  10.0e+99);
                end
              end
              idmult = (zinv * zinv);
            end
            else begin
              idmult = ((((__V1 - __VMAX_d) * __phitdinv) +  1.0) * __exp_VMAX_over_phitd_d);
              zinv = sqrt(idmult);
            end
            idmult = (idmult -  1.0);
            z = ( 1.0 / zinv);
            if ((__V1 >  0.0)) begin
              two_psistar = ((__phitd * ln(((z +  2.0) + sqrt(((z +  1.0) * (z +  3.0)))))) *  2.0);
            end
            else begin
              two_psistar = ((- __V1) + ((__phitd * ln((((zinv *  2.0) +  1.0) + sqrt(((zinv +  1.0) * ((zinv *  3.0) +  1.0)))))) *  2.0));
            end
            vjlim = (__vbimin_d - two_psistar);
            vjsrh = (((__V1 + vjlim) - sqrt((((__V1 - vjlim) * (__V1 - vjlim)) + ((__phitd *  4.0) * __phitd)))) *  0.5);
            vbbt = (((__V1 + __vbbtlim_d) - sqrt((((__V1 - __vbbtlim_d) * (__V1 - __vbbtlim_d)) + ((__phitr *  4.0) * __phitr)))) *  0.5);
            vav = ((__V1 - sqrt(((__V1 * __V1) +  4.0e-12))) *  0.5);
          end
          if ((__ABDRAIN_i ==  0.0)) begin
            ijunbot =  0.0;
            qjunbot =  0.0;
          end
          else begin
            if ((__one_minus_PBOT_d ==  0.5)) begin
              tmp = sqrt(( 1.0 - (vj * __vbiinvbot_d)));
            end
            else begin
              tmp = pow(( 1.0 - (vj * __vbiinvbot_d)), __one_minus_PBOT_d);
            end
            qjunbot = ((__qprefbot_d * ( 1.0 - tmp)) + (__qpref2bot_d * (__V1 - vj)));
            id = (__idsatbot_d * idmult);
            if (((__CSRHBOTD_i ==  0.0) && (__CTATBOTD_i ==  0.0))) begin
              isrh =  0.0;
            end
            else begin
              vbi_minus_vjsrh = (__vbibot_d - vjsrh);
              wsrhstep = ( 1.0 - sqrt(( 1.0 - (two_psistar / vbi_minus_vjsrh))));
              if ((__PBOTD_i ==  0.5)) begin
                dwsrh =  0.0;
              end
              else begin
                dwsrh = (((((wsrhstep * wsrhstep) * ln(wsrhstep)) / ( 1.0 - wsrhstep)) + wsrhstep) * ( 1.0 - (__PBOTD_i *  2.0)));
              end
              wsrh = (wsrhstep + dwsrh);
              if ((__PBOTD_i ==  0.5)) begin
                tmp = sqrt((vbi_minus_vjsrh * __VBIRBOTinv_d));
              end
              else begin
                tmp = pow((vbi_minus_vjsrh * __VBIRBOTinv_d), __PBOTD_i);
              end
              wdep = (__wdepnulrbot_d * tmp);
              asrh = (__ftdbot_d * ((zinv -  1.0) * wdep));
              isrh = (__CSRHBOTD_i * (asrh * wsrh));
            end
            if ((__CTATBOTD_i ==  0.0)) begin
              itat =  0.0;
            end
            else begin
              btat = (__btatpartbot_d * ((wdep * __one_minus_PBOT_d) / vbi_minus_vjsrh));
              twoatatoverthreebtat = ((__atatbot_d *  0.666666666666667) / btat);
              umaxbeforelimiting = (twoatatoverthreebtat * twoatatoverthreebtat);
              umax = sqrt(((umaxbeforelimiting * umaxbeforelimiting) / ((umaxbeforelimiting * umaxbeforelimiting) +  1.0)));
              sqrtumax = sqrt(umax);
              umaxpoweronepointfive = (umax * sqrtumax);
              if ((((- __PBOTD_i) * __one_over_one_minus_PBOT_d) == -1.0)) begin
                wgamma = ( 1.0 / ((btat * umaxpoweronepointfive) +  1.0));
              end
              else begin
                wgamma = pow(((btat * umaxpoweronepointfive) +  1.0), ((- __PBOTD_i) * __one_over_one_minus_PBOT_d));
              end
              wtat = ((wsrh * wgamma) / (wsrh + wgamma));
              ktat = sqrt(((btat / sqrtumax) *  0.375));
              ltat = (((twoatatoverthreebtat * sqrtumax) *  2.0) - umax);
              mtat = ((((__atatbot_d * twoatatoverthreebtat) * sqrtumax) - (__atatbot_d * umax)) + ((btat * umaxpoweronepointfive) *  0.5));
              xerfc = ((ltat -  1.0) * ktat);
              ysq = (xerfc * xerfc);
              if ((xerfc >  0.0)) begin
                terfc = ( 1.0 / ((__perfc * xerfc) +  1.0));
              end
              else begin
                terfc = ( 1.0 / ( 1.0 - (__perfc * xerfc)));
              end
              if ((((- ysq) + mtat) > -230.258509299405)) begin
                tmp = exp(((- ysq) + mtat));
              end
              else begin
                tmp = ( 100.0e-102 / (((-230.258509299405 - ((- ysq) + mtat)) * ((((-230.258509299405 - ((- ysq) + mtat)) * (((-230.258509299405 - ((- ysq) + mtat)) *  0.333333333333333) +  1.0)) *  0.5) +  1.0)) +  1.0));
              end
              erfcpos = ((((terfc *  0.29214664) + (__berfc * (terfc * terfc))) + (__cerfc * ((terfc * terfc) * terfc))) * tmp);
              if ((xerfc >  0.0)) begin
                erfctimesexpmtat = erfcpos;
              end
              else begin
                if ((mtat > -230.258509299405)) begin
                  tmp = exp(mtat);
                end
                else begin
                  tmp = ( 100.0e-102 / (((-230.258509299405 - mtat) * ((((-230.258509299405 - mtat) * (((-230.258509299405 - mtat) *  0.333333333333333) +  1.0)) *  0.5) +  1.0)) +  1.0));
                end
                erfctimesexpmtat = ((tmp *  2.0) - erfcpos);
              end
              gammamax = (((__atatbot_d * erfctimesexpmtat) / ktat) *  0.886226925452758);
              itat = (__CTATBOTD_i * ((asrh * gammamax) * wtat));
            end
            if ((__CBBTBOTD_i ==  0.0)) begin
              ibbt =  0.0;
            end
            else begin
              if ((__PBOTD_i ==  0.5)) begin
                tmp = sqrt(((__VBIRBOTD_i - vbbt) * __VBIRBOTinv_d));
              end
              else begin
                tmp = pow(((__VBIRBOTD_i - vbbt) * __VBIRBOTinv_d), __PBOTD_i);
              end
              Fmaxr = (__one_over_one_minus_PBOT_d * (((__VBIRBOTD_i - vbbt) * __wdepnulrinvbot_d) / tmp));
              if ((abs(((- __fbbtbot_d) / Fmaxr)) <  230.258509299405)) begin
                tmp = exp(((- __fbbtbot_d) / Fmaxr));
              end
              else begin
                if ((((- __fbbtbot_d) / Fmaxr) <  0.0)) begin
                  tmp = ( 100.0e-102 / (((-230.258509299405 - ((- __fbbtbot_d) / Fmaxr)) * ((((-230.258509299405 - ((- __fbbtbot_d) / Fmaxr)) * (((-230.258509299405 - ((- __fbbtbot_d) / Fmaxr)) *  0.333333333333333) +  1.0)) *  0.5) +  1.0)) +  1.0));
                end
                else begin
                  tmp = ((((((- __fbbtbot_d) / Fmaxr) -  230.258509299405) * ((((((- __fbbtbot_d) / Fmaxr) -  230.258509299405) * (((((- __fbbtbot_d) / Fmaxr) -  230.258509299405) *  0.333333333333333) +  1.0)) *  0.5) +  1.0)) +  1.0) *  10.0e+99);
                end
              end
              ibbt = (__CBBTBOTD_i * (((__V1 * Fmaxr) * Fmaxr) * tmp));
            end
            if ((__VBRBOTD_i >  1.0e+3)) begin
              fbreakdown =  1.0;
            end
            else begin
              if ((vav > ((- __alphaav) * __VBRBOTD_i))) begin
                if ((__PBRBOTD_i ==  4.0)) begin
                  tmp = ((((vav * __VBRinvbot_d) * (vav * __VBRinvbot_d)) * (vav * __VBRinvbot_d)) * (vav * __VBRinvbot_d));
                end
                else begin
                  tmp = pow(abs((vav * __VBRinvbot_d)), __PBRBOTD_i);
                end
                fbreakdown = ( 1.0 / ( 1.0 - tmp));
              end
              else begin
                fbreakdown = (__fstopbot_d + ((vav + (__alphaav * __VBRBOTD_i)) * __slopebot_d));
              end
            end
            ijunbot = ((((id + isrh) + itat) + ibbt) * fbreakdown);
          end
          if ((__LSDRAIN_i ==  0.0)) begin
            ijunsti =  0.0;
            qjunsti =  0.0;
          end
          else begin
            if ((__one_minus_PSTI_d ==  0.5)) begin
              tmp = sqrt(( 1.0 - (vj * __vbiinvsti_d)));
            end
            else begin
              tmp = pow(( 1.0 - (vj * __vbiinvsti_d)), __one_minus_PSTI_d);
            end
            qjunsti = ((__qprefsti_d * ( 1.0 - tmp)) + (__qpref2sti_d * (__V1 - vj)));
            id = (__idsatsti_d * idmult);
            if (((__CSRHSTID_i ==  0.0) && (__CTATSTID_i ==  0.0))) begin
              isrh =  0.0;
            end
            else begin
              vbi_minus_vjsrh = (__vbisti_d - vjsrh);
              wsrhstep = ( 1.0 - sqrt(( 1.0 - (two_psistar / vbi_minus_vjsrh))));
              if ((__PSTID_i ==  0.5)) begin
                dwsrh =  0.0;
              end
              else begin
                dwsrh = (((((wsrhstep * wsrhstep) * ln(wsrhstep)) / ( 1.0 - wsrhstep)) + wsrhstep) * ( 1.0 - (__PSTID_i *  2.0)));
              end
              wsrh = (wsrhstep + dwsrh);
              if ((__PSTID_i ==  0.5)) begin
                tmp = sqrt((vbi_minus_vjsrh * __VBIRSTIinv_d));
              end
              else begin
                tmp = pow((vbi_minus_vjsrh * __VBIRSTIinv_d), __PSTID_i);
              end
              wdep = (__wdepnulrsti_d * tmp);
              asrh = (__ftdsti_d * ((zinv -  1.0) * wdep));
              isrh = (__CSRHSTID_i * (asrh * wsrh));
            end
            if ((__CTATSTID_i ==  0.0)) begin
              itat =  0.0;
            end
            else begin
              btat = (__btatpartsti_d * ((wdep * __one_minus_PSTI_d) / vbi_minus_vjsrh));
              twoatatoverthreebtat = ((__atatsti_d *  0.666666666666667) / btat);
              umaxbeforelimiting = (twoatatoverthreebtat * twoatatoverthreebtat);
              umax = sqrt(((umaxbeforelimiting * umaxbeforelimiting) / ((umaxbeforelimiting * umaxbeforelimiting) +  1.0)));
              sqrtumax = sqrt(umax);
              umaxpoweronepointfive = (umax * sqrtumax);
              if ((((- __PSTID_i) * __one_over_one_minus_PSTI_d) == -1.0)) begin
                wgamma = ( 1.0 / ((btat * umaxpoweronepointfive) +  1.0));
              end
              else begin
                wgamma = pow(((btat * umaxpoweronepointfive) +  1.0), ((- __PSTID_i) * __one_over_one_minus_PSTI_d));
              end
              wtat = ((wsrh * wgamma) / (wsrh + wgamma));
              ktat = sqrt(((btat / sqrtumax) *  0.375));
              ltat = (((twoatatoverthreebtat * sqrtumax) *  2.0) - umax);
              mtat = ((((__atatsti_d * twoatatoverthreebtat) * sqrtumax) - (__atatsti_d * umax)) + ((btat * umaxpoweronepointfive) *  0.5));
              xerfc = ((ltat -  1.0) * ktat);
              ysq = (xerfc * xerfc);
              if ((xerfc >  0.0)) begin
                terfc = ( 1.0 / ((__perfc * xerfc) +  1.0));
              end
              else begin
                terfc = ( 1.0 / ( 1.0 - (__perfc * xerfc)));
              end
              if ((((- ysq) + mtat) > -230.258509299405)) begin
                tmp = exp(((- ysq) + mtat));
              end
              else begin
                tmp = ( 100.0e-102 / (((-230.258509299405 - ((- ysq) + mtat)) * ((((-230.258509299405 - ((- ysq) + mtat)) * (((-230.258509299405 - ((- ysq) + mtat)) *  0.333333333333333) +  1.0)) *  0.5) +  1.0)) +  1.0));
              end
              erfcpos = ((((terfc *  0.29214664) + (__berfc * (terfc * terfc))) + (__cerfc * ((terfc * terfc) * terfc))) * tmp);
              if ((xerfc >  0.0)) begin
                erfctimesexpmtat = erfcpos;
              end
              else begin
                if ((mtat > -230.258509299405)) begin
                  tmp = exp(mtat);
                end
                else begin
                  tmp = ( 100.0e-102 / (((-230.258509299405 - mtat) * ((((-230.258509299405 - mtat) * (((-230.258509299405 - mtat) *  0.333333333333333) +  1.0)) *  0.5) +  1.0)) +  1.0));
                end
                erfctimesexpmtat = ((tmp *  2.0) - erfcpos);
              end
              gammamax = (((__atatsti_d * erfctimesexpmtat) / ktat) *  0.886226925452758);
              itat = (__CTATSTID_i * ((asrh * gammamax) * wtat));
            end
            if ((__CBBTSTID_i ==  0.0)) begin
              ibbt =  0.0;
            end
            else begin
              if ((__PSTID_i ==  0.5)) begin
                tmp = sqrt(((__VBIRSTID_i - vbbt) * __VBIRSTIinv_d));
              end
              else begin
                tmp = pow(((__VBIRSTID_i - vbbt) * __VBIRSTIinv_d), __PSTID_i);
              end
              Fmaxr = (__one_over_one_minus_PSTI_d * (((__VBIRSTID_i - vbbt) * __wdepnulrinvsti_d) / tmp));
              if ((abs(((- __fbbtsti_d) / Fmaxr)) <  230.258509299405)) begin
                tmp = exp(((- __fbbtsti_d) / Fmaxr));
              end
              else begin
                if ((((- __fbbtsti_d) / Fmaxr) <  0.0)) begin
                  tmp = ( 100.0e-102 / (((-230.258509299405 - ((- __fbbtsti_d) / Fmaxr)) * ((((-230.258509299405 - ((- __fbbtsti_d) / Fmaxr)) * (((-230.258509299405 - ((- __fbbtsti_d) / Fmaxr)) *  0.333333333333333) +  1.0)) *  0.5) +  1.0)) +  1.0));
                end
                else begin
                  tmp = ((((((- __fbbtsti_d) / Fmaxr) -  230.258509299405) * ((((((- __fbbtsti_d) / Fmaxr) -  230.258509299405) * (((((- __fbbtsti_d) / Fmaxr) -  230.258509299405) *  0.333333333333333) +  1.0)) *  0.5) +  1.0)) +  1.0) *  10.0e+99);
                end
              end
              ibbt = (__CBBTSTID_i * (((__V1 * Fmaxr) * Fmaxr) * tmp));
            end
            if ((__VBRSTID_i >  1.0e+3)) begin
              fbreakdown =  1.0;
            end
            else begin
              if ((vav > ((- __alphaav) * __VBRSTID_i))) begin
                if ((__PBRSTID_i ==  4.0)) begin
                  tmp = ((((vav * __VBRinvsti_d) * (vav * __VBRinvsti_d)) * (vav * __VBRinvsti_d)) * (vav * __VBRinvsti_d));
                end
                else begin
                  tmp = pow(abs((vav * __VBRinvsti_d)), __PBRSTID_i);
                end
                fbreakdown = ( 1.0 / ( 1.0 - tmp));
              end
              else begin
                fbreakdown = (__fstopsti_d + ((vav + (__alphaav * __VBRSTID_i)) * __slopesti_d));
              end
            end
            ijunsti = ((((id + isrh) + itat) + ibbt) * fbreakdown);
          end
          if ((__LGDRAIN_i ==  0.0)) begin
            ijungat =  0.0;
            qjungat =  0.0;
          end
          else begin
            if ((__one_minus_PGAT_d ==  0.5)) begin
              tmp = sqrt(( 1.0 - (vj * __vbiinvgat_d)));
            end
            else begin
              tmp = pow(( 1.0 - (vj * __vbiinvgat_d)), __one_minus_PGAT_d);
            end
            qjungat = ((__qprefgat_d * ( 1.0 - tmp)) + (__qpref2gat_d * (__V1 - vj)));
            id = (__idsatgat_d * idmult);
            if (((__CSRHGATD_i ==  0.0) && (__CTATGATD_i ==  0.0))) begin
              isrh =  0.0;
            end
            else begin
              vbi_minus_vjsrh = (__vbigat_d - vjsrh);
              wsrhstep = ( 1.0 - sqrt(( 1.0 - (two_psistar / vbi_minus_vjsrh))));
              if ((__PGATD_i ==  0.5)) begin
                dwsrh =  0.0;
              end
              else begin
                dwsrh = (((((wsrhstep * wsrhstep) * ln(wsrhstep)) / ( 1.0 - wsrhstep)) + wsrhstep) * ( 1.0 - (__PGATD_i *  2.0)));
              end
              wsrh = (wsrhstep + dwsrh);
              if ((__PGATD_i ==  0.5)) begin
                tmp = sqrt((vbi_minus_vjsrh * __VBIRGATinv_d));
              end
              else begin
                tmp = pow((vbi_minus_vjsrh * __VBIRGATinv_d), __PGATD_i);
              end
              wdep = (__wdepnulrgat_d * tmp);
              asrh = (__ftdgat_d * ((zinv -  1.0) * wdep));
              isrh = (__CSRHGATD_i * (asrh * wsrh));
            end
            if ((__CTATGATD_i ==  0.0)) begin
              itat =  0.0;
            end
            else begin
              btat = (__btatpartgat_d * ((wdep * __one_minus_PGAT_d) / vbi_minus_vjsrh));
              twoatatoverthreebtat = ((__atatgat_d *  0.666666666666667) / btat);
              umaxbeforelimiting = (twoatatoverthreebtat * twoatatoverthreebtat);
              umax = sqrt(((umaxbeforelimiting * umaxbeforelimiting) / ((umaxbeforelimiting * umaxbeforelimiting) +  1.0)));
              sqrtumax = sqrt(umax);
              umaxpoweronepointfive = (umax * sqrtumax);
              if ((((- __PGATD_i) * __one_over_one_minus_PGAT_d) == -1.0)) begin
                wgamma = ( 1.0 / ((btat * umaxpoweronepointfive) +  1.0));
              end
              else begin
                wgamma = pow(((btat * umaxpoweronepointfive) +  1.0), ((- __PGATD_i) * __one_over_one_minus_PGAT_d));
              end
              wtat = ((wsrh * wgamma) / (wsrh + wgamma));
              ktat = sqrt(((btat / sqrtumax) *  0.375));
              ltat = (((twoatatoverthreebtat * sqrtumax) *  2.0) - umax);
              mtat = ((((__atatgat_d * twoatatoverthreebtat) * sqrtumax) - (__atatgat_d * umax)) + ((btat * umaxpoweronepointfive) *  0.5));
              xerfc = ((ltat -  1.0) * ktat);
              ysq = (xerfc * xerfc);
              if ((xerfc >  0.0)) begin
                terfc = ( 1.0 / ((__perfc * xerfc) +  1.0));
              end
              else begin
                terfc = ( 1.0 / ( 1.0 - (__perfc * xerfc)));
              end
              if ((((- ysq) + mtat) > -230.258509299405)) begin
                tmp = exp(((- ysq) + mtat));
              end
              else begin
                tmp = ( 100.0e-102 / (((-230.258509299405 - ((- ysq) + mtat)) * ((((-230.258509299405 - ((- ysq) + mtat)) * (((-230.258509299405 - ((- ysq) + mtat)) *  0.333333333333333) +  1.0)) *  0.5) +  1.0)) +  1.0));
              end
              erfcpos = ((((terfc *  0.29214664) + (__berfc * (terfc * terfc))) + (__cerfc * ((terfc * terfc) * terfc))) * tmp);
              if ((xerfc >  0.0)) begin
                erfctimesexpmtat = erfcpos;
              end
              else begin
                if ((mtat > -230.258509299405)) begin
                  tmp = exp(mtat);
                end
                else begin
                  tmp = ( 100.0e-102 / (((-230.258509299405 - mtat) * ((((-230.258509299405 - mtat) * (((-230.258509299405 - mtat) *  0.333333333333333) +  1.0)) *  0.5) +  1.0)) +  1.0));
                end
                erfctimesexpmtat = ((tmp *  2.0) - erfcpos);
              end
              gammamax = (((__atatgat_d * erfctimesexpmtat) / ktat) *  0.886226925452758);
              itat = (__CTATGATD_i * ((asrh * gammamax) * wtat));
            end
            if ((__CBBTGATD_i ==  0.0)) begin
              ibbt =  0.0;
            end
            else begin
              if ((__PGATD_i ==  0.5)) begin
                tmp = sqrt(((__VBIRGATD_i - vbbt) * __VBIRGATinv_d));
              end
              else begin
                tmp = pow(((__VBIRGATD_i - vbbt) * __VBIRGATinv_d), __PGATD_i);
              end
              Fmaxr = (__one_over_one_minus_PGAT_d * (((__VBIRGATD_i - vbbt) * __wdepnulrinvgat_d) / tmp));
              if ((abs(((- __fbbtgat_d) / Fmaxr)) <  230.258509299405)) begin
                tmp = exp(((- __fbbtgat_d) / Fmaxr));
              end
              else begin
                if ((((- __fbbtgat_d) / Fmaxr) <  0.0)) begin
                  tmp = ( 100.0e-102 / (((-230.258509299405 - ((- __fbbtgat_d) / Fmaxr)) * ((((-230.258509299405 - ((- __fbbtgat_d) / Fmaxr)) * (((-230.258509299405 - ((- __fbbtgat_d) / Fmaxr)) *  0.333333333333333) +  1.0)) *  0.5) +  1.0)) +  1.0));
                end
                else begin
                  tmp = ((((((- __fbbtgat_d) / Fmaxr) -  230.258509299405) * ((((((- __fbbtgat_d) / Fmaxr) -  230.258509299405) * (((((- __fbbtgat_d) / Fmaxr) -  230.258509299405) *  0.333333333333333) +  1.0)) *  0.5) +  1.0)) +  1.0) *  10.0e+99);
                end
              end
              ibbt = (__CBBTGATD_i * (((__V1 * Fmaxr) * Fmaxr) * tmp));
            end
            if ((__VBRGATD_i >  1.0e+3)) begin
              fbreakdown =  1.0;
            end
            else begin
              if ((vav > ((- __alphaav) * __VBRGATD_i))) begin
                if ((__PBRGATD_i ==  4.0)) begin
                  tmp = ((((vav * __VBRinvgat_d) * (vav * __VBRinvgat_d)) * (vav * __VBRinvgat_d)) * (vav * __VBRinvgat_d));
                end
                else begin
                  tmp = pow(abs((vav * __VBRinvgat_d)), __PBRGATD_i);
                end
                fbreakdown = ( 1.0 / ( 1.0 - tmp));
              end
              else begin
                fbreakdown = (__fstopgat_d + ((vav + (__alphaav * __VBRGATD_i)) * __slopegat_d));
              end
            end
            ijungat = ((((id + isrh) + itat) + ibbt) * fbreakdown);
          end
          __I1 = (((__ABDRAIN_i * ijunbot) + (__LSDRAIN_i * ijunsti)) + (__LGDRAIN_i * ijungat));
          vbbt =  0.0;
          two_psistar =  0.0;
          if ((! (((__ABDRAIN_i ==  0.0) && (__LSDRAIN_i ==  0.0)) && (__LGDRAIN_i ==  0.0)))) begin
            h1 = ((__vch_d *  4.0) * __vch_d);
            h2 = (__vch_d / __vfmin_d);
            h2d = (__V2 + (__vch_d * h2));
            h3 = (__vfmin_d + h2d);
            h4 = (__vfmin_d - h2d);
            h5 = sqrt(((h4 * h4) + h1));
            vj = (((__V2 * __vfmin_d) / (h3 + h5)) *  2.0);
            if ((__V2 < __VMAX_d)) begin
              if ((abs(((__V2 * __phitdinv) *  0.5)) <  230.258509299405)) begin
                zinv = exp(((__V2 * __phitdinv) *  0.5));
              end
              else begin
                if ((((__V2 * __phitdinv) *  0.5) <  0.0)) begin
                  zinv = ( 100.0e-102 / (((-230.258509299405 - ((__V2 * __phitdinv) *  0.5)) * ((((-230.258509299405 - ((__V2 * __phitdinv) *  0.5)) * (((-230.258509299405 - ((__V2 * __phitdinv) *  0.5)) *  0.333333333333333) +  1.0)) *  0.5) +  1.0)) +  1.0));
                end
                else begin
                  zinv = ((((((__V2 * __phitdinv) *  0.5) -  230.258509299405) * ((((((__V2 * __phitdinv) *  0.5) -  230.258509299405) * (((((__V2 * __phitdinv) *  0.5) -  230.258509299405) *  0.333333333333333) +  1.0)) *  0.5) +  1.0)) +  1.0) *  10.0e+99);
                end
              end
              idmult = (zinv * zinv);
            end
            else begin
              idmult = ((((__V2 - __VMAX_d) * __phitdinv) +  1.0) * __exp_VMAX_over_phitd_d);
              zinv = sqrt(idmult);
            end
            idmult = (idmult -  1.0);
            z = ( 1.0 / zinv);
            if ((__V2 >  0.0)) begin
              two_psistar = ((__phitd * ln(((z +  2.0) + sqrt(((z +  1.0) * (z +  3.0)))))) *  2.0);
            end
            else begin
              two_psistar = ((- __V2) + ((__phitd * ln((((zinv *  2.0) +  1.0) + sqrt(((zinv +  1.0) * ((zinv *  3.0) +  1.0)))))) *  2.0));
            end
            vjlim = (__vbimin_d - two_psistar);
            vjsrh = (((__V2 + vjlim) - sqrt((((__V2 - vjlim) * (__V2 - vjlim)) + ((__phitd *  4.0) * __phitd)))) *  0.5);
            vbbt = (((__V2 + __vbbtlim_d) - sqrt((((__V2 - __vbbtlim_d) * (__V2 - __vbbtlim_d)) + ((__phitr *  4.0) * __phitr)))) *  0.5);
            vav = ((__V2 - sqrt(((__V2 * __V2) +  4.0e-12))) *  0.5);
          end
          if ((__ABDRAIN_i ==  0.0)) begin
            ijunbot =  0.0;
            qjunbot =  0.0;
          end
          else begin
            if ((__one_minus_PBOT_d ==  0.5)) begin
              tmp = sqrt(( 1.0 - (vj * __vbiinvbot_d)));
            end
            else begin
              tmp = pow(( 1.0 - (vj * __vbiinvbot_d)), __one_minus_PBOT_d);
            end
            qjunbot = ((__qprefbot_d * ( 1.0 - tmp)) + (__qpref2bot_d * (__V2 - vj)));
            id = (__idsatbot_d * idmult);
            if (((__CSRHBOTD_i ==  0.0) && (__CTATBOTD_i ==  0.0))) begin
              isrh =  0.0;
            end
            else begin
              vbi_minus_vjsrh = (__vbibot_d - vjsrh);
              wsrhstep = ( 1.0 - sqrt(( 1.0 - (two_psistar / vbi_minus_vjsrh))));
              if ((__PBOTD_i ==  0.5)) begin
                dwsrh =  0.0;
              end
              else begin
                dwsrh = (((((wsrhstep * wsrhstep) * ln(wsrhstep)) / ( 1.0 - wsrhstep)) + wsrhstep) * ( 1.0 - (__PBOTD_i *  2.0)));
              end
              wsrh = (wsrhstep + dwsrh);
              if ((__PBOTD_i ==  0.5)) begin
                tmp = sqrt((vbi_minus_vjsrh * __VBIRBOTinv_d));
              end
              else begin
                tmp = pow((vbi_minus_vjsrh * __VBIRBOTinv_d), __PBOTD_i);
              end
              wdep = (__wdepnulrbot_d * tmp);
              asrh = (__ftdbot_d * ((zinv -  1.0) * wdep));
              isrh = (__CSRHBOTD_i * (asrh * wsrh));
            end
            if ((__CTATBOTD_i ==  0.0)) begin
              itat =  0.0;
            end
            else begin
              btat = (__btatpartbot_d * ((wdep * __one_minus_PBOT_d) / vbi_minus_vjsrh));
              twoatatoverthreebtat = ((__atatbot_d *  0.666666666666667) / btat);
              umaxbeforelimiting = (twoatatoverthreebtat * twoatatoverthreebtat);
              umax = sqrt(((umaxbeforelimiting * umaxbeforelimiting) / ((umaxbeforelimiting * umaxbeforelimiting) +  1.0)));
              sqrtumax = sqrt(umax);
              umaxpoweronepointfive = (umax * sqrtumax);
              if ((((- __PBOTD_i) * __one_over_one_minus_PBOT_d) == -1.0)) begin
                wgamma = ( 1.0 / ((btat * umaxpoweronepointfive) +  1.0));
              end
              else begin
                wgamma = pow(((btat * umaxpoweronepointfive) +  1.0), ((- __PBOTD_i) * __one_over_one_minus_PBOT_d));
              end
              wtat = ((wsrh * wgamma) / (wsrh + wgamma));
              ktat = sqrt(((btat / sqrtumax) *  0.375));
              ltat = (((twoatatoverthreebtat * sqrtumax) *  2.0) - umax);
              mtat = ((((__atatbot_d * twoatatoverthreebtat) * sqrtumax) - (__atatbot_d * umax)) + ((btat * umaxpoweronepointfive) *  0.5));
              xerfc = ((ltat -  1.0) * ktat);
              ysq = (xerfc * xerfc);
              if ((xerfc >  0.0)) begin
                terfc = ( 1.0 / ((__perfc * xerfc) +  1.0));
              end
              else begin
                terfc = ( 1.0 / ( 1.0 - (__perfc * xerfc)));
              end
              if ((((- ysq) + mtat) > -230.258509299405)) begin
                tmp = exp(((- ysq) + mtat));
              end
              else begin
                tmp = ( 100.0e-102 / (((-230.258509299405 - ((- ysq) + mtat)) * ((((-230.258509299405 - ((- ysq) + mtat)) * (((-230.258509299405 - ((- ysq) + mtat)) *  0.333333333333333) +  1.0)) *  0.5) +  1.0)) +  1.0));
              end
              erfcpos = ((((terfc *  0.29214664) + (__berfc * (terfc * terfc))) + (__cerfc * ((terfc * terfc) * terfc))) * tmp);
              if ((xerfc >  0.0)) begin
                erfctimesexpmtat = erfcpos;
              end
              else begin
                if ((mtat > -230.258509299405)) begin
                  tmp = exp(mtat);
                end
                else begin
                  tmp = ( 100.0e-102 / (((-230.258509299405 - mtat) * ((((-230.258509299405 - mtat) * (((-230.258509299405 - mtat) *  0.333333333333333) +  1.0)) *  0.5) +  1.0)) +  1.0));
                end
                erfctimesexpmtat = ((tmp *  2.0) - erfcpos);
              end
              gammamax = (((__atatbot_d * erfctimesexpmtat) / ktat) *  0.886226925452758);
              itat = (__CTATBOTD_i * ((asrh * gammamax) * wtat));
            end
            if ((__CBBTBOTD_i ==  0.0)) begin
              ibbt =  0.0;
            end
            else begin
              if ((__PBOTD_i ==  0.5)) begin
                tmp = sqrt(((__VBIRBOTD_i - vbbt) * __VBIRBOTinv_d));
              end
              else begin
                tmp = pow(((__VBIRBOTD_i - vbbt) * __VBIRBOTinv_d), __PBOTD_i);
              end
              Fmaxr = (__one_over_one_minus_PBOT_d * (((__VBIRBOTD_i - vbbt) * __wdepnulrinvbot_d) / tmp));
              if ((abs(((- __fbbtbot_d) / Fmaxr)) <  230.258509299405)) begin
                tmp = exp(((- __fbbtbot_d) / Fmaxr));
              end
              else begin
                if ((((- __fbbtbot_d) / Fmaxr) <  0.0)) begin
                  tmp = ( 100.0e-102 / (((-230.258509299405 - ((- __fbbtbot_d) / Fmaxr)) * ((((-230.258509299405 - ((- __fbbtbot_d) / Fmaxr)) * (((-230.258509299405 - ((- __fbbtbot_d) / Fmaxr)) *  0.333333333333333) +  1.0)) *  0.5) +  1.0)) +  1.0));
                end
                else begin
                  tmp = ((((((- __fbbtbot_d) / Fmaxr) -  230.258509299405) * ((((((- __fbbtbot_d) / Fmaxr) -  230.258509299405) * (((((- __fbbtbot_d) / Fmaxr) -  230.258509299405) *  0.333333333333333) +  1.0)) *  0.5) +  1.0)) +  1.0) *  10.0e+99);
                end
              end
              ibbt = (__CBBTBOTD_i * (((__V2 * Fmaxr) * Fmaxr) * tmp));
            end
            if ((__VBRBOTD_i >  1.0e+3)) begin
              fbreakdown =  1.0;
            end
            else begin
              if ((vav > ((- __alphaav) * __VBRBOTD_i))) begin
                if ((__PBRBOTD_i ==  4.0)) begin
                  tmp = ((((vav * __VBRinvbot_d) * (vav * __VBRinvbot_d)) * (vav * __VBRinvbot_d)) * (vav * __VBRinvbot_d));
                end
                else begin
                  tmp = pow(abs((vav * __VBRinvbot_d)), __PBRBOTD_i);
                end
                fbreakdown = ( 1.0 / ( 1.0 - tmp));
              end
              else begin
                fbreakdown = (__fstopbot_d + ((vav + (__alphaav * __VBRBOTD_i)) * __slopebot_d));
              end
            end
            ijunbot = ((((id + isrh) + itat) + ibbt) * fbreakdown);
          end
          if ((__LSDRAIN_i ==  0.0)) begin
            ijunsti =  0.0;
            qjunsti =  0.0;
          end
          else begin
            if ((__one_minus_PSTI_d ==  0.5)) begin
              tmp = sqrt(( 1.0 - (vj * __vbiinvsti_d)));
            end
            else begin
              tmp = pow(( 1.0 - (vj * __vbiinvsti_d)), __one_minus_PSTI_d);
            end
            qjunsti = ((__qprefsti_d * ( 1.0 - tmp)) + (__qpref2sti_d * (__V2 - vj)));
            id = (__idsatsti_d * idmult);
            if (((__CSRHSTID_i ==  0.0) && (__CTATSTID_i ==  0.0))) begin
              isrh =  0.0;
            end
            else begin
              vbi_minus_vjsrh = (__vbisti_d - vjsrh);
              wsrhstep = ( 1.0 - sqrt(( 1.0 - (two_psistar / vbi_minus_vjsrh))));
              if ((__PSTID_i ==  0.5)) begin
                dwsrh =  0.0;
              end
              else begin
                dwsrh = (((((wsrhstep * wsrhstep) * ln(wsrhstep)) / ( 1.0 - wsrhstep)) + wsrhstep) * ( 1.0 - (__PSTID_i *  2.0)));
              end
              wsrh = (wsrhstep + dwsrh);
              if ((__PSTID_i ==  0.5)) begin
                tmp = sqrt((vbi_minus_vjsrh * __VBIRSTIinv_d));
              end
              else begin
                tmp = pow((vbi_minus_vjsrh * __VBIRSTIinv_d), __PSTID_i);
              end
              wdep = (__wdepnulrsti_d * tmp);
              asrh = (__ftdsti_d * ((zinv -  1.0) * wdep));
              isrh = (__CSRHSTID_i * (asrh * wsrh));
            end
            if ((__CTATSTID_i ==  0.0)) begin
              itat =  0.0;
            end
            else begin
              btat = (__btatpartsti_d * ((wdep * __one_minus_PSTI_d) / vbi_minus_vjsrh));
              twoatatoverthreebtat = ((__atatsti_d *  0.666666666666667) / btat);
              umaxbeforelimiting = (twoatatoverthreebtat * twoatatoverthreebtat);
              umax = sqrt(((umaxbeforelimiting * umaxbeforelimiting) / ((umaxbeforelimiting * umaxbeforelimiting) +  1.0)));
              sqrtumax = sqrt(umax);
              umaxpoweronepointfive = (umax * sqrtumax);
              if ((((- __PSTID_i) * __one_over_one_minus_PSTI_d) == -1.0)) begin
                wgamma = ( 1.0 / ((btat * umaxpoweronepointfive) +  1.0));
              end
              else begin
                wgamma = pow(((btat * umaxpoweronepointfive) +  1.0), ((- __PSTID_i) * __one_over_one_minus_PSTI_d));
              end
              wtat = ((wsrh * wgamma) / (wsrh + wgamma));
              ktat = sqrt(((btat / sqrtumax) *  0.375));
              ltat = (((twoatatoverthreebtat * sqrtumax) *  2.0) - umax);
              mtat = ((((__atatsti_d * twoatatoverthreebtat) * sqrtumax) - (__atatsti_d * umax)) + ((btat * umaxpoweronepointfive) *  0.5));
              xerfc = ((ltat -  1.0) * ktat);
              ysq = (xerfc * xerfc);
              if ((xerfc >  0.0)) begin
                terfc = ( 1.0 / ((__perfc * xerfc) +  1.0));
              end
              else begin
                terfc = ( 1.0 / ( 1.0 - (__perfc * xerfc)));
              end
              if ((((- ysq) + mtat) > -230.258509299405)) begin
                tmp = exp(((- ysq) + mtat));
              end
              else begin
                tmp = ( 100.0e-102 / (((-230.258509299405 - ((- ysq) + mtat)) * ((((-230.258509299405 - ((- ysq) + mtat)) * (((-230.258509299405 - ((- ysq) + mtat)) *  0.333333333333333) +  1.0)) *  0.5) +  1.0)) +  1.0));
              end
              erfcpos = ((((terfc *  0.29214664) + (__berfc * (terfc * terfc))) + (__cerfc * ((terfc * terfc) * terfc))) * tmp);
              if ((xerfc >  0.0)) begin
                erfctimesexpmtat = erfcpos;
              end
              else begin
                if ((mtat > -230.258509299405)) begin
                  tmp = exp(mtat);
                end
                else begin
                  tmp = ( 100.0e-102 / (((-230.258509299405 - mtat) * ((((-230.258509299405 - mtat) * (((-230.258509299405 - mtat) *  0.333333333333333) +  1.0)) *  0.5) +  1.0)) +  1.0));
                end
                erfctimesexpmtat = ((tmp *  2.0) - erfcpos);
              end
              gammamax = (((__atatsti_d * erfctimesexpmtat) / ktat) *  0.886226925452758);
              itat = (__CTATSTID_i * ((asrh * gammamax) * wtat));
            end
            if ((__CBBTSTID_i ==  0.0)) begin
              ibbt =  0.0;
            end
            else begin
              if ((__PSTID_i ==  0.5)) begin
                tmp = sqrt(((__VBIRSTID_i - vbbt) * __VBIRSTIinv_d));
              end
              else begin
                tmp = pow(((__VBIRSTID_i - vbbt) * __VBIRSTIinv_d), __PSTID_i);
              end
              Fmaxr = (__one_over_one_minus_PSTI_d * (((__VBIRSTID_i - vbbt) * __wdepnulrinvsti_d) / tmp));
              if ((abs(((- __fbbtsti_d) / Fmaxr)) <  230.258509299405)) begin
                tmp = exp(((- __fbbtsti_d) / Fmaxr));
              end
              else begin
                if ((((- __fbbtsti_d) / Fmaxr) <  0.0)) begin
                  tmp = ( 100.0e-102 / (((-230.258509299405 - ((- __fbbtsti_d) / Fmaxr)) * ((((-230.258509299405 - ((- __fbbtsti_d) / Fmaxr)) * (((-230.258509299405 - ((- __fbbtsti_d) / Fmaxr)) *  0.333333333333333) +  1.0)) *  0.5) +  1.0)) +  1.0));
                end
                else begin
                  tmp = ((((((- __fbbtsti_d) / Fmaxr) -  230.258509299405) * ((((((- __fbbtsti_d) / Fmaxr) -  230.258509299405) * (((((- __fbbtsti_d) / Fmaxr) -  230.258509299405) *  0.333333333333333) +  1.0)) *  0.5) +  1.0)) +  1.0) *  10.0e+99);
                end
              end
              ibbt = (__CBBTSTID_i * (((__V2 * Fmaxr) * Fmaxr) * tmp));
            end
            if ((__VBRSTID_i >  1.0e+3)) begin
              fbreakdown =  1.0;
            end
            else begin
              if ((vav > ((- __alphaav) * __VBRSTID_i))) begin
                if ((__PBRSTID_i ==  4.0)) begin
                  tmp = ((((vav * __VBRinvsti_d) * (vav * __VBRinvsti_d)) * (vav * __VBRinvsti_d)) * (vav * __VBRinvsti_d));
                end
                else begin
                  tmp = pow(abs((vav * __VBRinvsti_d)), __PBRSTID_i);
                end
                fbreakdown = ( 1.0 / ( 1.0 - tmp));
              end
              else begin
                fbreakdown = (__fstopsti_d + ((vav + (__alphaav * __VBRSTID_i)) * __slopesti_d));
              end
            end
            ijunsti = ((((id + isrh) + itat) + ibbt) * fbreakdown);
          end
          if ((__LGDRAIN_i ==  0.0)) begin
            ijungat =  0.0;
            qjungat =  0.0;
          end
          else begin
            if ((__one_minus_PGAT_d ==  0.5)) begin
              tmp = sqrt(( 1.0 - (vj * __vbiinvgat_d)));
            end
            else begin
              tmp = pow(( 1.0 - (vj * __vbiinvgat_d)), __one_minus_PGAT_d);
            end
            qjungat = ((__qprefgat_d * ( 1.0 - tmp)) + (__qpref2gat_d * (__V2 - vj)));
            id = (__idsatgat_d * idmult);
            if (((__CSRHGATD_i ==  0.0) && (__CTATGATD_i ==  0.0))) begin
              isrh =  0.0;
            end
            else begin
              vbi_minus_vjsrh = (__vbigat_d - vjsrh);
              wsrhstep = ( 1.0 - sqrt(( 1.0 - (two_psistar / vbi_minus_vjsrh))));
              if ((__PGATD_i ==  0.5)) begin
                dwsrh =  0.0;
              end
              else begin
                dwsrh = (((((wsrhstep * wsrhstep) * ln(wsrhstep)) / ( 1.0 - wsrhstep)) + wsrhstep) * ( 1.0 - (__PGATD_i *  2.0)));
              end
              wsrh = (wsrhstep + dwsrh);
              if ((__PGATD_i ==  0.5)) begin
                tmp = sqrt((vbi_minus_vjsrh * __VBIRGATinv_d));
              end
              else begin
                tmp = pow((vbi_minus_vjsrh * __VBIRGATinv_d), __PGATD_i);
              end
              wdep = (__wdepnulrgat_d * tmp);
              asrh = (__ftdgat_d * ((zinv -  1.0) * wdep));
              isrh = (__CSRHGATD_i * (asrh * wsrh));
            end
            if ((__CTATGATD_i ==  0.0)) begin
              itat =  0.0;
            end
            else begin
              btat = (__btatpartgat_d * ((wdep * __one_minus_PGAT_d) / vbi_minus_vjsrh));
              twoatatoverthreebtat = ((__atatgat_d *  0.666666666666667) / btat);
              umaxbeforelimiting = (twoatatoverthreebtat * twoatatoverthreebtat);
              umax = sqrt(((umaxbeforelimiting * umaxbeforelimiting) / ((umaxbeforelimiting * umaxbeforelimiting) +  1.0)));
              sqrtumax = sqrt(umax);
              umaxpoweronepointfive = (umax * sqrtumax);
              if ((((- __PGATD_i) * __one_over_one_minus_PGAT_d) == -1.0)) begin
                wgamma = ( 1.0 / ((btat * umaxpoweronepointfive) +  1.0));
              end
              else begin
                wgamma = pow(((btat * umaxpoweronepointfive) +  1.0), ((- __PGATD_i) * __one_over_one_minus_PGAT_d));
              end
              wtat = ((wsrh * wgamma) / (wsrh + wgamma));
              ktat = sqrt(((btat / sqrtumax) *  0.375));
              ltat = (((twoatatoverthreebtat * sqrtumax) *  2.0) - umax);
              mtat = ((((__atatgat_d * twoatatoverthreebtat) * sqrtumax) - (__atatgat_d * umax)) + ((btat * umaxpoweronepointfive) *  0.5));
              xerfc = ((ltat -  1.0) * ktat);
              ysq = (xerfc * xerfc);
              if ((xerfc >  0.0)) begin
                terfc = ( 1.0 / ((__perfc * xerfc) +  1.0));
              end
              else begin
                terfc = ( 1.0 / ( 1.0 - (__perfc * xerfc)));
              end
              if ((((- ysq) + mtat) > -230.258509299405)) begin
                tmp = exp(((- ysq) + mtat));
              end
              else begin
                tmp = ( 100.0e-102 / (((-230.258509299405 - ((- ysq) + mtat)) * ((((-230.258509299405 - ((- ysq) + mtat)) * (((-230.258509299405 - ((- ysq) + mtat)) *  0.333333333333333) +  1.0)) *  0.5) +  1.0)) +  1.0));
              end
              erfcpos = ((((terfc *  0.29214664) + (__berfc * (terfc * terfc))) + (__cerfc * ((terfc * terfc) * terfc))) * tmp);
              if ((xerfc >  0.0)) begin
                erfctimesexpmtat = erfcpos;
              end
              else begin
                if ((mtat > -230.258509299405)) begin
                  tmp = exp(mtat);
                end
                else begin
                  tmp = ( 100.0e-102 / (((-230.258509299405 - mtat) * ((((-230.258509299405 - mtat) * (((-230.258509299405 - mtat) *  0.333333333333333) +  1.0)) *  0.5) +  1.0)) +  1.0));
                end
                erfctimesexpmtat = ((tmp *  2.0) - erfcpos);
              end
              gammamax = (((__atatgat_d * erfctimesexpmtat) / ktat) *  0.886226925452758);
              itat = (__CTATGATD_i * ((asrh * gammamax) * wtat));
            end
            if ((__CBBTGATD_i ==  0.0)) begin
              ibbt =  0.0;
            end
            else begin
              if ((__PGATD_i ==  0.5)) begin
                tmp = sqrt(((__VBIRGATD_i - vbbt) * __VBIRGATinv_d));
              end
              else begin
                tmp = pow(((__VBIRGATD_i - vbbt) * __VBIRGATinv_d), __PGATD_i);
              end
              Fmaxr = (__one_over_one_minus_PGAT_d * (((__VBIRGATD_i - vbbt) * __wdepnulrinvgat_d) / tmp));
              if ((abs(((- __fbbtgat_d) / Fmaxr)) <  230.258509299405)) begin
                tmp = exp(((- __fbbtgat_d) / Fmaxr));
              end
              else begin
                if ((((- __fbbtgat_d) / Fmaxr) <  0.0)) begin
                  tmp = ( 100.0e-102 / (((-230.258509299405 - ((- __fbbtgat_d) / Fmaxr)) * ((((-230.258509299405 - ((- __fbbtgat_d) / Fmaxr)) * (((-230.258509299405 - ((- __fbbtgat_d) / Fmaxr)) *  0.333333333333333) +  1.0)) *  0.5) +  1.0)) +  1.0));
                end
                else begin
                  tmp = ((((((- __fbbtgat_d) / Fmaxr) -  230.258509299405) * ((((((- __fbbtgat_d) / Fmaxr) -  230.258509299405) * (((((- __fbbtgat_d) / Fmaxr) -  230.258509299405) *  0.333333333333333) +  1.0)) *  0.5) +  1.0)) +  1.0) *  10.0e+99);
                end
              end
              ibbt = (__CBBTGATD_i * (((__V2 * Fmaxr) * Fmaxr) * tmp));
            end
            if ((__VBRGATD_i >  1.0e+3)) begin
              fbreakdown =  1.0;
            end
            else begin
              if ((vav > ((- __alphaav) * __VBRGATD_i))) begin
                if ((__PBRGATD_i ==  4.0)) begin
                  tmp = ((((vav * __VBRinvgat_d) * (vav * __VBRinvgat_d)) * (vav * __VBRinvgat_d)) * (vav * __VBRinvgat_d));
                end
                else begin
                  tmp = pow(abs((vav * __VBRinvgat_d)), __PBRGATD_i);
                end
                fbreakdown = ( 1.0 / ( 1.0 - tmp));
              end
              else begin
                fbreakdown = (__fstopgat_d + ((vav + (__alphaav * __VBRGATD_i)) * __slopegat_d));
              end
            end
            ijungat = ((((id + isrh) + itat) + ibbt) * fbreakdown);
          end
          __I2 = (((__ABDRAIN_i * ijunbot) + (__LSDRAIN_i * ijunsti)) + (__LGDRAIN_i * ijungat));
          vbbt =  0.0;
          two_psistar =  0.0;
          if ((! (((__ABDRAIN_i ==  0.0) && (__LSDRAIN_i ==  0.0)) && (__LGDRAIN_i ==  0.0)))) begin
            h1 = ((__vch_d *  4.0) * __vch_d);
            h2 = (__vch_d / __vfmin_d);
            h2d = (__V3 + (__vch_d * h2));
            h3 = (__vfmin_d + h2d);
            h4 = (__vfmin_d - h2d);
            h5 = sqrt(((h4 * h4) + h1));
            vj = (((__V3 * __vfmin_d) / (h3 + h5)) *  2.0);
            if ((__V3 < __VMAX_d)) begin
              if ((abs(((__V3 * __phitdinv) *  0.5)) <  230.258509299405)) begin
                zinv = exp(((__V3 * __phitdinv) *  0.5));
              end
              else begin
                if ((((__V3 * __phitdinv) *  0.5) <  0.0)) begin
                  zinv = ( 100.0e-102 / (((-230.258509299405 - ((__V3 * __phitdinv) *  0.5)) * ((((-230.258509299405 - ((__V3 * __phitdinv) *  0.5)) * (((-230.258509299405 - ((__V3 * __phitdinv) *  0.5)) *  0.333333333333333) +  1.0)) *  0.5) +  1.0)) +  1.0));
                end
                else begin
                  zinv = ((((((__V3 * __phitdinv) *  0.5) -  230.258509299405) * ((((((__V3 * __phitdinv) *  0.5) -  230.258509299405) * (((((__V3 * __phitdinv) *  0.5) -  230.258509299405) *  0.333333333333333) +  1.0)) *  0.5) +  1.0)) +  1.0) *  10.0e+99);
                end
              end
              idmult = (zinv * zinv);
            end
            else begin
              idmult = ((((__V3 - __VMAX_d) * __phitdinv) +  1.0) * __exp_VMAX_over_phitd_d);
              zinv = sqrt(idmult);
            end
            idmult = (idmult -  1.0);
            z = ( 1.0 / zinv);
            if ((__V3 >  0.0)) begin
              two_psistar = ((__phitd * ln(((z +  2.0) + sqrt(((z +  1.0) * (z +  3.0)))))) *  2.0);
            end
            else begin
              two_psistar = ((- __V3) + ((__phitd * ln((((zinv *  2.0) +  1.0) + sqrt(((zinv +  1.0) * ((zinv *  3.0) +  1.0)))))) *  2.0));
            end
            vjlim = (__vbimin_d - two_psistar);
            vjsrh = (((__V3 + vjlim) - sqrt((((__V3 - vjlim) * (__V3 - vjlim)) + ((__phitd *  4.0) * __phitd)))) *  0.5);
            vbbt = (((__V3 + __vbbtlim_d) - sqrt((((__V3 - __vbbtlim_d) * (__V3 - __vbbtlim_d)) + ((__phitr *  4.0) * __phitr)))) *  0.5);
            vav = ((__V3 - sqrt(((__V3 * __V3) +  4.0e-12))) *  0.5);
          end
          if ((__ABDRAIN_i ==  0.0)) begin
            ijunbot =  0.0;
            qjunbot =  0.0;
          end
          else begin
            if ((__one_minus_PBOT_d ==  0.5)) begin
              tmp = sqrt(( 1.0 - (vj * __vbiinvbot_d)));
            end
            else begin
              tmp = pow(( 1.0 - (vj * __vbiinvbot_d)), __one_minus_PBOT_d);
            end
            qjunbot = ((__qprefbot_d * ( 1.0 - tmp)) + (__qpref2bot_d * (__V3 - vj)));
            id = (__idsatbot_d * idmult);
            if (((__CSRHBOTD_i ==  0.0) && (__CTATBOTD_i ==  0.0))) begin
              isrh =  0.0;
            end
            else begin
              vbi_minus_vjsrh = (__vbibot_d - vjsrh);
              wsrhstep = ( 1.0 - sqrt(( 1.0 - (two_psistar / vbi_minus_vjsrh))));
              if ((__PBOTD_i ==  0.5)) begin
                dwsrh =  0.0;
              end
              else begin
                dwsrh = (((((wsrhstep * wsrhstep) * ln(wsrhstep)) / ( 1.0 - wsrhstep)) + wsrhstep) * ( 1.0 - (__PBOTD_i *  2.0)));
              end
              wsrh = (wsrhstep + dwsrh);
              if ((__PBOTD_i ==  0.5)) begin
                tmp = sqrt((vbi_minus_vjsrh * __VBIRBOTinv_d));
              end
              else begin
                tmp = pow((vbi_minus_vjsrh * __VBIRBOTinv_d), __PBOTD_i);
              end
              wdep = (__wdepnulrbot_d * tmp);
              asrh = (__ftdbot_d * ((zinv -  1.0) * wdep));
              isrh = (__CSRHBOTD_i * (asrh * wsrh));
            end
            if ((__CTATBOTD_i ==  0.0)) begin
              itat =  0.0;
            end
            else begin
              btat = (__btatpartbot_d * ((wdep * __one_minus_PBOT_d) / vbi_minus_vjsrh));
              twoatatoverthreebtat = ((__atatbot_d *  0.666666666666667) / btat);
              umaxbeforelimiting = (twoatatoverthreebtat * twoatatoverthreebtat);
              umax = sqrt(((umaxbeforelimiting * umaxbeforelimiting) / ((umaxbeforelimiting * umaxbeforelimiting) +  1.0)));
              sqrtumax = sqrt(umax);
              umaxpoweronepointfive = (umax * sqrtumax);
              if ((((- __PBOTD_i) * __one_over_one_minus_PBOT_d) == -1.0)) begin
                wgamma = ( 1.0 / ((btat * umaxpoweronepointfive) +  1.0));
              end
              else begin
                wgamma = pow(((btat * umaxpoweronepointfive) +  1.0), ((- __PBOTD_i) * __one_over_one_minus_PBOT_d));
              end
              wtat = ((wsrh * wgamma) / (wsrh + wgamma));
              ktat = sqrt(((btat / sqrtumax) *  0.375));
              ltat = (((twoatatoverthreebtat * sqrtumax) *  2.0) - umax);
              mtat = ((((__atatbot_d * twoatatoverthreebtat) * sqrtumax) - (__atatbot_d * umax)) + ((btat * umaxpoweronepointfive) *  0.5));
              xerfc = ((ltat -  1.0) * ktat);
              ysq = (xerfc * xerfc);
              if ((xerfc >  0.0)) begin
                terfc = ( 1.0 / ((__perfc * xerfc) +  1.0));
              end
              else begin
                terfc = ( 1.0 / ( 1.0 - (__perfc * xerfc)));
              end
              if ((((- ysq) + mtat) > -230.258509299405)) begin
                tmp = exp(((- ysq) + mtat));
              end
              else begin
                tmp = ( 100.0e-102 / (((-230.258509299405 - ((- ysq) + mtat)) * ((((-230.258509299405 - ((- ysq) + mtat)) * (((-230.258509299405 - ((- ysq) + mtat)) *  0.333333333333333) +  1.0)) *  0.5) +  1.0)) +  1.0));
              end
              erfcpos = ((((terfc *  0.29214664) + (__berfc * (terfc * terfc))) + (__cerfc * ((terfc * terfc) * terfc))) * tmp);
              if ((xerfc >  0.0)) begin
                erfctimesexpmtat = erfcpos;
              end
              else begin
                if ((mtat > -230.258509299405)) begin
                  tmp = exp(mtat);
                end
                else begin
                  tmp = ( 100.0e-102 / (((-230.258509299405 - mtat) * ((((-230.258509299405 - mtat) * (((-230.258509299405 - mtat) *  0.333333333333333) +  1.0)) *  0.5) +  1.0)) +  1.0));
                end
                erfctimesexpmtat = ((tmp *  2.0) - erfcpos);
              end
              gammamax = (((__atatbot_d * erfctimesexpmtat) / ktat) *  0.886226925452758);
              itat = (__CTATBOTD_i * ((asrh * gammamax) * wtat));
            end
            if ((__CBBTBOTD_i ==  0.0)) begin
              ibbt =  0.0;
            end
            else begin
              if ((__PBOTD_i ==  0.5)) begin
                tmp = sqrt(((__VBIRBOTD_i - vbbt) * __VBIRBOTinv_d));
              end
              else begin
                tmp = pow(((__VBIRBOTD_i - vbbt) * __VBIRBOTinv_d), __PBOTD_i);
              end
              Fmaxr = (__one_over_one_minus_PBOT_d * (((__VBIRBOTD_i - vbbt) * __wdepnulrinvbot_d) / tmp));
              if ((abs(((- __fbbtbot_d) / Fmaxr)) <  230.258509299405)) begin
                tmp = exp(((- __fbbtbot_d) / Fmaxr));
              end
              else begin
                if ((((- __fbbtbot_d) / Fmaxr) <  0.0)) begin
                  tmp = ( 100.0e-102 / (((-230.258509299405 - ((- __fbbtbot_d) / Fmaxr)) * ((((-230.258509299405 - ((- __fbbtbot_d) / Fmaxr)) * (((-230.258509299405 - ((- __fbbtbot_d) / Fmaxr)) *  0.333333333333333) +  1.0)) *  0.5) +  1.0)) +  1.0));
                end
                else begin
                  tmp = ((((((- __fbbtbot_d) / Fmaxr) -  230.258509299405) * ((((((- __fbbtbot_d) / Fmaxr) -  230.258509299405) * (((((- __fbbtbot_d) / Fmaxr) -  230.258509299405) *  0.333333333333333) +  1.0)) *  0.5) +  1.0)) +  1.0) *  10.0e+99);
                end
              end
              ibbt = (__CBBTBOTD_i * (((__V3 * Fmaxr) * Fmaxr) * tmp));
            end
            if ((__VBRBOTD_i >  1.0e+3)) begin
              fbreakdown =  1.0;
            end
            else begin
              if ((vav > ((- __alphaav) * __VBRBOTD_i))) begin
                if ((__PBRBOTD_i ==  4.0)) begin
                  tmp = ((((vav * __VBRinvbot_d) * (vav * __VBRinvbot_d)) * (vav * __VBRinvbot_d)) * (vav * __VBRinvbot_d));
                end
                else begin
                  tmp = pow(abs((vav * __VBRinvbot_d)), __PBRBOTD_i);
                end
                fbreakdown = ( 1.0 / ( 1.0 - tmp));
              end
              else begin
                fbreakdown = (__fstopbot_d + ((vav + (__alphaav * __VBRBOTD_i)) * __slopebot_d));
              end
            end
            ijunbot = ((((id + isrh) + itat) + ibbt) * fbreakdown);
          end
          if ((__LSDRAIN_i ==  0.0)) begin
            ijunsti =  0.0;
            qjunsti =  0.0;
          end
          else begin
            if ((__one_minus_PSTI_d ==  0.5)) begin
              tmp = sqrt(( 1.0 - (vj * __vbiinvsti_d)));
            end
            else begin
              tmp = pow(( 1.0 - (vj * __vbiinvsti_d)), __one_minus_PSTI_d);
            end
            qjunsti = ((__qprefsti_d * ( 1.0 - tmp)) + (__qpref2sti_d * (__V3 - vj)));
            id = (__idsatsti_d * idmult);
            if (((__CSRHSTID_i ==  0.0) && (__CTATSTID_i ==  0.0))) begin
              isrh =  0.0;
            end
            else begin
              vbi_minus_vjsrh = (__vbisti_d - vjsrh);
              wsrhstep = ( 1.0 - sqrt(( 1.0 - (two_psistar / vbi_minus_vjsrh))));
              if ((__PSTID_i ==  0.5)) begin
                dwsrh =  0.0;
              end
              else begin
                dwsrh = (((((wsrhstep * wsrhstep) * ln(wsrhstep)) / ( 1.0 - wsrhstep)) + wsrhstep) * ( 1.0 - (__PSTID_i *  2.0)));
              end
              wsrh = (wsrhstep + dwsrh);
              if ((__PSTID_i ==  0.5)) begin
                tmp = sqrt((vbi_minus_vjsrh * __VBIRSTIinv_d));
              end
              else begin
                tmp = pow((vbi_minus_vjsrh * __VBIRSTIinv_d), __PSTID_i);
              end
              wdep = (__wdepnulrsti_d * tmp);
              asrh = (__ftdsti_d * ((zinv -  1.0) * wdep));
              isrh = (__CSRHSTID_i * (asrh * wsrh));
            end
            if ((__CTATSTID_i ==  0.0)) begin
              itat =  0.0;
            end
            else begin
              btat = (__btatpartsti_d * ((wdep * __one_minus_PSTI_d) / vbi_minus_vjsrh));
              twoatatoverthreebtat = ((__atatsti_d *  0.666666666666667) / btat);
              umaxbeforelimiting = (twoatatoverthreebtat * twoatatoverthreebtat);
              umax = sqrt(((umaxbeforelimiting * umaxbeforelimiting) / ((umaxbeforelimiting * umaxbeforelimiting) +  1.0)));
              sqrtumax = sqrt(umax);
              umaxpoweronepointfive = (umax * sqrtumax);
              if ((((- __PSTID_i) * __one_over_one_minus_PSTI_d) == -1.0)) begin
                wgamma = ( 1.0 / ((btat * umaxpoweronepointfive) +  1.0));
              end
              else begin
                wgamma = pow(((btat * umaxpoweronepointfive) +  1.0), ((- __PSTID_i) * __one_over_one_minus_PSTI_d));
              end
              wtat = ((wsrh * wgamma) / (wsrh + wgamma));
              ktat = sqrt(((btat / sqrtumax) *  0.375));
              ltat = (((twoatatoverthreebtat * sqrtumax) *  2.0) - umax);
              mtat = ((((__atatsti_d * twoatatoverthreebtat) * sqrtumax) - (__atatsti_d * umax)) + ((btat * umaxpoweronepointfive) *  0.5));
              xerfc = ((ltat -  1.0) * ktat);
              ysq = (xerfc * xerfc);
              if ((xerfc >  0.0)) begin
                terfc = ( 1.0 / ((__perfc * xerfc) +  1.0));
              end
              else begin
                terfc = ( 1.0 / ( 1.0 - (__perfc * xerfc)));
              end
              if ((((- ysq) + mtat) > -230.258509299405)) begin
                tmp = exp(((- ysq) + mtat));
              end
              else begin
                tmp = ( 100.0e-102 / (((-230.258509299405 - ((- ysq) + mtat)) * ((((-230.258509299405 - ((- ysq) + mtat)) * (((-230.258509299405 - ((- ysq) + mtat)) *  0.333333333333333) +  1.0)) *  0.5) +  1.0)) +  1.0));
              end
              erfcpos = ((((terfc *  0.29214664) + (__berfc * (terfc * terfc))) + (__cerfc * ((terfc * terfc) * terfc))) * tmp);
              if ((xerfc >  0.0)) begin
                erfctimesexpmtat = erfcpos;
              end
              else begin
                if ((mtat > -230.258509299405)) begin
                  tmp = exp(mtat);
                end
                else begin
                  tmp = ( 100.0e-102 / (((-230.258509299405 - mtat) * ((((-230.258509299405 - mtat) * (((-230.258509299405 - mtat) *  0.333333333333333) +  1.0)) *  0.5) +  1.0)) +  1.0));
                end
                erfctimesexpmtat = ((tmp *  2.0) - erfcpos);
              end
              gammamax = (((__atatsti_d * erfctimesexpmtat) / ktat) *  0.886226925452758);
              itat = (__CTATSTID_i * ((asrh * gammamax) * wtat));
            end
            if ((__CBBTSTID_i ==  0.0)) begin
              ibbt =  0.0;
            end
            else begin
              if ((__PSTID_i ==  0.5)) begin
                tmp = sqrt(((__VBIRSTID_i - vbbt) * __VBIRSTIinv_d));
              end
              else begin
                tmp = pow(((__VBIRSTID_i - vbbt) * __VBIRSTIinv_d), __PSTID_i);
              end
              Fmaxr = (__one_over_one_minus_PSTI_d * (((__VBIRSTID_i - vbbt) * __wdepnulrinvsti_d) / tmp));
              if ((abs(((- __fbbtsti_d) / Fmaxr)) <  230.258509299405)) begin
                tmp = exp(((- __fbbtsti_d) / Fmaxr));
              end
              else begin
                if ((((- __fbbtsti_d) / Fmaxr) <  0.0)) begin
                  tmp = ( 100.0e-102 / (((-230.258509299405 - ((- __fbbtsti_d) / Fmaxr)) * ((((-230.258509299405 - ((- __fbbtsti_d) / Fmaxr)) * (((-230.258509299405 - ((- __fbbtsti_d) / Fmaxr)) *  0.333333333333333) +  1.0)) *  0.5) +  1.0)) +  1.0));
                end
                else begin
                  tmp = ((((((- __fbbtsti_d) / Fmaxr) -  230.258509299405) * ((((((- __fbbtsti_d) / Fmaxr) -  230.258509299405) * (((((- __fbbtsti_d) / Fmaxr) -  230.258509299405) *  0.333333333333333) +  1.0)) *  0.5) +  1.0)) +  1.0) *  10.0e+99);
                end
              end
              ibbt = (__CBBTSTID_i * (((__V3 * Fmaxr) * Fmaxr) * tmp));
            end
            if ((__VBRSTID_i >  1.0e+3)) begin
              fbreakdown =  1.0;
            end
            else begin
              if ((vav > ((- __alphaav) * __VBRSTID_i))) begin
                if ((__PBRSTID_i ==  4.0)) begin
                  tmp = ((((vav * __VBRinvsti_d) * (vav * __VBRinvsti_d)) * (vav * __VBRinvsti_d)) * (vav * __VBRinvsti_d));
                end
                else begin
                  tmp = pow(abs((vav * __VBRinvsti_d)), __PBRSTID_i);
                end
                fbreakdown = ( 1.0 / ( 1.0 - tmp));
              end
              else begin
                fbreakdown = (__fstopsti_d + ((vav + (__alphaav * __VBRSTID_i)) * __slopesti_d));
              end
            end
            ijunsti = ((((id + isrh) + itat) + ibbt) * fbreakdown);
          end
          if ((__LGDRAIN_i ==  0.0)) begin
            ijungat =  0.0;
            qjungat =  0.0;
          end
          else begin
            if ((__one_minus_PGAT_d ==  0.5)) begin
              tmp = sqrt(( 1.0 - (vj * __vbiinvgat_d)));
            end
            else begin
              tmp = pow(( 1.0 - (vj * __vbiinvgat_d)), __one_minus_PGAT_d);
            end
            qjungat = ((__qprefgat_d * ( 1.0 - tmp)) + (__qpref2gat_d * (__V3 - vj)));
            id = (__idsatgat_d * idmult);
            if (((__CSRHGATD_i ==  0.0) && (__CTATGATD_i ==  0.0))) begin
              isrh =  0.0;
            end
            else begin
              vbi_minus_vjsrh = (__vbigat_d - vjsrh);
              wsrhstep = ( 1.0 - sqrt(( 1.0 - (two_psistar / vbi_minus_vjsrh))));
              if ((__PGATD_i ==  0.5)) begin
                dwsrh =  0.0;
              end
              else begin
                dwsrh = (((((wsrhstep * wsrhstep) * ln(wsrhstep)) / ( 1.0 - wsrhstep)) + wsrhstep) * ( 1.0 - (__PGATD_i *  2.0)));
              end
              wsrh = (wsrhstep + dwsrh);
              if ((__PGATD_i ==  0.5)) begin
                tmp = sqrt((vbi_minus_vjsrh * __VBIRGATinv_d));
              end
              else begin
                tmp = pow((vbi_minus_vjsrh * __VBIRGATinv_d), __PGATD_i);
              end
              wdep = (__wdepnulrgat_d * tmp);
              asrh = (__ftdgat_d * ((zinv -  1.0) * wdep));
              isrh = (__CSRHGATD_i * (asrh * wsrh));
            end
            if ((__CTATGATD_i ==  0.0)) begin
              itat =  0.0;
            end
            else begin
              btat = (__btatpartgat_d * ((wdep * __one_minus_PGAT_d) / vbi_minus_vjsrh));
              twoatatoverthreebtat = ((__atatgat_d *  0.666666666666667) / btat);
              umaxbeforelimiting = (twoatatoverthreebtat * twoatatoverthreebtat);
              umax = sqrt(((umaxbeforelimiting * umaxbeforelimiting) / ((umaxbeforelimiting * umaxbeforelimiting) +  1.0)));
              sqrtumax = sqrt(umax);
              umaxpoweronepointfive = (umax * sqrtumax);
              if ((((- __PGATD_i) * __one_over_one_minus_PGAT_d) == -1.0)) begin
                wgamma = ( 1.0 / ((btat * umaxpoweronepointfive) +  1.0));
              end
              else begin
                wgamma = pow(((btat * umaxpoweronepointfive) +  1.0), ((- __PGATD_i) * __one_over_one_minus_PGAT_d));
              end
              wtat = ((wsrh * wgamma) / (wsrh + wgamma));
              ktat = sqrt(((btat / sqrtumax) *  0.375));
              ltat = (((twoatatoverthreebtat * sqrtumax) *  2.0) - umax);
              mtat = ((((__atatgat_d * twoatatoverthreebtat) * sqrtumax) - (__atatgat_d * umax)) + ((btat * umaxpoweronepointfive) *  0.5));
              xerfc = ((ltat -  1.0) * ktat);
              ysq = (xerfc * xerfc);
              if ((xerfc >  0.0)) begin
                terfc = ( 1.0 / ((__perfc * xerfc) +  1.0));
              end
              else begin
                terfc = ( 1.0 / ( 1.0 - (__perfc * xerfc)));
              end
              if ((((- ysq) + mtat) > -230.258509299405)) begin
                tmp = exp(((- ysq) + mtat));
              end
              else begin
                tmp = ( 100.0e-102 / (((-230.258509299405 - ((- ysq) + mtat)) * ((((-230.258509299405 - ((- ysq) + mtat)) * (((-230.258509299405 - ((- ysq) + mtat)) *  0.333333333333333) +  1.0)) *  0.5) +  1.0)) +  1.0));
              end
              erfcpos = ((((terfc *  0.29214664) + (__berfc * (terfc * terfc))) + (__cerfc * ((terfc * terfc) * terfc))) * tmp);
              if ((xerfc >  0.0)) begin
                erfctimesexpmtat = erfcpos;
              end
              else begin
                if ((mtat > -230.258509299405)) begin
                  tmp = exp(mtat);
                end
                else begin
                  tmp = ( 100.0e-102 / (((-230.258509299405 - mtat) * ((((-230.258509299405 - mtat) * (((-230.258509299405 - mtat) *  0.333333333333333) +  1.0)) *  0.5) +  1.0)) +  1.0));
                end
                erfctimesexpmtat = ((tmp *  2.0) - erfcpos);
              end
              gammamax = (((__atatgat_d * erfctimesexpmtat) / ktat) *  0.886226925452758);
              itat = (__CTATGATD_i * ((asrh * gammamax) * wtat));
            end
            if ((__CBBTGATD_i ==  0.0)) begin
              ibbt =  0.0;
            end
            else begin
              if ((__PGATD_i ==  0.5)) begin
                tmp = sqrt(((__VBIRGATD_i - vbbt) * __VBIRGATinv_d));
              end
              else begin
                tmp = pow(((__VBIRGATD_i - vbbt) * __VBIRGATinv_d), __PGATD_i);
              end
              Fmaxr = (__one_over_one_minus_PGAT_d * (((__VBIRGATD_i - vbbt) * __wdepnulrinvgat_d) / tmp));
              if ((abs(((- __fbbtgat_d) / Fmaxr)) <  230.258509299405)) begin
                tmp = exp(((- __fbbtgat_d) / Fmaxr));
              end
              else begin
                if ((((- __fbbtgat_d) / Fmaxr) <  0.0)) begin
                  tmp = ( 100.0e-102 / (((-230.258509299405 - ((- __fbbtgat_d) / Fmaxr)) * ((((-230.258509299405 - ((- __fbbtgat_d) / Fmaxr)) * (((-230.258509299405 - ((- __fbbtgat_d) / Fmaxr)) *  0.333333333333333) +  1.0)) *  0.5) +  1.0)) +  1.0));
                end
                else begin
                  tmp = ((((((- __fbbtgat_d) / Fmaxr) -  230.258509299405) * ((((((- __fbbtgat_d) / Fmaxr) -  230.258509299405) * (((((- __fbbtgat_d) / Fmaxr) -  230.258509299405) *  0.333333333333333) +  1.0)) *  0.5) +  1.0)) +  1.0) *  10.0e+99);
                end
              end
              ibbt = (__CBBTGATD_i * (((__V3 * Fmaxr) * Fmaxr) * tmp));
            end
            if ((__VBRGATD_i >  1.0e+3)) begin
              fbreakdown =  1.0;
            end
            else begin
              if ((vav > ((- __alphaav) * __VBRGATD_i))) begin
                if ((__PBRGATD_i ==  4.0)) begin
                  tmp = ((((vav * __VBRinvgat_d) * (vav * __VBRinvgat_d)) * (vav * __VBRinvgat_d)) * (vav * __VBRinvgat_d));
                end
                else begin
                  tmp = pow(abs((vav * __VBRinvgat_d)), __PBRGATD_i);
                end
                fbreakdown = ( 1.0 / ( 1.0 - tmp));
              end
              else begin
                fbreakdown = (__fstopgat_d + ((vav + (__alphaav * __VBRGATD_i)) * __slopegat_d));
              end
            end
            ijungat = ((((id + isrh) + itat) + ibbt) * fbreakdown);
          end
          __I3 = (((__ABDRAIN_i * ijunbot) + (__LSDRAIN_i * ijunsti)) + (__LGDRAIN_i * ijungat));
          vbbt =  0.0;
          two_psistar =  0.0;
          if ((! (((__ABDRAIN_i ==  0.0) && (__LSDRAIN_i ==  0.0)) && (__LGDRAIN_i ==  0.0)))) begin
            h1 = ((__vch_d *  4.0) * __vch_d);
            h2 = (__vch_d / __vfmin_d);
            h2d = (__V4 + (__vch_d * h2));
            h3 = (__vfmin_d + h2d);
            h4 = (__vfmin_d - h2d);
            h5 = sqrt(((h4 * h4) + h1));
            vj = (((__V4 * __vfmin_d) / (h3 + h5)) *  2.0);
            if ((__V4 < __VMAX_d)) begin
              if ((abs(((__V4 * __phitdinv) *  0.5)) <  230.258509299405)) begin
                zinv = exp(((__V4 * __phitdinv) *  0.5));
              end
              else begin
                if ((((__V4 * __phitdinv) *  0.5) <  0.0)) begin
                  zinv = ( 100.0e-102 / (((-230.258509299405 - ((__V4 * __phitdinv) *  0.5)) * ((((-230.258509299405 - ((__V4 * __phitdinv) *  0.5)) * (((-230.258509299405 - ((__V4 * __phitdinv) *  0.5)) *  0.333333333333333) +  1.0)) *  0.5) +  1.0)) +  1.0));
                end
                else begin
                  zinv = ((((((__V4 * __phitdinv) *  0.5) -  230.258509299405) * ((((((__V4 * __phitdinv) *  0.5) -  230.258509299405) * (((((__V4 * __phitdinv) *  0.5) -  230.258509299405) *  0.333333333333333) +  1.0)) *  0.5) +  1.0)) +  1.0) *  10.0e+99);
                end
              end
              idmult = (zinv * zinv);
            end
            else begin
              idmult = ((((__V4 - __VMAX_d) * __phitdinv) +  1.0) * __exp_VMAX_over_phitd_d);
              zinv = sqrt(idmult);
            end
            idmult = (idmult -  1.0);
            z = ( 1.0 / zinv);
            if ((__V4 >  0.0)) begin
              two_psistar = ((__phitd * ln(((z +  2.0) + sqrt(((z +  1.0) * (z +  3.0)))))) *  2.0);
            end
            else begin
              two_psistar = ((- __V4) + ((__phitd * ln((((zinv *  2.0) +  1.0) + sqrt(((zinv +  1.0) * ((zinv *  3.0) +  1.0)))))) *  2.0));
            end
            vjlim = (__vbimin_d - two_psistar);
            vjsrh = (((__V4 + vjlim) - sqrt((((__V4 - vjlim) * (__V4 - vjlim)) + ((__phitd *  4.0) * __phitd)))) *  0.5);
            vbbt = (((__V4 + __vbbtlim_d) - sqrt((((__V4 - __vbbtlim_d) * (__V4 - __vbbtlim_d)) + ((__phitr *  4.0) * __phitr)))) *  0.5);
            vav = ((__V4 - sqrt(((__V4 * __V4) +  4.0e-12))) *  0.5);
          end
          if ((__ABDRAIN_i ==  0.0)) begin
            ijunbot =  0.0;
            qjunbot =  0.0;
          end
          else begin
            if ((__one_minus_PBOT_d ==  0.5)) begin
              tmp = sqrt(( 1.0 - (vj * __vbiinvbot_d)));
            end
            else begin
              tmp = pow(( 1.0 - (vj * __vbiinvbot_d)), __one_minus_PBOT_d);
            end
            qjunbot = ((__qprefbot_d * ( 1.0 - tmp)) + (__qpref2bot_d * (__V4 - vj)));
            id = (__idsatbot_d * idmult);
            if (((__CSRHBOTD_i ==  0.0) && (__CTATBOTD_i ==  0.0))) begin
              isrh =  0.0;
            end
            else begin
              vbi_minus_vjsrh = (__vbibot_d - vjsrh);
              wsrhstep = ( 1.0 - sqrt(( 1.0 - (two_psistar / vbi_minus_vjsrh))));
              if ((__PBOTD_i ==  0.5)) begin
                dwsrh =  0.0;
              end
              else begin
                dwsrh = (((((wsrhstep * wsrhstep) * ln(wsrhstep)) / ( 1.0 - wsrhstep)) + wsrhstep) * ( 1.0 - (__PBOTD_i *  2.0)));
              end
              wsrh = (wsrhstep + dwsrh);
              if ((__PBOTD_i ==  0.5)) begin
                tmp = sqrt((vbi_minus_vjsrh * __VBIRBOTinv_d));
              end
              else begin
                tmp = pow((vbi_minus_vjsrh * __VBIRBOTinv_d), __PBOTD_i);
              end
              wdep = (__wdepnulrbot_d * tmp);
              asrh = (__ftdbot_d * ((zinv -  1.0) * wdep));
              isrh = (__CSRHBOTD_i * (asrh * wsrh));
            end
            if ((__CTATBOTD_i ==  0.0)) begin
              itat =  0.0;
            end
            else begin
              btat = (__btatpartbot_d * ((wdep * __one_minus_PBOT_d) / vbi_minus_vjsrh));
              twoatatoverthreebtat = ((__atatbot_d *  0.666666666666667) / btat);
              umaxbeforelimiting = (twoatatoverthreebtat * twoatatoverthreebtat);
              umax = sqrt(((umaxbeforelimiting * umaxbeforelimiting) / ((umaxbeforelimiting * umaxbeforelimiting) +  1.0)));
              sqrtumax = sqrt(umax);
              umaxpoweronepointfive = (umax * sqrtumax);
              if ((((- __PBOTD_i) * __one_over_one_minus_PBOT_d) == -1.0)) begin
                wgamma = ( 1.0 / ((btat * umaxpoweronepointfive) +  1.0));
              end
              else begin
                wgamma = pow(((btat * umaxpoweronepointfive) +  1.0), ((- __PBOTD_i) * __one_over_one_minus_PBOT_d));
              end
              wtat = ((wsrh * wgamma) / (wsrh + wgamma));
              ktat = sqrt(((btat / sqrtumax) *  0.375));
              ltat = (((twoatatoverthreebtat * sqrtumax) *  2.0) - umax);
              mtat = ((((__atatbot_d * twoatatoverthreebtat) * sqrtumax) - (__atatbot_d * umax)) + ((btat * umaxpoweronepointfive) *  0.5));
              xerfc = ((ltat -  1.0) * ktat);
              ysq = (xerfc * xerfc);
              if ((xerfc >  0.0)) begin
                terfc = ( 1.0 / ((__perfc * xerfc) +  1.0));
              end
              else begin
                terfc = ( 1.0 / ( 1.0 - (__perfc * xerfc)));
              end
              if ((((- ysq) + mtat) > -230.258509299405)) begin
                tmp = exp(((- ysq) + mtat));
              end
              else begin
                tmp = ( 100.0e-102 / (((-230.258509299405 - ((- ysq) + mtat)) * ((((-230.258509299405 - ((- ysq) + mtat)) * (((-230.258509299405 - ((- ysq) + mtat)) *  0.333333333333333) +  1.0)) *  0.5) +  1.0)) +  1.0));
              end
              erfcpos = ((((terfc *  0.29214664) + (__berfc * (terfc * terfc))) + (__cerfc * ((terfc * terfc) * terfc))) * tmp);
              if ((xerfc >  0.0)) begin
                erfctimesexpmtat = erfcpos;
              end
              else begin
                if ((mtat > -230.258509299405)) begin
                  tmp = exp(mtat);
                end
                else begin
                  tmp = ( 100.0e-102 / (((-230.258509299405 - mtat) * ((((-230.258509299405 - mtat) * (((-230.258509299405 - mtat) *  0.333333333333333) +  1.0)) *  0.5) +  1.0)) +  1.0));
                end
                erfctimesexpmtat = ((tmp *  2.0) - erfcpos);
              end
              gammamax = (((__atatbot_d * erfctimesexpmtat) / ktat) *  0.886226925452758);
              itat = (__CTATBOTD_i * ((asrh * gammamax) * wtat));
            end
            if ((__CBBTBOTD_i ==  0.0)) begin
              ibbt =  0.0;
            end
            else begin
              if ((__PBOTD_i ==  0.5)) begin
                tmp = sqrt(((__VBIRBOTD_i - vbbt) * __VBIRBOTinv_d));
              end
              else begin
                tmp = pow(((__VBIRBOTD_i - vbbt) * __VBIRBOTinv_d), __PBOTD_i);
              end
              Fmaxr = (__one_over_one_minus_PBOT_d * (((__VBIRBOTD_i - vbbt) * __wdepnulrinvbot_d) / tmp));
              if ((abs(((- __fbbtbot_d) / Fmaxr)) <  230.258509299405)) begin
                tmp = exp(((- __fbbtbot_d) / Fmaxr));
              end
              else begin
                if ((((- __fbbtbot_d) / Fmaxr) <  0.0)) begin
                  tmp = ( 100.0e-102 / (((-230.258509299405 - ((- __fbbtbot_d) / Fmaxr)) * ((((-230.258509299405 - ((- __fbbtbot_d) / Fmaxr)) * (((-230.258509299405 - ((- __fbbtbot_d) / Fmaxr)) *  0.333333333333333) +  1.0)) *  0.5) +  1.0)) +  1.0));
                end
                else begin
                  tmp = ((((((- __fbbtbot_d) / Fmaxr) -  230.258509299405) * ((((((- __fbbtbot_d) / Fmaxr) -  230.258509299405) * (((((- __fbbtbot_d) / Fmaxr) -  230.258509299405) *  0.333333333333333) +  1.0)) *  0.5) +  1.0)) +  1.0) *  10.0e+99);
                end
              end
              ibbt = (__CBBTBOTD_i * (((__V4 * Fmaxr) * Fmaxr) * tmp));
            end
            if ((__VBRBOTD_i >  1.0e+3)) begin
              fbreakdown =  1.0;
            end
            else begin
              if ((vav > ((- __alphaav) * __VBRBOTD_i))) begin
                if ((__PBRBOTD_i ==  4.0)) begin
                  tmp = ((((vav * __VBRinvbot_d) * (vav * __VBRinvbot_d)) * (vav * __VBRinvbot_d)) * (vav * __VBRinvbot_d));
                end
                else begin
                  tmp = pow(abs((vav * __VBRinvbot_d)), __PBRBOTD_i);
                end
                fbreakdown = ( 1.0 / ( 1.0 - tmp));
              end
              else begin
                fbreakdown = (__fstopbot_d + ((vav + (__alphaav * __VBRBOTD_i)) * __slopebot_d));
              end
            end
            ijunbot = ((((id + isrh) + itat) + ibbt) * fbreakdown);
          end
          if ((__LSDRAIN_i ==  0.0)) begin
            ijunsti =  0.0;
            qjunsti =  0.0;
          end
          else begin
            if ((__one_minus_PSTI_d ==  0.5)) begin
              tmp = sqrt(( 1.0 - (vj * __vbiinvsti_d)));
            end
            else begin
              tmp = pow(( 1.0 - (vj * __vbiinvsti_d)), __one_minus_PSTI_d);
            end
            qjunsti = ((__qprefsti_d * ( 1.0 - tmp)) + (__qpref2sti_d * (__V4 - vj)));
            id = (__idsatsti_d * idmult);
            if (((__CSRHSTID_i ==  0.0) && (__CTATSTID_i ==  0.0))) begin
              isrh =  0.0;
            end
            else begin
              vbi_minus_vjsrh = (__vbisti_d - vjsrh);
              wsrhstep = ( 1.0 - sqrt(( 1.0 - (two_psistar / vbi_minus_vjsrh))));
              if ((__PSTID_i ==  0.5)) begin
                dwsrh =  0.0;
              end
              else begin
                dwsrh = (((((wsrhstep * wsrhstep) * ln(wsrhstep)) / ( 1.0 - wsrhstep)) + wsrhstep) * ( 1.0 - (__PSTID_i *  2.0)));
              end
              wsrh = (wsrhstep + dwsrh);
              if ((__PSTID_i ==  0.5)) begin
                tmp = sqrt((vbi_minus_vjsrh * __VBIRSTIinv_d));
              end
              else begin
                tmp = pow((vbi_minus_vjsrh * __VBIRSTIinv_d), __PSTID_i);
              end
              wdep = (__wdepnulrsti_d * tmp);
              asrh = (__ftdsti_d * ((zinv -  1.0) * wdep));
              isrh = (__CSRHSTID_i * (asrh * wsrh));
            end
            if ((__CTATSTID_i ==  0.0)) begin
              itat =  0.0;
            end
            else begin
              btat = (__btatpartsti_d * ((wdep * __one_minus_PSTI_d) / vbi_minus_vjsrh));
              twoatatoverthreebtat = ((__atatsti_d *  0.666666666666667) / btat);
              umaxbeforelimiting = (twoatatoverthreebtat * twoatatoverthreebtat);
              umax = sqrt(((umaxbeforelimiting * umaxbeforelimiting) / ((umaxbeforelimiting * umaxbeforelimiting) +  1.0)));
              sqrtumax = sqrt(umax);
              umaxpoweronepointfive = (umax * sqrtumax);
              if ((((- __PSTID_i) * __one_over_one_minus_PSTI_d) == -1.0)) begin
                wgamma = ( 1.0 / ((btat * umaxpoweronepointfive) +  1.0));
              end
              else begin
                wgamma = pow(((btat * umaxpoweronepointfive) +  1.0), ((- __PSTID_i) * __one_over_one_minus_PSTI_d));
              end
              wtat = ((wsrh * wgamma) / (wsrh + wgamma));
              ktat = sqrt(((btat / sqrtumax) *  0.375));
              ltat = (((twoatatoverthreebtat * sqrtumax) *  2.0) - umax);
              mtat = ((((__atatsti_d * twoatatoverthreebtat) * sqrtumax) - (__atatsti_d * umax)) + ((btat * umaxpoweronepointfive) *  0.5));
              xerfc = ((ltat -  1.0) * ktat);
              ysq = (xerfc * xerfc);
              if ((xerfc >  0.0)) begin
                terfc = ( 1.0 / ((__perfc * xerfc) +  1.0));
              end
              else begin
                terfc = ( 1.0 / ( 1.0 - (__perfc * xerfc)));
              end
              if ((((- ysq) + mtat) > -230.258509299405)) begin
                tmp = exp(((- ysq) + mtat));
              end
              else begin
                tmp = ( 100.0e-102 / (((-230.258509299405 - ((- ysq) + mtat)) * ((((-230.258509299405 - ((- ysq) + mtat)) * (((-230.258509299405 - ((- ysq) + mtat)) *  0.333333333333333) +  1.0)) *  0.5) +  1.0)) +  1.0));
              end
              erfcpos = ((((terfc *  0.29214664) + (__berfc * (terfc * terfc))) + (__cerfc * ((terfc * terfc) * terfc))) * tmp);
              if ((xerfc >  0.0)) begin
                erfctimesexpmtat = erfcpos;
              end
              else begin
                if ((mtat > -230.258509299405)) begin
                  tmp = exp(mtat);
                end
                else begin
                  tmp = ( 100.0e-102 / (((-230.258509299405 - mtat) * ((((-230.258509299405 - mtat) * (((-230.258509299405 - mtat) *  0.333333333333333) +  1.0)) *  0.5) +  1.0)) +  1.0));
                end
                erfctimesexpmtat = ((tmp *  2.0) - erfcpos);
              end
              gammamax = (((__atatsti_d * erfctimesexpmtat) / ktat) *  0.886226925452758);
              itat = (__CTATSTID_i * ((asrh * gammamax) * wtat));
            end
            if ((__CBBTSTID_i ==  0.0)) begin
              ibbt =  0.0;
            end
            else begin
              if ((__PSTID_i ==  0.5)) begin
                tmp = sqrt(((__VBIRSTID_i - vbbt) * __VBIRSTIinv_d));
              end
              else begin
                tmp = pow(((__VBIRSTID_i - vbbt) * __VBIRSTIinv_d), __PSTID_i);
              end
              Fmaxr = (__one_over_one_minus_PSTI_d * (((__VBIRSTID_i - vbbt) * __wdepnulrinvsti_d) / tmp));
              if ((abs(((- __fbbtsti_d) / Fmaxr)) <  230.258509299405)) begin
                tmp = exp(((- __fbbtsti_d) / Fmaxr));
              end
              else begin
                if ((((- __fbbtsti_d) / Fmaxr) <  0.0)) begin
                  tmp = ( 100.0e-102 / (((-230.258509299405 - ((- __fbbtsti_d) / Fmaxr)) * ((((-230.258509299405 - ((- __fbbtsti_d) / Fmaxr)) * (((-230.258509299405 - ((- __fbbtsti_d) / Fmaxr)) *  0.333333333333333) +  1.0)) *  0.5) +  1.0)) +  1.0));
                end
                else begin
                  tmp = ((((((- __fbbtsti_d) / Fmaxr) -  230.258509299405) * ((((((- __fbbtsti_d) / Fmaxr) -  230.258509299405) * (((((- __fbbtsti_d) / Fmaxr) -  230.258509299405) *  0.333333333333333) +  1.0)) *  0.5) +  1.0)) +  1.0) *  10.0e+99);
                end
              end
              ibbt = (__CBBTSTID_i * (((__V4 * Fmaxr) * Fmaxr) * tmp));
            end
            if ((__VBRSTID_i >  1.0e+3)) begin
              fbreakdown =  1.0;
            end
            else begin
              if ((vav > ((- __alphaav) * __VBRSTID_i))) begin
                if ((__PBRSTID_i ==  4.0)) begin
                  tmp = ((((vav * __VBRinvsti_d) * (vav * __VBRinvsti_d)) * (vav * __VBRinvsti_d)) * (vav * __VBRinvsti_d));
                end
                else begin
                  tmp = pow(abs((vav * __VBRinvsti_d)), __PBRSTID_i);
                end
                fbreakdown = ( 1.0 / ( 1.0 - tmp));
              end
              else begin
                fbreakdown = (__fstopsti_d + ((vav + (__alphaav * __VBRSTID_i)) * __slopesti_d));
              end
            end
            ijunsti = ((((id + isrh) + itat) + ibbt) * fbreakdown);
          end
          if ((__LGDRAIN_i ==  0.0)) begin
            ijungat =  0.0;
            qjungat =  0.0;
          end
          else begin
            if ((__one_minus_PGAT_d ==  0.5)) begin
              tmp = sqrt(( 1.0 - (vj * __vbiinvgat_d)));
            end
            else begin
              tmp = pow(( 1.0 - (vj * __vbiinvgat_d)), __one_minus_PGAT_d);
            end
            qjungat = ((__qprefgat_d * ( 1.0 - tmp)) + (__qpref2gat_d * (__V4 - vj)));
            id = (__idsatgat_d * idmult);
            if (((__CSRHGATD_i ==  0.0) && (__CTATGATD_i ==  0.0))) begin
              isrh =  0.0;
            end
            else begin
              vbi_minus_vjsrh = (__vbigat_d - vjsrh);
              wsrhstep = ( 1.0 - sqrt(( 1.0 - (two_psistar / vbi_minus_vjsrh))));
              if ((__PGATD_i ==  0.5)) begin
                dwsrh =  0.0;
              end
              else begin
                dwsrh = (((((wsrhstep * wsrhstep) * ln(wsrhstep)) / ( 1.0 - wsrhstep)) + wsrhstep) * ( 1.0 - (__PGATD_i *  2.0)));
              end
              wsrh = (wsrhstep + dwsrh);
              if ((__PGATD_i ==  0.5)) begin
                tmp = sqrt((vbi_minus_vjsrh * __VBIRGATinv_d));
              end
              else begin
                tmp = pow((vbi_minus_vjsrh * __VBIRGATinv_d), __PGATD_i);
              end
              wdep = (__wdepnulrgat_d * tmp);
              asrh = (__ftdgat_d * ((zinv -  1.0) * wdep));
              isrh = (__CSRHGATD_i * (asrh * wsrh));
            end
            if ((__CTATGATD_i ==  0.0)) begin
              itat =  0.0;
            end
            else begin
              btat = (__btatpartgat_d * ((wdep * __one_minus_PGAT_d) / vbi_minus_vjsrh));
              twoatatoverthreebtat = ((__atatgat_d *  0.666666666666667) / btat);
              umaxbeforelimiting = (twoatatoverthreebtat * twoatatoverthreebtat);
              umax = sqrt(((umaxbeforelimiting * umaxbeforelimiting) / ((umaxbeforelimiting * umaxbeforelimiting) +  1.0)));
              sqrtumax = sqrt(umax);
              umaxpoweronepointfive = (umax * sqrtumax);
              if ((((- __PGATD_i) * __one_over_one_minus_PGAT_d) == -1.0)) begin
                wgamma = ( 1.0 / ((btat * umaxpoweronepointfive) +  1.0));
              end
              else begin
                wgamma = pow(((btat * umaxpoweronepointfive) +  1.0), ((- __PGATD_i) * __one_over_one_minus_PGAT_d));
              end
              wtat = ((wsrh * wgamma) / (wsrh + wgamma));
              ktat = sqrt(((btat / sqrtumax) *  0.375));
              ltat = (((twoatatoverthreebtat * sqrtumax) *  2.0) - umax);
              mtat = ((((__atatgat_d * twoatatoverthreebtat) * sqrtumax) - (__atatgat_d * umax)) + ((btat * umaxpoweronepointfive) *  0.5));
              xerfc = ((ltat -  1.0) * ktat);
              ysq = (xerfc * xerfc);
              if ((xerfc >  0.0)) begin
                terfc = ( 1.0 / ((__perfc * xerfc) +  1.0));
              end
              else begin
                terfc = ( 1.0 / ( 1.0 - (__perfc * xerfc)));
              end
              if ((((- ysq) + mtat) > -230.258509299405)) begin
                tmp = exp(((- ysq) + mtat));
              end
              else begin
                tmp = ( 100.0e-102 / (((-230.258509299405 - ((- ysq) + mtat)) * ((((-230.258509299405 - ((- ysq) + mtat)) * (((-230.258509299405 - ((- ysq) + mtat)) *  0.333333333333333) +  1.0)) *  0.5) +  1.0)) +  1.0));
              end
              erfcpos = ((((terfc *  0.29214664) + (__berfc * (terfc * terfc))) + (__cerfc * ((terfc * terfc) * terfc))) * tmp);
              if ((xerfc >  0.0)) begin
                erfctimesexpmtat = erfcpos;
              end
              else begin
                if ((mtat > -230.258509299405)) begin
                  tmp = exp(mtat);
                end
                else begin
                  tmp = ( 100.0e-102 / (((-230.258509299405 - mtat) * ((((-230.258509299405 - mtat) * (((-230.258509299405 - mtat) *  0.333333333333333) +  1.0)) *  0.5) +  1.0)) +  1.0));
                end
                erfctimesexpmtat = ((tmp *  2.0) - erfcpos);
              end
              gammamax = (((__atatgat_d * erfctimesexpmtat) / ktat) *  0.886226925452758);
              itat = (__CTATGATD_i * ((asrh * gammamax) * wtat));
            end
            if ((__CBBTGATD_i ==  0.0)) begin
              ibbt =  0.0;
            end
            else begin
              if ((__PGATD_i ==  0.5)) begin
                tmp = sqrt(((__VBIRGATD_i - vbbt) * __VBIRGATinv_d));
              end
              else begin
                tmp = pow(((__VBIRGATD_i - vbbt) * __VBIRGATinv_d), __PGATD_i);
              end
              Fmaxr = (__one_over_one_minus_PGAT_d * (((__VBIRGATD_i - vbbt) * __wdepnulrinvgat_d) / tmp));
              if ((abs(((- __fbbtgat_d) / Fmaxr)) <  230.258509299405)) begin
                tmp = exp(((- __fbbtgat_d) / Fmaxr));
              end
              else begin
                if ((((- __fbbtgat_d) / Fmaxr) <  0.0)) begin
                  tmp = ( 100.0e-102 / (((-230.258509299405 - ((- __fbbtgat_d) / Fmaxr)) * ((((-230.258509299405 - ((- __fbbtgat_d) / Fmaxr)) * (((-230.258509299405 - ((- __fbbtgat_d) / Fmaxr)) *  0.333333333333333) +  1.0)) *  0.5) +  1.0)) +  1.0));
                end
                else begin
                  tmp = ((((((- __fbbtgat_d) / Fmaxr) -  230.258509299405) * ((((((- __fbbtgat_d) / Fmaxr) -  230.258509299405) * (((((- __fbbtgat_d) / Fmaxr) -  230.258509299405) *  0.333333333333333) +  1.0)) *  0.5) +  1.0)) +  1.0) *  10.0e+99);
                end
              end
              ibbt = (__CBBTGATD_i * (((__V4 * Fmaxr) * Fmaxr) * tmp));
            end
            if ((__VBRGATD_i >  1.0e+3)) begin
              fbreakdown =  1.0;
            end
            else begin
              if ((vav > ((- __alphaav) * __VBRGATD_i))) begin
                if ((__PBRGATD_i ==  4.0)) begin
                  tmp = ((((vav * __VBRinvgat_d) * (vav * __VBRinvgat_d)) * (vav * __VBRinvgat_d)) * (vav * __VBRinvgat_d));
                end
                else begin
                  tmp = pow(abs((vav * __VBRinvgat_d)), __PBRGATD_i);
                end
                fbreakdown = ( 1.0 / ( 1.0 - tmp));
              end
              else begin
                fbreakdown = (__fstopgat_d + ((vav + (__alphaav * __VBRGATD_i)) * __slopegat_d));
              end
            end
            ijungat = ((((id + isrh) + itat) + ibbt) * fbreakdown);
          end
          __I4 = (((__ABDRAIN_i * ijunbot) + (__LSDRAIN_i * ijunsti)) + (__LGDRAIN_i * ijungat));
          vbbt =  0.0;
          two_psistar =  0.0;
          if ((! (((__ABDRAIN_i ==  0.0) && (__LSDRAIN_i ==  0.0)) && (__LGDRAIN_i ==  0.0)))) begin
            h1 = ((__vch_d *  4.0) * __vch_d);
            h2 = (__vch_d / __vfmin_d);
            h2d = (__V5 + (__vch_d * h2));
            h3 = (__vfmin_d + h2d);
            h4 = (__vfmin_d - h2d);
            h5 = sqrt(((h4 * h4) + h1));
            vj = (((__V5 * __vfmin_d) / (h3 + h5)) *  2.0);
            if ((__V5 < __VMAX_d)) begin
              if ((abs(((__V5 * __phitdinv) *  0.5)) <  230.258509299405)) begin
                zinv = exp(((__V5 * __phitdinv) *  0.5));
              end
              else begin
                if ((((__V5 * __phitdinv) *  0.5) <  0.0)) begin
                  zinv = ( 100.0e-102 / (((-230.258509299405 - ((__V5 * __phitdinv) *  0.5)) * ((((-230.258509299405 - ((__V5 * __phitdinv) *  0.5)) * (((-230.258509299405 - ((__V5 * __phitdinv) *  0.5)) *  0.333333333333333) +  1.0)) *  0.5) +  1.0)) +  1.0));
                end
                else begin
                  zinv = ((((((__V5 * __phitdinv) *  0.5) -  230.258509299405) * ((((((__V5 * __phitdinv) *  0.5) -  230.258509299405) * (((((__V5 * __phitdinv) *  0.5) -  230.258509299405) *  0.333333333333333) +  1.0)) *  0.5) +  1.0)) +  1.0) *  10.0e+99);
                end
              end
              idmult = (zinv * zinv);
            end
            else begin
              idmult = ((((__V5 - __VMAX_d) * __phitdinv) +  1.0) * __exp_VMAX_over_phitd_d);
              zinv = sqrt(idmult);
            end
            idmult = (idmult -  1.0);
            z = ( 1.0 / zinv);
            if ((__V5 >  0.0)) begin
              two_psistar = ((__phitd * ln(((z +  2.0) + sqrt(((z +  1.0) * (z +  3.0)))))) *  2.0);
            end
            else begin
              two_psistar = ((- __V5) + ((__phitd * ln((((zinv *  2.0) +  1.0) + sqrt(((zinv +  1.0) * ((zinv *  3.0) +  1.0)))))) *  2.0));
            end
            vjlim = (__vbimin_d - two_psistar);
            vjsrh = (((__V5 + vjlim) - sqrt((((__V5 - vjlim) * (__V5 - vjlim)) + ((__phitd *  4.0) * __phitd)))) *  0.5);
            vbbt = (((__V5 + __vbbtlim_d) - sqrt((((__V5 - __vbbtlim_d) * (__V5 - __vbbtlim_d)) + ((__phitr *  4.0) * __phitr)))) *  0.5);
            vav = ((__V5 - sqrt(((__V5 * __V5) +  4.0e-12))) *  0.5);
          end
          if ((__ABDRAIN_i ==  0.0)) begin
            ijunbot =  0.0;
            qjunbot =  0.0;
          end
          else begin
            if ((__one_minus_PBOT_d ==  0.5)) begin
              tmp = sqrt(( 1.0 - (vj * __vbiinvbot_d)));
            end
            else begin
              tmp = pow(( 1.0 - (vj * __vbiinvbot_d)), __one_minus_PBOT_d);
            end
            qjunbot = ((__qprefbot_d * ( 1.0 - tmp)) + (__qpref2bot_d * (__V5 - vj)));
            id = (__idsatbot_d * idmult);
            if (((__CSRHBOTD_i ==  0.0) && (__CTATBOTD_i ==  0.0))) begin
              isrh =  0.0;
            end
            else begin
              vbi_minus_vjsrh = (__vbibot_d - vjsrh);
              wsrhstep = ( 1.0 - sqrt(( 1.0 - (two_psistar / vbi_minus_vjsrh))));
              if ((__PBOTD_i ==  0.5)) begin
                dwsrh =  0.0;
              end
              else begin
                dwsrh = (((((wsrhstep * wsrhstep) * ln(wsrhstep)) / ( 1.0 - wsrhstep)) + wsrhstep) * ( 1.0 - (__PBOTD_i *  2.0)));
              end
              wsrh = (wsrhstep + dwsrh);
              if ((__PBOTD_i ==  0.5)) begin
                tmp = sqrt((vbi_minus_vjsrh * __VBIRBOTinv_d));
              end
              else begin
                tmp = pow((vbi_minus_vjsrh * __VBIRBOTinv_d), __PBOTD_i);
              end
              wdep = (__wdepnulrbot_d * tmp);
              asrh = (__ftdbot_d * ((zinv -  1.0) * wdep));
              isrh = (__CSRHBOTD_i * (asrh * wsrh));
            end
            if ((__CTATBOTD_i ==  0.0)) begin
              itat =  0.0;
            end
            else begin
              btat = (__btatpartbot_d * ((wdep * __one_minus_PBOT_d) / vbi_minus_vjsrh));
              twoatatoverthreebtat = ((__atatbot_d *  0.666666666666667) / btat);
              umaxbeforelimiting = (twoatatoverthreebtat * twoatatoverthreebtat);
              umax = sqrt(((umaxbeforelimiting * umaxbeforelimiting) / ((umaxbeforelimiting * umaxbeforelimiting) +  1.0)));
              sqrtumax = sqrt(umax);
              umaxpoweronepointfive = (umax * sqrtumax);
              if ((((- __PBOTD_i) * __one_over_one_minus_PBOT_d) == -1.0)) begin
                wgamma = ( 1.0 / ((btat * umaxpoweronepointfive) +  1.0));
              end
              else begin
                wgamma = pow(((btat * umaxpoweronepointfive) +  1.0), ((- __PBOTD_i) * __one_over_one_minus_PBOT_d));
              end
              wtat = ((wsrh * wgamma) / (wsrh + wgamma));
              ktat = sqrt(((btat / sqrtumax) *  0.375));
              ltat = (((twoatatoverthreebtat * sqrtumax) *  2.0) - umax);
              mtat = ((((__atatbot_d * twoatatoverthreebtat) * sqrtumax) - (__atatbot_d * umax)) + ((btat * umaxpoweronepointfive) *  0.5));
              xerfc = ((ltat -  1.0) * ktat);
              ysq = (xerfc * xerfc);
              if ((xerfc >  0.0)) begin
                terfc = ( 1.0 / ((__perfc * xerfc) +  1.0));
              end
              else begin
                terfc = ( 1.0 / ( 1.0 - (__perfc * xerfc)));
              end
              if ((((- ysq) + mtat) > -230.258509299405)) begin
                tmp = exp(((- ysq) + mtat));
              end
              else begin
                tmp = ( 100.0e-102 / (((-230.258509299405 - ((- ysq) + mtat)) * ((((-230.258509299405 - ((- ysq) + mtat)) * (((-230.258509299405 - ((- ysq) + mtat)) *  0.333333333333333) +  1.0)) *  0.5) +  1.0)) +  1.0));
              end
              erfcpos = ((((terfc *  0.29214664) + (__berfc * (terfc * terfc))) + (__cerfc * ((terfc * terfc) * terfc))) * tmp);
              if ((xerfc >  0.0)) begin
                erfctimesexpmtat = erfcpos;
              end
              else begin
                if ((mtat > -230.258509299405)) begin
                  tmp = exp(mtat);
                end
                else begin
                  tmp = ( 100.0e-102 / (((-230.258509299405 - mtat) * ((((-230.258509299405 - mtat) * (((-230.258509299405 - mtat) *  0.333333333333333) +  1.0)) *  0.5) +  1.0)) +  1.0));
                end
                erfctimesexpmtat = ((tmp *  2.0) - erfcpos);
              end
              gammamax = (((__atatbot_d * erfctimesexpmtat) / ktat) *  0.886226925452758);
              itat = (__CTATBOTD_i * ((asrh * gammamax) * wtat));
            end
            if ((__CBBTBOTD_i ==  0.0)) begin
              ibbt =  0.0;
            end
            else begin
              if ((__PBOTD_i ==  0.5)) begin
                tmp = sqrt(((__VBIRBOTD_i - vbbt) * __VBIRBOTinv_d));
              end
              else begin
                tmp = pow(((__VBIRBOTD_i - vbbt) * __VBIRBOTinv_d), __PBOTD_i);
              end
              Fmaxr = (__one_over_one_minus_PBOT_d * (((__VBIRBOTD_i - vbbt) * __wdepnulrinvbot_d) / tmp));
              if ((abs(((- __fbbtbot_d) / Fmaxr)) <  230.258509299405)) begin
                tmp = exp(((- __fbbtbot_d) / Fmaxr));
              end
              else begin
                if ((((- __fbbtbot_d) / Fmaxr) <  0.0)) begin
                  tmp = ( 100.0e-102 / (((-230.258509299405 - ((- __fbbtbot_d) / Fmaxr)) * ((((-230.258509299405 - ((- __fbbtbot_d) / Fmaxr)) * (((-230.258509299405 - ((- __fbbtbot_d) / Fmaxr)) *  0.333333333333333) +  1.0)) *  0.5) +  1.0)) +  1.0));
                end
                else begin
                  tmp = ((((((- __fbbtbot_d) / Fmaxr) -  230.258509299405) * ((((((- __fbbtbot_d) / Fmaxr) -  230.258509299405) * (((((- __fbbtbot_d) / Fmaxr) -  230.258509299405) *  0.333333333333333) +  1.0)) *  0.5) +  1.0)) +  1.0) *  10.0e+99);
                end
              end
              ibbt = (__CBBTBOTD_i * (((__V5 * Fmaxr) * Fmaxr) * tmp));
            end
            if ((__VBRBOTD_i >  1.0e+3)) begin
              fbreakdown =  1.0;
            end
            else begin
              if ((vav > ((- __alphaav) * __VBRBOTD_i))) begin
                if ((__PBRBOTD_i ==  4.0)) begin
                  tmp = ((((vav * __VBRinvbot_d) * (vav * __VBRinvbot_d)) * (vav * __VBRinvbot_d)) * (vav * __VBRinvbot_d));
                end
                else begin
                  tmp = pow(abs((vav * __VBRinvbot_d)), __PBRBOTD_i);
                end
                fbreakdown = ( 1.0 / ( 1.0 - tmp));
              end
              else begin
                fbreakdown = (__fstopbot_d + ((vav + (__alphaav * __VBRBOTD_i)) * __slopebot_d));
              end
            end
            ijunbot = ((((id + isrh) + itat) + ibbt) * fbreakdown);
          end
          if ((__LSDRAIN_i ==  0.0)) begin
            ijunsti =  0.0;
            qjunsti =  0.0;
          end
          else begin
            if ((__one_minus_PSTI_d ==  0.5)) begin
              tmp = sqrt(( 1.0 - (vj * __vbiinvsti_d)));
            end
            else begin
              tmp = pow(( 1.0 - (vj * __vbiinvsti_d)), __one_minus_PSTI_d);
            end
            qjunsti = ((__qprefsti_d * ( 1.0 - tmp)) + (__qpref2sti_d * (__V5 - vj)));
            id = (__idsatsti_d * idmult);
            if (((__CSRHSTID_i ==  0.0) && (__CTATSTID_i ==  0.0))) begin
              isrh =  0.0;
            end
            else begin
              vbi_minus_vjsrh = (__vbisti_d - vjsrh);
              wsrhstep = ( 1.0 - sqrt(( 1.0 - (two_psistar / vbi_minus_vjsrh))));
              if ((__PSTID_i ==  0.5)) begin
                dwsrh =  0.0;
              end
              else begin
                dwsrh = (((((wsrhstep * wsrhstep) * ln(wsrhstep)) / ( 1.0 - wsrhstep)) + wsrhstep) * ( 1.0 - (__PSTID_i *  2.0)));
              end
              wsrh = (wsrhstep + dwsrh);
              if ((__PSTID_i ==  0.5)) begin
                tmp = sqrt((vbi_minus_vjsrh * __VBIRSTIinv_d));
              end
              else begin
                tmp = pow((vbi_minus_vjsrh * __VBIRSTIinv_d), __PSTID_i);
              end
              wdep = (__wdepnulrsti_d * tmp);
              asrh = (__ftdsti_d * ((zinv -  1.0) * wdep));
              isrh = (__CSRHSTID_i * (asrh * wsrh));
            end
            if ((__CTATSTID_i ==  0.0)) begin
              itat =  0.0;
            end
            else begin
              btat = (__btatpartsti_d * ((wdep * __one_minus_PSTI_d) / vbi_minus_vjsrh));
              twoatatoverthreebtat = ((__atatsti_d *  0.666666666666667) / btat);
              umaxbeforelimiting = (twoatatoverthreebtat * twoatatoverthreebtat);
              umax = sqrt(((umaxbeforelimiting * umaxbeforelimiting) / ((umaxbeforelimiting * umaxbeforelimiting) +  1.0)));
              sqrtumax = sqrt(umax);
              umaxpoweronepointfive = (umax * sqrtumax);
              if ((((- __PSTID_i) * __one_over_one_minus_PSTI_d) == -1.0)) begin
                wgamma = ( 1.0 / ((btat * umaxpoweronepointfive) +  1.0));
              end
              else begin
                wgamma = pow(((btat * umaxpoweronepointfive) +  1.0), ((- __PSTID_i) * __one_over_one_minus_PSTI_d));
              end
              wtat = ((wsrh * wgamma) / (wsrh + wgamma));
              ktat = sqrt(((btat / sqrtumax) *  0.375));
              ltat = (((twoatatoverthreebtat * sqrtumax) *  2.0) - umax);
              mtat = ((((__atatsti_d * twoatatoverthreebtat) * sqrtumax) - (__atatsti_d * umax)) + ((btat * umaxpoweronepointfive) *  0.5));
              xerfc = ((ltat -  1.0) * ktat);
              ysq = (xerfc * xerfc);
              if ((xerfc >  0.0)) begin
                terfc = ( 1.0 / ((__perfc * xerfc) +  1.0));
              end
              else begin
                terfc = ( 1.0 / ( 1.0 - (__perfc * xerfc)));
              end
              if ((((- ysq) + mtat) > -230.258509299405)) begin
                tmp = exp(((- ysq) + mtat));
              end
              else begin
                tmp = ( 100.0e-102 / (((-230.258509299405 - ((- ysq) + mtat)) * ((((-230.258509299405 - ((- ysq) + mtat)) * (((-230.258509299405 - ((- ysq) + mtat)) *  0.333333333333333) +  1.0)) *  0.5) +  1.0)) +  1.0));
              end
              erfcpos = ((((terfc *  0.29214664) + (__berfc * (terfc * terfc))) + (__cerfc * ((terfc * terfc) * terfc))) * tmp);
              if ((xerfc >  0.0)) begin
                erfctimesexpmtat = erfcpos;
              end
              else begin
                if ((mtat > -230.258509299405)) begin
                  tmp = exp(mtat);
                end
                else begin
                  tmp = ( 100.0e-102 / (((-230.258509299405 - mtat) * ((((-230.258509299405 - mtat) * (((-230.258509299405 - mtat) *  0.333333333333333) +  1.0)) *  0.5) +  1.0)) +  1.0));
                end
                erfctimesexpmtat = ((tmp *  2.0) - erfcpos);
              end
              gammamax = (((__atatsti_d * erfctimesexpmtat) / ktat) *  0.886226925452758);
              itat = (__CTATSTID_i * ((asrh * gammamax) * wtat));
            end
            if ((__CBBTSTID_i ==  0.0)) begin
              ibbt =  0.0;
            end
            else begin
              if ((__PSTID_i ==  0.5)) begin
                tmp = sqrt(((__VBIRSTID_i - vbbt) * __VBIRSTIinv_d));
              end
              else begin
                tmp = pow(((__VBIRSTID_i - vbbt) * __VBIRSTIinv_d), __PSTID_i);
              end
              Fmaxr = (__one_over_one_minus_PSTI_d * (((__VBIRSTID_i - vbbt) * __wdepnulrinvsti_d) / tmp));
              if ((abs(((- __fbbtsti_d) / Fmaxr)) <  230.258509299405)) begin
                tmp = exp(((- __fbbtsti_d) / Fmaxr));
              end
              else begin
                if ((((- __fbbtsti_d) / Fmaxr) <  0.0)) begin
                  tmp = ( 100.0e-102 / (((-230.258509299405 - ((- __fbbtsti_d) / Fmaxr)) * ((((-230.258509299405 - ((- __fbbtsti_d) / Fmaxr)) * (((-230.258509299405 - ((- __fbbtsti_d) / Fmaxr)) *  0.333333333333333) +  1.0)) *  0.5) +  1.0)) +  1.0));
                end
                else begin
                  tmp = ((((((- __fbbtsti_d) / Fmaxr) -  230.258509299405) * ((((((- __fbbtsti_d) / Fmaxr) -  230.258509299405) * (((((- __fbbtsti_d) / Fmaxr) -  230.258509299405) *  0.333333333333333) +  1.0)) *  0.5) +  1.0)) +  1.0) *  10.0e+99);
                end
              end
              ibbt = (__CBBTSTID_i * (((__V5 * Fmaxr) * Fmaxr) * tmp));
            end
            if ((__VBRSTID_i >  1.0e+3)) begin
              fbreakdown =  1.0;
            end
            else begin
              if ((vav > ((- __alphaav) * __VBRSTID_i))) begin
                if ((__PBRSTID_i ==  4.0)) begin
                  tmp = ((((vav * __VBRinvsti_d) * (vav * __VBRinvsti_d)) * (vav * __VBRinvsti_d)) * (vav * __VBRinvsti_d));
                end
                else begin
                  tmp = pow(abs((vav * __VBRinvsti_d)), __PBRSTID_i);
                end
                fbreakdown = ( 1.0 / ( 1.0 - tmp));
              end
              else begin
                fbreakdown = (__fstopsti_d + ((vav + (__alphaav * __VBRSTID_i)) * __slopesti_d));
              end
            end
            ijunsti = ((((id + isrh) + itat) + ibbt) * fbreakdown);
          end
          if ((__LGDRAIN_i ==  0.0)) begin
            ijungat =  0.0;
            qjungat =  0.0;
          end
          else begin
            if ((__one_minus_PGAT_d ==  0.5)) begin
              tmp = sqrt(( 1.0 - (vj * __vbiinvgat_d)));
            end
            else begin
              tmp = pow(( 1.0 - (vj * __vbiinvgat_d)), __one_minus_PGAT_d);
            end
            qjungat = ((__qprefgat_d * ( 1.0 - tmp)) + (__qpref2gat_d * (__V5 - vj)));
            id = (__idsatgat_d * idmult);
            if (((__CSRHGATD_i ==  0.0) && (__CTATGATD_i ==  0.0))) begin
              isrh =  0.0;
            end
            else begin
              vbi_minus_vjsrh = (__vbigat_d - vjsrh);
              wsrhstep = ( 1.0 - sqrt(( 1.0 - (two_psistar / vbi_minus_vjsrh))));
              if ((__PGATD_i ==  0.5)) begin
                dwsrh =  0.0;
              end
              else begin
                dwsrh = (((((wsrhstep * wsrhstep) * ln(wsrhstep)) / ( 1.0 - wsrhstep)) + wsrhstep) * ( 1.0 - (__PGATD_i *  2.0)));
              end
              wsrh = (wsrhstep + dwsrh);
              if ((__PGATD_i ==  0.5)) begin
                tmp = sqrt((vbi_minus_vjsrh * __VBIRGATinv_d));
              end
              else begin
                tmp = pow((vbi_minus_vjsrh * __VBIRGATinv_d), __PGATD_i);
              end
              wdep = (__wdepnulrgat_d * tmp);
              asrh = (__ftdgat_d * ((zinv -  1.0) * wdep));
              isrh = (__CSRHGATD_i * (asrh * wsrh));
            end
            if ((__CTATGATD_i ==  0.0)) begin
              itat =  0.0;
            end
            else begin
              btat = (__btatpartgat_d * ((wdep * __one_minus_PGAT_d) / vbi_minus_vjsrh));
              twoatatoverthreebtat = ((__atatgat_d *  0.666666666666667) / btat);
              umaxbeforelimiting = (twoatatoverthreebtat * twoatatoverthreebtat);
              umax = sqrt(((umaxbeforelimiting * umaxbeforelimiting) / ((umaxbeforelimiting * umaxbeforelimiting) +  1.0)));
              sqrtumax = sqrt(umax);
              umaxpoweronepointfive = (umax * sqrtumax);
              if ((((- __PGATD_i) * __one_over_one_minus_PGAT_d) == -1.0)) begin
                wgamma = ( 1.0 / ((btat * umaxpoweronepointfive) +  1.0));
              end
              else begin
                wgamma = pow(((btat * umaxpoweronepointfive) +  1.0), ((- __PGATD_i) * __one_over_one_minus_PGAT_d));
              end
              wtat = ((wsrh * wgamma) / (wsrh + wgamma));
              ktat = sqrt(((btat / sqrtumax) *  0.375));
              ltat = (((twoatatoverthreebtat * sqrtumax) *  2.0) - umax);
              mtat = ((((__atatgat_d * twoatatoverthreebtat) * sqrtumax) - (__atatgat_d * umax)) + ((btat * umaxpoweronepointfive) *  0.5));
              xerfc = ((ltat -  1.0) * ktat);
              ysq = (xerfc * xerfc);
              if ((xerfc >  0.0)) begin
                terfc = ( 1.0 / ((__perfc * xerfc) +  1.0));
              end
              else begin
                terfc = ( 1.0 / ( 1.0 - (__perfc * xerfc)));
              end
              if ((((- ysq) + mtat) > -230.258509299405)) begin
                tmp = exp(((- ysq) + mtat));
              end
              else begin
                tmp = ( 100.0e-102 / (((-230.258509299405 - ((- ysq) + mtat)) * ((((-230.258509299405 - ((- ysq) + mtat)) * (((-230.258509299405 - ((- ysq) + mtat)) *  0.333333333333333) +  1.0)) *  0.5) +  1.0)) +  1.0));
              end
              erfcpos = ((((terfc *  0.29214664) + (__berfc * (terfc * terfc))) + (__cerfc * ((terfc * terfc) * terfc))) * tmp);
              if ((xerfc >  0.0)) begin
                erfctimesexpmtat = erfcpos;
              end
              else begin
                if ((mtat > -230.258509299405)) begin
                  tmp = exp(mtat);
                end
                else begin
                  tmp = ( 100.0e-102 / (((-230.258509299405 - mtat) * ((((-230.258509299405 - mtat) * (((-230.258509299405 - mtat) *  0.333333333333333) +  1.0)) *  0.5) +  1.0)) +  1.0));
                end
                erfctimesexpmtat = ((tmp *  2.0) - erfcpos);
              end
              gammamax = (((__atatgat_d * erfctimesexpmtat) / ktat) *  0.886226925452758);
              itat = (__CTATGATD_i * ((asrh * gammamax) * wtat));
            end
            if ((__CBBTGATD_i ==  0.0)) begin
              ibbt =  0.0;
            end
            else begin
              if ((__PGATD_i ==  0.5)) begin
                tmp = sqrt(((__VBIRGATD_i - vbbt) * __VBIRGATinv_d));
              end
              else begin
                tmp = pow(((__VBIRGATD_i - vbbt) * __VBIRGATinv_d), __PGATD_i);
              end
              Fmaxr = (__one_over_one_minus_PGAT_d * (((__VBIRGATD_i - vbbt) * __wdepnulrinvgat_d) / tmp));
              if ((abs(((- __fbbtgat_d) / Fmaxr)) <  230.258509299405)) begin
                tmp = exp(((- __fbbtgat_d) / Fmaxr));
              end
              else begin
                if ((((- __fbbtgat_d) / Fmaxr) <  0.0)) begin
                  tmp = ( 100.0e-102 / (((-230.258509299405 - ((- __fbbtgat_d) / Fmaxr)) * ((((-230.258509299405 - ((- __fbbtgat_d) / Fmaxr)) * (((-230.258509299405 - ((- __fbbtgat_d) / Fmaxr)) *  0.333333333333333) +  1.0)) *  0.5) +  1.0)) +  1.0));
                end
                else begin
                  tmp = ((((((- __fbbtgat_d) / Fmaxr) -  230.258509299405) * ((((((- __fbbtgat_d) / Fmaxr) -  230.258509299405) * (((((- __fbbtgat_d) / Fmaxr) -  230.258509299405) *  0.333333333333333) +  1.0)) *  0.5) +  1.0)) +  1.0) *  10.0e+99);
                end
              end
              ibbt = (__CBBTGATD_i * (((__V5 * Fmaxr) * Fmaxr) * tmp));
            end
            if ((__VBRGATD_i >  1.0e+3)) begin
              fbreakdown =  1.0;
            end
            else begin
              if ((vav > ((- __alphaav) * __VBRGATD_i))) begin
                if ((__PBRGATD_i ==  4.0)) begin
                  tmp = ((((vav * __VBRinvgat_d) * (vav * __VBRinvgat_d)) * (vav * __VBRinvgat_d)) * (vav * __VBRinvgat_d));
                end
                else begin
                  tmp = pow(abs((vav * __VBRinvgat_d)), __PBRGATD_i);
                end
                fbreakdown = ( 1.0 / ( 1.0 - tmp));
              end
              else begin
                fbreakdown = (__fstopgat_d + ((vav + (__alphaav * __VBRGATD_i)) * __slopegat_d));
              end
            end
            ijungat = ((((id + isrh) + itat) + ibbt) * fbreakdown);
          end
          __I5 = (((__ABDRAIN_i * ijunbot) + (__LSDRAIN_i * ijunsti)) + (__LGDRAIN_i * ijungat));
          __ISATFOR1_d = (((__ABDRAIN_i * __idsatbot_d) + (__LSDRAIN_i * __idsatsti_d)) + (__LGDRAIN_i * __idsatgat_d));
          __I4_cor = (__I4 - (__ISATFOR1_d * (exp(((__V4 * __phitdinv) * __MFOR1_d)) -  1.0)));
          __I5_cor = (__I5 - (__ISATFOR1_d * (exp(((__V5 * __phitdinv) * __MFOR1_d)) -  1.0)));
          if ((! (((__ABDRAIN_i ==  0.0) && (__LSDRAIN_i ==  0.0)) && (__LGDRAIN_i ==  0.0)))) begin
            if (((__I4 >  0.0) && (__I5 >  0.0))) begin
              if (((((((__I4_cor / __I4) >  0.001) || ((__I5_cor / __I5) >  0.001)) && (__I4_cor >  0.0)) && (__I5_cor >  0.0)) && (__I5_cor > __I4_cor))) begin
                __alphaje = (__I4_cor / __I5_cor);
                __MFOR2_d = ((__phitd * ln(__alphaje)) / (__V4 - __V5));
                __ISATFOR2_d = (__I4_cor / (exp(((__V4 * __phitdinv) * __MFOR2_d)) -  1.0));
              end
            end
            __I1_cor = ((__I1 - (__ISATFOR1_d * (exp(((__V1 * __phitdinv) * __MFOR1_d)) -  1.0))) - (__ISATFOR2_d * (exp(((__V1 * __phitdinv) * __MFOR2_d)) -  1.0)));
            __I2_cor = ((__I2 - (__ISATFOR1_d * (exp(((__V2 * __phitdinv) * __MFOR1_d)) -  1.0))) - (__ISATFOR2_d * (exp(((__V2 * __phitdinv) * __MFOR2_d)) -  1.0)));
            __I3_cor = ((__I3 - (__ISATFOR1_d * (exp(((__V3 * __phitdinv) * __MFOR1_d)) -  1.0))) - (__ISATFOR2_d * (exp(((__V3 * __phitdinv) * __MFOR2_d)) -  1.0)));
            if ((((__I1 <  0.0) && (__I2 <  0.0)) && (__I3 <  0.0))) begin
              if ((((((((__I1_cor / __I1) >  0.001) || ((__I2_cor / __I2) >  0.001)) || ((__I3_cor / __I3) >  0.001)) && (__I1_cor <  0.0)) && (__I2_cor <  0.0)) && (__I3_cor <  0.0))) begin
                __alphaje = (__I1_cor / __I2_cor);
                __m0_rev = (((- __phitd) * ln(__alphaje)) / (__V1 - __V2));
                __tt0 = (__V2 / (__V2 - __V1));
                __tt1 = ((__phitd * (__alphaje -  1.0)) * (pow(__alphaje, __tt0) -  1.0));
                __tt0 = (__V1 / (__V1 - __V2));
                __tt2 = (((pow(__alphaje, __tt0) * (__V2 - __V1)) + (__alphaje * __V1)) - __V2);
                __mcor_rev = (__tt1 / __tt2);
                __MREV_d = (__m0_rev + __mcor_rev);
                if ((abs(((__V3 * __phitdinv) * __MREV_d)) <  1.0e-6)) begin
                  __m0flag_d =  1.0;
                  __ISATREV_d = (__I3_cor * (( 1.0 / __V3) + ((__phitdinv *  0.5) * __MREV_d)));
                  __MREV_d = ((((__I3_cor * -0.5) * __MREV_d) * __phitdinv) / __V3);
                end
                else begin
                  __m0flag_d =  0.0;
                  __ISATREV_d = ((- __I3_cor) / (exp((((- __V3) * __phitdinv) * __MREV_d)) -  1.0));
                end
              end
            end
          end
          __zfrac = (__FJUNQD_i * (((__ABDRAIN_i * __cjobot_d) + (__LSDRAIN_i * __cjosti_d)) + (__LGDRAIN_i * __cjogat_d)));
          if (((__ABDRAIN_i * __cjobot_d) <= __zfrac)) begin
            __zflagbot_d =  0.0;
          end
          if (((__LSDRAIN_i * __cjosti_d) <= __zfrac)) begin
            __zflagsti_d =  0.0;
          end
          if (((__LGDRAIN_i * __cjogat_d) <= __zfrac)) begin
            __zflaggat_d =  0.0;
          end
          if ((! (((__ABDRAIN_i ==  0.0) && (__LSDRAIN_i ==  0.0)) && (__LGDRAIN_i ==  0.0)))) begin
            __xhighf1_d = ln(( 767.9e-6 / (__ISATFOR1_d +  1.0e-21)));
            __xhighf2_d = ln(( 767.9e-6 / (__ISATFOR2_d +  1.0e-21)));
            __xhighr_d = ln(( 767.9e-6 / (abs(__ISATREV_d) +  1.0e-21)));
          end
          __xhighf1_d = min(__xhighf1_d,  230.258509299405);
          __expxhf1_d = exp(__xhighf1_d);
          __xhighf2_d = min(__xhighf2_d,  230.258509299405);
          __expxhf2_d = exp(__xhighf2_d);
          __xhighr_d = min(__xhighr_d,  230.258509299405);
          __expxhr_d = exp(__xhighr_d);
        end
      end
    end
    begin : evaluateblock
      real sigVds, dphit1, xgct, xsct0, xbct, xsbstar, xsct, dCTG, ct_fact, phit1, inv_phit1, Vgb1_dc, xg_dc, alpha_dc, dps_dc, qim_dc;
      real qim1_dc, H_dc, FdL_dc, Gvsatinv_dc, Ids, Iimpact, mavl, Igdov, Igsov, Igcd, Igcs, eta_p_ac, Gvsat_ac, Gmob_dL_ac, Vgsinr_ac;
      real Vsginr_ac, Vgdinr_ac, Vdginr_ac, H0, COX_qm, ijun_s, ijunbot_s, ijunsti_s, ijungat_s, ijun_d, ijunbot_d, ijunsti_d, ijungat_d;
      real qjun_s, qjunbot_s, qjunsti_s, qjungat_s, qjun_d, qjunbot_d, qjunsti_d, qjungat_d, jnoise_s, jnoise_d, Gmob_dc, xitsb_dc;
      real Vdse_dc, Vgsinr_dc, Vsginr_dc, Vgdinr_dc, Vdginr_dc, Vsbstaredge, Vsbxedge, dphit1edge, phit1edge, inv_phit1edge, Vdspedge;
      real delVgedge, xgedge, xbedge, dxthedge, xnedge_s, qseffedge, xnedge_d, qdseffedge, qdeffedge, qmeffedge, dsqredge, alphabmedge;
      real Idsedge, Sfledge, midedge, sqidedge;
      real temp, temp1, temp2;
      begin : evaluateStatic
        temp =  0.0;
        temp1 =  0.0;
        temp2 =  0.0;
        __QCLM =  0.0;
        __xs_ov =  0.0;
        __xd_ov =  0.0;
        __Vovs =  0.0;
        __Vovd =  0.0;
        Iimpact =  0.0;
        mavl =  0.0;
        __pd =  1.0;
        __ym =  0.0;
        if ((__CHNL_TYPE == 1)) begin
          __Vgs = V(GP, SI);
          __Vds = V(DI, SI);
          __Vsb = V(SI, BP);
          __Vjun_s = (- V(SI, BS));
          __Vjun_d = (- V(DI, BD));
        end
        else begin
          __Vgs = (- V(GP, SI));
          __Vds = (- V(DI, SI));
          __Vsb = (- V(SI, BP));
          __Vjun_s = V(SI, BS);
          __Vjun_d = V(DI, BD);
        end
        __Vgb = (__Vgs + __Vsb);
        __VgsPrime = __Vgs;
        __VsbPrime = __Vsb;
        __VdbPrime = (__Vds + __Vsb);
        __VgdPrime = (__Vgs - __Vds);
        __xgs_ov = ((- __VgsPrime) * __inv_phita);
        __xgd_ov = ((- __VgdPrime) * __inv_phita);
        __xgb_ov = ((- (__Vgb - __VFB_T)) * __inv_phita);
        if (0) begin
          if ((abs(__Vgs) >  1.6)) begin
            $strobe("%M: Vgs=%g has exceeded Vgs_max=%g", __Vgs,  1.6);
          end
          if ((abs(__VgdPrime) >  1.6)) begin
            $strobe("%M: Vgd=%g has exceeded Vgd_max=%g", __VgdPrime,  1.6);
          end
          if ((abs(__Vds) >  1.6)) begin
            $strobe("%M: Vds=%g has exceeded Vds_max=%g", __Vds,  1.6);
          end
          if ((abs((__Vgs + __Vsb)) >  1.6)) begin
            $strobe("%M: Vgb=%g has exceeded Vgb_max=%g", (__Vgs + __Vsb),  1.6);
          end
          if ((abs(__Vsb) >  1.6)) begin
            $strobe("%M: Vsb=%g has exceeded Vsb_max=%g", __Vsb,  1.6);
          end
          if ((abs(__VdbPrime) >  1.6)) begin
            $strobe("%M: Vdb=%g has exceeded Vdb_max=%g", __VdbPrime,  1.6);
          end
        end
        sigVds =  1.0;
        if ((__Vds <  0.0)) begin
          sigVds = -1.0;
          __Vgs = (__Vgs - __Vds);
          __Vsb = (__Vsb + __Vds);
          __Vds = (- __Vds);
        end
        __Vdb = (__Vds + __Vsb);
        __Vdsx = ((__Vds * __Vds) / (sqrt(((__Vds * __Vds) +  0.01)) +  0.1));
        begin : SPcalc_dc
          real phib, G_0, Vsbstar, cfloc, thesatloc, axloc, alploc;
          real Vsbx, xg, Dnsub, Gf, Gf2, inv_Gf2, xi, inv_xi, Ux, xn_s, delta_ns, margin, x_s, delta_1s, xi0s, xi1s;
          real xi2s, Es, Ds, Ps, Rxcor, xgs, qis, qbs, rhob, GR, Eeffm, Mutmp, Gmob, xitsb, wsat, thesat1, phi_inf;
          real ysat, za, Phi_0, asat, Phi_2, Phi_0_2, Phi0_Phi2, Phi_sat, Vdse, Udse, xn_d, k_ds, delta_nd, x_d, x_ds;
          real pC, qC, dps, xi0d, Ed, Dd, Pd, sqd, qbd, x_m, Em, D_bar, Dm, Pm, xgm, eta_p, sqm, alpha, d0, x_pm, p_pd;
          real q_pd, xi_pd, u_pd, km, km0, qim, qim1, qbm, qeff, qeff1, s1, dL, GdL, Gmob_dL, zsat, Gvsat, Gvsatinv;
          real Voxm, alpha1, H, Vgsinr, Vsginr, Vgdinr, Vdginr;
          real SP_S_temp, SP_S_temp1, SP_S_temp2;
          real SP_S_yg, SP_S_ysub, SP_S_eta, SP_S_a, SP_S_c, SP_S_tau, SP_S_y0, SP_S_delta0, SP_S_delta1, SP_S_xi0;
          real SP_S_xi1, SP_S_xi2, SP_S_pC, SP_S_qC, SP_xg1, SP_S_A_fac, SP_S_xbar, SP_S_w, SP_S_x1, SP_S_bx, SP_S_b;
          real SP_S_x0;
          real FdL, qim1_1, r1, r2, s2, dL1;
          temp = ((((__Vdb + __Vsb) - sqrt((((__Vdb - __Vsb) * (__Vdb - __Vsb)) + __bphi_dc))) *  0.5) + __phix_dc);
          __Vsbstar_dc = ((__Vsb - ((temp - sqrt(((temp * temp) + __aphi_dc))) *  0.5)) + __phix1_dc);
          __Vsbstar_dc_tmp = __Vsbstar_dc;
          if (0) begin
          end
          phib = __phib_dc;
          G_0 = __G_0_dc;
          Vsbstar = __Vsbstar_dc;
          cfloc = __CF_i;
          thesatloc = __THESAT_T;
          axloc = __AX_i;
          alploc = __ALP_i;
          FdL =  1.0;
          alpha =  0.0;
          GdL =  1.0;
          dL =  0.0;
          qbm =  0.0;
          dps =  0.0;
          qim =  0.0;
          qim1 =  0.0;
          H =  1.0;
          s1 =  0.0;
          eta_p =  1.0;
          Gvsat =  1.0;
          Gvsatinv =  1.0;
          SP_S_x1 =  0.0;
          x_s =  0.0;
          sqm =  0.0;
          xitsb =  0.0;
          rhob =  0.0;
          Gmob =  1.0;
          Gmob_dL =  1.0;
          Udse =  0.0;
          thesat1 =  0.0;
          Em =  0.0;
          Dm =  0.0;
          Pm =  0.0;
          xgm =  0.0;
          qbs =  0.0;
          qbd =  0.0;
          if (0) begin
          end
          else begin
            __Vgb1 = ((__Vgs + Vsbstar) - __VFB_T);
          end
          Vsbx = (Vsbstar + ((__Vds - __Vdsx) *  0.5));
          __Vdsp = ((__Vdsx *  2.0) / (sqrt(((__CFD_i * __Vdsx) +  1.0)) +  1.0));
          __delVg = ((cfloc * __Vdsp) * ((__CFB_i * Vsbx) +  1.0));
          dphit1 = ((__PSCE_i * ((__PSCED_i * __Vdsx) +  1.0)) * ((__PSCEB_i * Vsbx) +  1.0));
          __Vgb1 = (__Vgb1 + __delVg);
          if ((__DNSUB_i >  0.0)) begin
            Dnsub = ((__DNSUB_i *  0.5) * (((__Vgs + __Vsb) - __VNSUB_i) + sqrt(((( 0.0 - ((__Vgs + __Vsb) - __VNSUB_i)) * ( 0.0 - ((__Vgs + __Vsb) - __VNSUB_i))) + __NSLP_i))));
            Gf = (G_0 * sqrt((Dnsub +  1.0)));
          end
          else begin
            Gf = G_0;
          end
          Gf2 = (Gf * Gf);
          inv_Gf2 = ( 1.0 / Gf2);
          dCTG =  1.0;
          if ((__CTG_i >  0.0)) begin
            xgct = ((__Vgb1 *  2.0) * __inv_phit);
            temp1 = (Gf2 + xgct);
            temp2 = (((temp1 + xgct) + sqrt((((temp1 + xgct) * (temp1 + xgct)) +  5.0))) *  0.5);
            xsct0 = ((temp1 - (Gf * sqrt(temp2))) *  0.5);
            xbct = (phib * __inv_phit);
            xsbstar = (Vsbx * __inv_phit);
            temp1 = ((xbct + xsbstar) +  2.0);
            xsct = (((xsct0 + temp1) - sqrt((((xsct0 - temp1) * (xsct0 - temp1)) +  5.0))) *  0.5);
            temp2 = (__CTG_T * (xsct - ((__CTB_i +  1.0) * ((xbct *  0.5) + xsbstar))));
            if ((temp2 > -230.258509299405)) begin
              dCTG = exp(temp2);
            end
            else begin
              dCTG = ( 100.0e-102 / (((-230.258509299405 - temp2) * ((((-230.258509299405 - temp2) * (((-230.258509299405 - temp2) *  0.333333333333333) +  1.0)) *  0.5) +  1.0)) +  1.0));
            end
          end
          ct_fact = ((__CT_T * dCTG) +  1.0);
          phit1 = ((__phit * ct_fact) * (dphit1 +  1.0));
          inv_phit1 = ( 1.0 / phit1);
          xg = (__Vgb1 * inv_phit1);
          if (0) begin
          end
          xi = ((Gf *  0.707106781186547) +  1.0);
          inv_xi = ( 1.0 / xi);
          Ux = (Vsbstar * inv_phit1);
          xn_s = ((phib * inv_phit1) + Ux);
          if ((xn_s <  460.517018598809)) begin
            delta_ns = exp((- xn_s));
          end
          else begin
            delta_ns = ( 10.0e-201 / (((xn_s -  460.517018598809) * ((((xn_s -  460.517018598809) * (((xn_s -  460.517018598809) *  0.333333333333333) +  1.0)) *  0.5) +  1.0)) +  1.0));
          end
          margin = (xi *  10.0e-6);
          if ((abs(xg) <= margin)) begin
            SP_S_temp1 = ((inv_xi * inv_xi) *  0.117851130197758);
            x_s = ((xg * inv_xi) * ((((xg * ( 1.0 - delta_ns)) * Gf) * SP_S_temp1) +  1.0));
          end
          else begin
            if ((xg < (- margin))) begin
              SP_S_yg = (- xg);
              SP_S_ysub = ((SP_S_yg * inv_xi) *  1.25);
              SP_S_eta = (((SP_S_ysub + 10) - sqrt((((SP_S_ysub -  6.0) * (SP_S_ysub -  6.0)) +  64.0))) *  0.5);
              SP_S_temp = (SP_S_yg - SP_S_eta);
              SP_S_a = ((SP_S_temp * SP_S_temp) + (Gf2 * (SP_S_eta +  1.0)));
              SP_S_c = ((SP_S_temp *  2.0) - Gf2);
              SP_S_tau = ((- SP_S_eta) + ln((SP_S_a * inv_Gf2)));
              __nu = (SP_S_a + SP_S_c);
              __mutau = ((__nu * __nu) + (SP_S_tau * (((SP_S_c * SP_S_c) *  0.5) - SP_S_a)));
              SP_S_y0 = (SP_S_eta + (((SP_S_a * __nu) * SP_S_tau) / (__mutau + (((((__nu / __mutau) * SP_S_tau) * SP_S_tau) * SP_S_c) * (((SP_S_c * SP_S_c) *  0.333333333333333) - SP_S_a)))));
              if ((SP_S_y0 <  230.258509299405)) begin
                SP_S_delta0 = exp(SP_S_y0);
              end
              else begin
                SP_S_delta0 = ((((SP_S_y0 -  230.258509299405) * ((((SP_S_y0 -  230.258509299405) * (((SP_S_y0 -  230.258509299405) *  0.333333333333333) +  1.0)) *  0.5) +  1.0)) +  1.0) *  10.0e+99);
              end
              SP_S_delta1 = ( 1.0 / SP_S_delta0);
              SP_S_temp = ( 1.0 / ((SP_S_y0 * SP_S_y0) +  2.0));
              SP_S_xi0 = ((SP_S_y0 * SP_S_y0) * SP_S_temp);
              SP_S_xi1 = (((SP_S_y0 * SP_S_temp) * SP_S_temp) *  4.0);
              SP_S_xi2 = ((((SP_S_temp *  8.0) - (SP_S_xi0 *  12.0)) * SP_S_temp) * SP_S_temp);
              SP_S_temp = (SP_S_yg - SP_S_y0);
              SP_S_temp1 = (delta_ns * SP_S_delta1);
              SP_S_pC = ((SP_S_temp *  2.0) + (Gf2 * (((SP_S_delta0 -  1.0) - SP_S_temp1) + (delta_ns * ( 1.0 - SP_S_xi1)))));
              SP_S_qC = ((SP_S_temp * SP_S_temp) - (Gf2 * ((((SP_S_delta0 - SP_S_y0) -  1.0) + SP_S_temp1) + (delta_ns * ((SP_S_y0 -  1.0) - SP_S_xi0)))));
              SP_S_temp = ( 2.0 - (Gf2 * ((SP_S_delta0 + SP_S_temp1) - (delta_ns * SP_S_xi2))));
              SP_S_temp = ((SP_S_pC * SP_S_pC) - ((SP_S_qC * SP_S_temp) *  2.0));
              x_s = ((- SP_S_y0) - ((SP_S_qC / (SP_S_pC + sqrt(SP_S_temp))) *  2.0));
            end
            else begin
              SP_xg1 = ( 1.0 / ((Gf *  0.732464877560822) +  1.25));
              SP_S_A_fac = ((((xi *  1.25) * SP_xg1) -  1.0) * SP_xg1);
              SP_S_xbar = ((xg * inv_xi) * ((SP_S_A_fac * xg) +  1.0));
              if (((- SP_S_xbar) > -230.258509299405)) begin
                SP_S_temp = exp((- SP_S_xbar));
              end
              else begin
                SP_S_temp = ( 100.0e-102 / (((-230.258509299405 - (- SP_S_xbar)) * ((((-230.258509299405 - (- SP_S_xbar)) * (((-230.258509299405 - (- SP_S_xbar)) *  0.333333333333333) +  1.0)) *  0.5) +  1.0)) +  1.0));
              end
              SP_S_w = ( 1.0 - SP_S_temp);
              SP_S_x1 = ((xg + (Gf2 *  0.5)) - (Gf * sqrt(((xg + (Gf2 *  0.25)) - SP_S_w))));
              SP_S_bx = (xn_s +  3.0);
              SP_S_eta = ((((SP_S_x1 + SP_S_bx) - sqrt((((SP_S_x1 - SP_S_bx) * (SP_S_x1 - SP_S_bx)) +  5.0))) *  0.5) - ((SP_S_bx - sqrt(((SP_S_bx * SP_S_bx) +  5.0))) *  0.5));
              SP_S_temp = (xg - SP_S_eta);
              SP_S_temp1 = exp((- SP_S_eta));
              SP_S_temp2 = ( 1.0 / ((SP_S_eta * SP_S_eta) +  2.0));
              SP_S_xi0 = ((SP_S_eta * SP_S_eta) * SP_S_temp2);
              SP_S_xi1 = (((SP_S_eta * SP_S_temp2) * SP_S_temp2) *  4.0);
              SP_S_xi2 = ((((SP_S_temp2 *  8.0) - (SP_S_xi0 *  12.0)) * SP_S_temp2) * SP_S_temp2);
              SP_S_a = max( 100.0e-42, ((SP_S_temp * SP_S_temp) - (Gf2 * (((SP_S_temp1 + SP_S_eta) -  1.0) - (delta_ns * ((SP_S_eta +  1.0) + SP_S_xi0))))));
              SP_S_b = ( 1.0 - ((Gf2 * (SP_S_temp1 - (delta_ns * SP_S_xi2))) *  0.5));
              SP_S_c = ((SP_S_temp *  2.0) + (Gf2 * (( 1.0 - SP_S_temp1) - (delta_ns * (SP_S_xi1 +  1.0)))));
              SP_S_tau = ((xn_s - SP_S_eta) + ln((SP_S_a / Gf2)));
              __nu = (SP_S_a + SP_S_c);
              __mutau = ((__nu * __nu) + (SP_S_tau * (((SP_S_c * SP_S_c) *  0.5) - (SP_S_a * SP_S_b))));
              SP_S_x0 = (SP_S_eta + (((SP_S_a * __nu) * SP_S_tau) / (__mutau + (((((__nu / __mutau) * SP_S_tau) * SP_S_tau) * SP_S_c) * (((SP_S_c * SP_S_c) *  0.333333333333333) - (SP_S_a * SP_S_b))))));
              if ((SP_S_x0 <  230.258509299405)) begin
                SP_S_delta0 = exp(SP_S_x0);
                SP_S_delta1 = ( 1.0 / SP_S_delta0);
                SP_S_delta0 = (delta_ns * SP_S_delta0);
              end
              else begin
                if ((SP_S_x0 > (xn_s -  230.258509299405))) begin
                  SP_S_delta0 = exp((SP_S_x0 - xn_s));
                  SP_S_delta1 = (delta_ns / SP_S_delta0);
                end
                else begin
                  SP_S_delta0 = ( 100.0e-102 / ((((xn_s - SP_S_x0) -  230.258509299405) * (((((xn_s - SP_S_x0) -  230.258509299405) * ((((xn_s - SP_S_x0) -  230.258509299405) *  0.333333333333333) +  1.0)) *  0.5) +  1.0)) +  1.0));
                  SP_S_delta1 = ( 100.0e-102 / (((SP_S_x0 -  230.258509299405) * ((((SP_S_x0 -  230.258509299405) * (((SP_S_x0 -  230.258509299405) *  0.333333333333333) +  1.0)) *  0.5) +  1.0)) +  1.0));
                end
              end
              SP_S_temp = ( 1.0 / ((SP_S_x0 * SP_S_x0) +  2.0));
              SP_S_xi0 = ((SP_S_x0 * SP_S_x0) * SP_S_temp);
              SP_S_xi1 = (((SP_S_x0 * SP_S_temp) * SP_S_temp) *  4.0);
              SP_S_xi2 = ((((SP_S_temp *  8.0) - (SP_S_xi0 *  12.0)) * SP_S_temp) * SP_S_temp);
              SP_S_temp = (xg - SP_S_x0);
              SP_S_pC = ((SP_S_temp *  2.0) + (Gf2 * ((( 1.0 - SP_S_delta1) + SP_S_delta0) - (delta_ns * (SP_S_xi1 +  1.0)))));
              SP_S_qC = ((SP_S_temp * SP_S_temp) - (Gf2 * ((((SP_S_delta1 + SP_S_x0) -  1.0) + SP_S_delta0) - (delta_ns * ((SP_S_x0 +  1.0) + SP_S_xi0)))));
              SP_S_temp = ( 2.0 - (Gf2 * ((SP_S_delta1 + SP_S_delta0) - (delta_ns * SP_S_xi2))));
              SP_S_temp = ((SP_S_pC * SP_S_pC) - ((SP_S_qC * SP_S_temp) *  2.0));
              x_s = (SP_S_x0 + ((SP_S_qC / (SP_S_pC + sqrt(SP_S_temp))) *  2.0));
            end
          end
          x_d = x_s;
          x_m = x_s;
          x_ds =  0.0;
          __Vdsat_lim = (phit1 *  3.912023005);
          if ((xg <=  0.0)) begin
            qis =  0.0;
            xgm = (xg - x_s);
            qbs = (xgm * phit1);
            qbd = qbs;
            Voxm = (xgm * phit1);
            qeff1 = Voxm;
            __Vdsat = __Vdsat_lim;
            Vdse = __Vds;
          end
          else begin
            delta_1s =  0.0;
            temp = ( 1.0 / ((x_s * x_s) +  2.0));
            xi0s = ((x_s * x_s) * temp);
            xi1s = (((x_s * temp) * temp) *  4.0);
            xi2s = ((((temp *  8.0) - (xi0s *  12.0)) * temp) * temp);
            if ((x_s <  230.258509299405)) begin
              delta_1s = exp(x_s);
              Es = ( 1.0 / delta_1s);
              delta_1s = (delta_ns * delta_1s);
            end
            else begin
              if ((x_s > (xn_s -  230.258509299405))) begin
                delta_1s = exp((x_s - xn_s));
                Es = (delta_ns / delta_1s);
              end
              else begin
                delta_1s = ( 100.0e-102 / ((((xn_s - x_s) -  230.258509299405) * (((((xn_s - x_s) -  230.258509299405) * ((((xn_s - x_s) -  230.258509299405) *  0.333333333333333) +  1.0)) *  0.5) +  1.0)) +  1.0));
                Es = ( 100.0e-102 / (((x_s -  230.258509299405) * ((((x_s -  230.258509299405) * (((x_s -  230.258509299405) *  0.333333333333333) +  1.0)) *  0.5) +  1.0)) +  1.0));
              end
            end
            Ds = (delta_1s - (delta_ns * ((x_s +  1.0) + xi0s)));
            if ((x_s <  10.0e-6)) begin
              Ps = (((x_s * x_s) * ( 1.0 - ((x_s * ( 1.0 - (x_s *  0.25))) *  0.333333333333333))) *  0.5);
              Ds = (((((delta_ns * x_s) * x_s) * x_s) * ((x_s *  1.75) +  1.0)) *  0.166666666666667);
              temp = sqrt(( 1.0 - ((x_s * ( 1.0 - (x_s *  0.25))) *  0.333333333333333)));
              sqm = ((x_s * temp) *  0.707106781186547);
              alpha = ((((Gf *  0.707106781186547) * (( 1.0 - (x_s *  0.5)) + ((x_s * x_s) *  0.166666666666667))) / temp) +  1.0);
            end
            else begin
              Ps = ((x_s -  1.0) + Es);
              sqm = sqrt(Ps);
              alpha = ((((Gf * ( 1.0 - Es)) / sqm) *  0.5) +  1.0);
            end
            Em = Es;
            Ed = Em;
            Dm = Ds;
            Dd = Dm;
            Rxcor = ((((__XCOR_T *  0.2) * Vsbx) +  1.0) / ((__XCOR_T * Vsbx) +  1.0));
            if ((Ds >  100.0e-102)) begin
              xgs = (Gf * sqrt((Ps + Ds)));
              qis = (((Gf2 * Ds) * phit1) / (xgs + (Gf * sqm)));
              qbs = ((sqm * Gf) * phit1);
              if ((__RSB_i <  0.0)) begin
                rhob = ( 1.0 / ( 1.0 - (__RSB_i * Vsbx)));
              end
              else begin
                rhob = ((__RSB_i * Vsbx) +  1.0);
              end
              if ((__RSG_i <  0.0)) begin
                temp = ( 1.0 - (__RSG_i * qis));
              end
              else begin
                temp = ( 1.0 / ((__RSG_i * qis) +  1.0));
              end
              GR = (__THER_i * ((rhob * temp) * qis));
              Eeffm = (__E_eff0 * (qbs + (__eta_mu * qis)));
              temp1 = ln((Ps / ((Ps + Ds) +  10.0e-15)));
              Mutmp = (pow((Eeffm * __MUE_T), __THEMU_T) + (__CS_T * exp(((__THECS_T *  0.5) * temp1))));
              Gmob = (((Mutmp +  1.0) + GR) * Rxcor);
              if ((__THESATB_i <  0.0)) begin
                xitsb = ( 1.0 / ( 1.0 - (__THESATB_i * Vsbx)));
              end
              else begin
                xitsb = ((__THESATB_i * Vsbx) +  1.0);
              end
              temp2 = (qis * xitsb);
              wsat = ((temp2 / (temp2 +  100.0)) *  100.0);
              if ((__THESATG_i <  0.0)) begin
                temp = ( 1.0 / ( 1.0 - (__THESATG_i * wsat)));
              end
              else begin
                temp = ((__THESATG_i * wsat) +  1.0);
              end
              thesat1 = (thesatloc * (temp / Gmob));
              phi_inf = ((qis / alpha) + phit1);
              ysat = ((thesat1 * phi_inf) *  0.707106781186547);
              if ((__CHNL_TYPE == -1)) begin
                ysat = (ysat / sqrt((ysat +  1.0)));
              end
              za = ( 2.0 / (sqrt(((ysat *  4.0) +  1.0)) +  1.0));
              temp1 = (za * ysat);
              Phi_0 = ((phi_inf * za) * ((((temp1 * ( 1.0 - (temp1 * za))) / ((((temp1 * temp1) * za) *  4.0) +  1.0)) *  0.86) +  1.0));
              asat = (xgs + (Gf2 *  0.5));
              Phi_2 = ((((Gf2 * Ds) * phit1) / (asat + sqrt(((asat * asat) - ((Gf2 * Ds) *  0.98))))) *  0.98);
              Phi_0_2 = (Phi_0 + Phi_2);
              Phi0_Phi2 = ((Phi_0 * Phi_2) *  2.0);
              Phi_sat = (Phi0_Phi2 / (Phi_0_2 + sqrt(((Phi_0_2 * Phi_0_2) - (Phi0_Phi2 *  1.98)))));
              __Vdsat = (Phi_sat - (phit1 * ln(((((Phi_sat * (Phi_sat - ((asat *  2.0) * phit1))) * inv_Gf2) / ((phit1 * phit1) * Ds)) +  1.0))));
            end
            else begin
              __Vdsat = __Vdsat_lim;
            end
            temp = pow((__Vds / __Vdsat), axloc);
            temp1 = (-1.0 / axloc);
            Vdse = (__Vds * pow((temp +  1.0), temp1));
            Udse = (Vdse * inv_phit1);
            xn_d = (xn_s + Udse);
            if ((Udse <  460.517018598809)) begin
              k_ds = exp((- Udse));
            end
            else begin
              k_ds = ( 10.0e-201 / (((Udse -  460.517018598809) * ((((Udse -  460.517018598809) * (((Udse -  460.517018598809) *  0.333333333333333) +  1.0)) *  0.5) +  1.0)) +  1.0));
            end
            delta_nd = (delta_ns * k_ds);
            if ((abs(xg) <= margin)) begin
              SP_S_temp1 = ((inv_xi * inv_xi) *  0.117851130197758);
              x_d = ((xg * inv_xi) * ((((xg * ( 1.0 - delta_nd)) * Gf) * SP_S_temp1) +  1.0));
            end
            else begin
              SP_S_bx = (xn_d +  3.0);
              SP_S_eta = ((((SP_S_x1 + SP_S_bx) - sqrt((((SP_S_x1 - SP_S_bx) * (SP_S_x1 - SP_S_bx)) +  5.0))) *  0.5) - ((SP_S_bx - sqrt(((SP_S_bx * SP_S_bx) +  5.0))) *  0.5));
              SP_S_temp = (xg - SP_S_eta);
              SP_S_temp1 = exp((- SP_S_eta));
              SP_S_temp2 = ( 1.0 / ((SP_S_eta * SP_S_eta) +  2.0));
              SP_S_xi0 = ((SP_S_eta * SP_S_eta) * SP_S_temp2);
              SP_S_xi1 = (((SP_S_eta * SP_S_temp2) * SP_S_temp2) *  4.0);
              SP_S_xi2 = ((((SP_S_temp2 *  8.0) - (SP_S_xi0 *  12.0)) * SP_S_temp2) * SP_S_temp2);
              SP_S_a = max( 100.0e-42, ((SP_S_temp * SP_S_temp) - (Gf2 * (((SP_S_temp1 + SP_S_eta) -  1.0) - (delta_nd * ((SP_S_eta +  1.0) + SP_S_xi0))))));
              SP_S_b = ( 1.0 - ((Gf2 * (SP_S_temp1 - (delta_nd * SP_S_xi2))) *  0.5));
              SP_S_c = ((SP_S_temp *  2.0) + (Gf2 * (( 1.0 - SP_S_temp1) - (delta_nd * (SP_S_xi1 +  1.0)))));
              SP_S_tau = ((xn_d - SP_S_eta) + ln((SP_S_a / Gf2)));
              __nu = (SP_S_a + SP_S_c);
              __mutau = ((__nu * __nu) + (SP_S_tau * (((SP_S_c * SP_S_c) *  0.5) - (SP_S_a * SP_S_b))));
              SP_S_x0 = (SP_S_eta + (((SP_S_a * __nu) * SP_S_tau) / (__mutau + (((((__nu / __mutau) * SP_S_tau) * SP_S_tau) * SP_S_c) * (((SP_S_c * SP_S_c) *  0.333333333333333) - (SP_S_a * SP_S_b))))));
              if ((SP_S_x0 <  230.258509299405)) begin
                SP_S_delta0 = exp(SP_S_x0);
                SP_S_delta1 = ( 1.0 / SP_S_delta0);
                SP_S_delta0 = (delta_nd * SP_S_delta0);
              end
              else begin
                if ((SP_S_x0 > (xn_d -  230.258509299405))) begin
                  SP_S_delta0 = exp((SP_S_x0 - xn_d));
                  SP_S_delta1 = (delta_nd / SP_S_delta0);
                end
                else begin
                  SP_S_delta0 = ( 100.0e-102 / ((((xn_d - SP_S_x0) -  230.258509299405) * (((((xn_d - SP_S_x0) -  230.258509299405) * ((((xn_d - SP_S_x0) -  230.258509299405) *  0.333333333333333) +  1.0)) *  0.5) +  1.0)) +  1.0));
                  SP_S_delta1 = ( 100.0e-102 / (((SP_S_x0 -  230.258509299405) * ((((SP_S_x0 -  230.258509299405) * (((SP_S_x0 -  230.258509299405) *  0.333333333333333) +  1.0)) *  0.5) +  1.0)) +  1.0));
                end
              end
              SP_S_temp = ( 1.0 / ((SP_S_x0 * SP_S_x0) +  2.0));
              SP_S_xi0 = ((SP_S_x0 * SP_S_x0) * SP_S_temp);
              SP_S_xi1 = (((SP_S_x0 * SP_S_temp) * SP_S_temp) *  4.0);
              SP_S_xi2 = ((((SP_S_temp *  8.0) - (SP_S_xi0 *  12.0)) * SP_S_temp) * SP_S_temp);
              SP_S_temp = (xg - SP_S_x0);
              SP_S_pC = ((SP_S_temp *  2.0) + (Gf2 * ((( 1.0 - SP_S_delta1) + SP_S_delta0) - (delta_nd * (SP_S_xi1 +  1.0)))));
              SP_S_qC = ((SP_S_temp * SP_S_temp) - (Gf2 * ((((SP_S_delta1 + SP_S_x0) -  1.0) + SP_S_delta0) - (delta_nd * ((SP_S_x0 +  1.0) + SP_S_xi0)))));
              SP_S_temp = ( 2.0 - (Gf2 * ((SP_S_delta1 + SP_S_delta0) - (delta_nd * SP_S_xi2))));
              SP_S_temp = ((SP_S_pC * SP_S_pC) - ((SP_S_qC * SP_S_temp) *  2.0));
              x_d = (SP_S_x0 + ((SP_S_qC / (SP_S_pC + sqrt(SP_S_temp))) *  2.0));
            end
            x_ds = (x_d - x_s);
            if ((x_ds <  100.0e-12)) begin
              pC = (((xg - x_s) *  2.0) + (Gf2 * ((( 1.0 - Es) + (delta_1s * k_ds)) - (delta_nd * (xi1s +  1.0)))));
              qC = ((Gf2 * ( 1.0 - k_ds)) * Ds);
              temp = ( 2.0 - (Gf2 * ((Es + (delta_1s * k_ds)) - (delta_nd * xi2s))));
              temp = ((pC * pC) - ((temp * qC) *  2.0));
              x_ds = ((qC / (pC + sqrt(temp))) *  2.0);
              x_d = (x_s + x_ds);
            end
            dps = (x_ds * phit1);
            xi0d = ((x_d * x_d) / ((x_d * x_d) +  2.0));
            if ((x_d <  230.258509299405)) begin
              Ed = exp((- x_d));
              if ((x_d <  10.0e-6)) begin
                Pd = (((x_d * x_d) * ( 1.0 - ((x_d * ( 1.0 - (x_d *  0.25))) *  0.333333333333333))) *  0.5);
                temp = sqrt(( 1.0 - ((x_d * ( 1.0 - (x_d *  0.25))) *  0.333333333333333)));
                sqd = ((x_d * temp) *  0.707106781186547);
                Dd = (((((delta_nd *  0.166666666666667) * x_d) * x_d) * x_d) * ((x_d *  1.75) +  1.0));
              end
              else begin
                Pd = ((x_d -  1.0) + Ed);
                sqd = sqrt(Pd);
                Dd = (delta_nd * (((( 1.0 / Ed) - x_d) -  1.0) - xi0d));
              end
            end
            else begin
              if ((x_d > (xn_d -  230.258509299405))) begin
                temp = exp((x_d - xn_d));
                Ed = (delta_nd / temp);
                Dd = (temp - (delta_nd * ((x_d +  1.0) + xi0d)));
              end
              else begin
                Ed = ( 100.0e-102 / (((x_d -  230.258509299405) * ((((x_d -  230.258509299405) * (((x_d -  230.258509299405) *  0.333333333333333) +  1.0)) *  0.5) +  1.0)) +  1.0));
                temp = ( 100.0e-102 / ((((xn_d - x_d) -  230.258509299405) * (((((xn_d - x_d) -  230.258509299405) * ((((xn_d - x_d) -  230.258509299405) *  0.333333333333333) +  1.0)) *  0.5) +  1.0)) +  1.0));
                Dd = (temp - (delta_nd * ((x_d +  1.0) + xi0d)));
              end
              Pd = ((x_d -  1.0) + Ed);
              sqd = sqrt(Pd);
            end
            qbd = ((sqd * Gf) * phit1);
            x_m = ((x_s + x_d) *  0.5);
            Em =  0.0;
            temp = (Ed * Es);
            if ((temp >  0.0)) begin
              Em = sqrt(temp);
            end
            D_bar = ((Ds + Dd) *  0.5);
            Dm = (D_bar + (((x_ds * x_ds) * (Em - (inv_Gf2 *  2.0))) *  0.125));
            if ((x_m <  10.0e-6)) begin
              Pm = (((x_m * x_m) * ( 1.0 - ((x_m * ( 1.0 - (x_m *  0.25))) *  0.333333333333333))) *  0.5);
              xgm = (Gf * sqrt((Dm + Pm)));
              if ((__kp >  0.0)) begin
                eta_p = ( 1.0 / sqrt(((__kp * xgm) +  1.0)));
              end
              temp = sqrt(( 1.0 - ((x_m * ( 1.0 - (x_m *  0.25))) *  0.333333333333333)));
              sqm = ((x_m * temp) *  0.707106781186547);
              alpha = (eta_p + (((Gf * (( 1.0 - (x_m *  0.5)) + ((x_m * x_m) *  0.166666666666667))) / temp) *  0.707106781186547));
            end
            else begin
              Pm = ((x_m -  1.0) + Em);
              xgm = (Gf * sqrt((Dm + Pm)));
              if ((__kp >  0.0)) begin
                d0 = (( 1.0 - Em) + ((xgm * inv_Gf2) *  2.0));
                eta_p = ( 1.0 / sqrt(((__kp * xgm) +  1.0)));
                temp = (eta_p / (eta_p +  1.0));
                x_pm = (__kp * (((temp * temp) * Gf2) * Dm));
                p_pd = (((xgm - x_pm) *  2.0) + (Gf2 * (( 1.0 - Em) + Dm)));
                q_pd = (x_pm * (x_pm - (xgm *  2.0)));
                xi_pd = ( 1.0 - ((Gf2 * (Em + Dm)) *  0.5));
                u_pd = ((q_pd * p_pd) / ((p_pd * p_pd) - (xi_pd * q_pd)));
                x_m = (x_m + u_pd);
                km = exp(u_pd);
                Em = (Em / km);
                Dm = (Dm * km);
                Pm = ((x_m -  1.0) + Em);
                xgm = (Gf * sqrt((Dm + Pm)));
                km0 = (( 1.0 - Em) + (((xgm * eta_p) * inv_Gf2) *  2.0));
                x_ds = (((x_ds * km) * (d0 + D_bar)) / (km0 + (km * D_bar)));
                dps = (x_ds * phit1);
              end
              sqm = sqrt(Pm);
              alpha = (eta_p + (((Gf * ( 1.0 - Em)) / sqm) *  0.5));
            end
            qim = (phit1 * ((Gf2 * Dm) / (xgm + (Gf * sqm))));
            qim1 = (qim + (phit1 * alpha));
            qbm = ((sqm * Gf) * phit1);
            if ((__RSG_i <  0.0)) begin
              temp = ( 1.0 - (__RSG_i * qim));
            end
            else begin
              temp = ( 1.0 / ((__RSG_i * qim) +  1.0));
            end
            GR = (__THER_i * ((rhob * temp) * qim));
            qeff = (qbm + (__eta_mu * qim));
            qeff1 = (qbm + (__eta_mu1 * qim));
            Eeffm = (__E_eff0 * qeff);
            temp1 = ln((Pm / ((Pm + Dm) +  10.0e-15)));
            Mutmp = (pow((Eeffm * __MUE_T), __THEMU_T) + (__CS_T * exp(((__THECS_T *  0.5) * temp1))));
            Gmob = (((Mutmp +  1.0) + GR) * Rxcor);
            s1 = ln(((((__Vds - dps) * __inv_VP) +  1.0) / (((Vdse - dps) * __inv_VP) +  1.0)));
            dL = (alploc * s1);
            GdL = ( 1.0 / ((dL +  1.0) + (dL * dL)));
            temp2 = (qim * xitsb);
            wsat = ((temp2 / (temp2 +  100.0)) *  100.0);
            Gmob_dL = (Gmob * GdL);
            if ((__THESATG_i <  0.0)) begin
              temp = ( 1.0 / ( 1.0 - (__THESATG_i * wsat)));
            end
            else begin
              temp = ((__THESATG_i * wsat) +  1.0);
            end
            thesat1 = (thesatloc * (temp / Gmob_dL));
            zsat = (((thesat1 * thesat1) * dps) * dps);
            if ((__CHNL_TYPE == -1)) begin
              zsat = (zsat / ((thesat1 * dps) +  1.0));
            end
            Gvsat = ((Gmob_dL * (sqrt(((zsat *  2.0) +  1.0)) +  1.0)) *  0.5);
            Gvsatinv = ( 1.0 / Gvsat);
            Voxm = (xgm * phit1);
            temp = (Gmob_dL * Gvsatinv);
            alpha1 = (alpha * ((((zsat * temp) * temp) *  0.5) +  1.0));
            H = ((temp * qim1) / alpha1);
          end
          Vgsinr = (phit1 * (x_s - xn_s));
          Vsginr = ((__Vgb1 - Vgsinr) - qbs);
          Vgdinr = ((dps + Vgsinr) - __Vds);
          Vdginr = ((__Vgb1 - Vgdinr) - qbd);
          if ((xg >  0.0)) begin
            qim1_1 = ( 1.0 / qim1);
            r1 = (qim * qim1_1);
            r2 = (phit1 * (alpha * qim1_1));
            s2 = ln(((__Vdsx * __inv_VP) +  1.0));
            dL1 = ((dL + (__ALP1_i * ((qim1_1 * r1) * s1))) + (__ALP2_i * (((qbm * r2) * r2) * s2)));
            FdL = (((dL1 +  1.0) + (dL1 * dL1)) * GdL);
          end
          Vgb1_dc = __Vgb1;
          xg_dc = xg;
          __qeff1_dc = qeff1;
          __Voxm_dc = Voxm;
          alpha_dc = alpha;
          dps_dc = dps;
          qim_dc = qim;
          qim1_dc = qim1;
          __GdL_dc = GdL;
          FdL_dc = FdL;
          H_dc = H;
          __eta_p_dc = eta_p;
          __Gvsat_dc = Gvsat;
          Gvsatinv_dc = Gvsatinv;
          __Gmob_dL_dc = Gmob_dL;
          __x_ds_dc = x_ds;
          __x_m_dc = x_m;
          __Gf_dc = Gf;
          __Vdsat_dc = __Vdsat;
          __Udse_dc = Udse;
          Gmob_dc = Gmob;
          xitsb_dc = xitsb;
          Vdse_dc = Vdse;
          Vgsinr_dc = Vgsinr;
          Vsginr_dc = Vsginr;
          Vgdinr_dc = Vgdinr;
          Vdginr_dc = Vdginr;
          __xgm_dc = xgm;
          __thesat1_dc = thesat1;
          __margin_dc = margin;
        end
        if ((xg_dc <=  0.0)) begin
          Ids =  0.0;
        end
        else begin
          Ids = (__BET_i * (((FdL_dc * qim1_dc) * dps_dc) * Gvsatinv_dc));
        end
        if (((((1 && ((__IGOV_i >  0.0) || (__IGOVD_i >  0.0))) || (1 && ((__AGIDL_i >  0.0) || (__AGIDLD_i >  0.0)))) || (__CGOV_i >  0.0)) || (__CGOVD_i >  0.0))) begin
          __SP_OV_xg = ((__xgs_ov + sqrt(((__xgs_ov * __xgs_ov) + __SP_OV_eps2_s))) *  0.5);
          __xs_ov = ((((- __SP_OV_xg) - (__GOV2_s *  0.5)) + (__GOV_s * sqrt(((__SP_OV_xg + (__GOV2_s *  0.25)) + __SP_OV_a_s)))) + __SP_OV_delta1_s);
          __SP_OV_xg = ((__xgd_ov + sqrt(((__xgd_ov * __xgd_ov) + __SP_OV_eps2_d))) *  0.5);
          __xd_ov = ((((- __SP_OV_xg) - (__GOV2_d *  0.5)) + (__GOV_d * sqrt(((__SP_OV_xg + (__GOV2_d *  0.25)) + __SP_OV_a_d)))) + __SP_OV_delta1_d);
          __Vovs = ((- __phita) * (__xgs_ov + __xs_ov));
          __Vovd = ((- __phita) * (__xgd_ov + __xd_ov));
        end
        Igsov =  0.0;
        Igdov =  0.0;
        __Igc =  0.0;
        __Igb =  0.0;
        Igcs =  0.0;
        Igcd =  0.0;
        if (1) begin
          if ((__IGOV_i >  0.0)) begin
            __zg = (sqrt(((__Vovs * __Vovs) +  1.0e-6)) * __inv_CHIB);
            if ((__GC3OV_i <  0.0)) begin
              __zg = (((__zg + __GCQOV) - sqrt((((__zg - __GCQOV) * (__zg - __GCQOV)) +  1.0e-6))) *  0.5);
            end
            temp = (__BOV * ((__zg * (__GC2OV_i + (__GC3OV_i * __zg))) + -1.5));
            if ((temp >  0.0)) begin
              __TP = ((temp * (((temp * ((temp *  0.333333333333333) +  1.0)) *  0.5) +  1.0)) +  1.0);
            end
            else begin
              if ((temp > -230.258509299405)) begin
                __TP = exp(temp);
              end
              else begin
                __TP = ( 100.0e-102 / (((-230.258509299405 - temp) * ((((-230.258509299405 - temp) * (((-230.258509299405 - temp) *  0.333333333333333) +  1.0)) *  0.5) +  1.0)) +  1.0));
              end
            end
            __Fs1 = (__xs_ov +  3.0);
            __Fs2 = (-3.0 - __GCO_i);
            __Fs3 = (__VgsPrime *  30.0);
            __tme1 =  3.1;
            __tme2 = (__Fs1 + __Fs3);
            temp = (( 2.0 / __tme1) * (__tme2 - sqrt(((__tme2 * __tme2) - ((__tme1 * __Fs1) * __Fs3)))));
            __tme1 =  3.7;
            __tme2 = (__Fs2 + temp);
            __Fs = (( 2.0 / __tme1) * (__tme2 + sqrt(((__tme2 * __tme2) - ((__tme1 * __Fs2) * temp)))));
            Igsov = (__IGOV_i * (__TP * __Fs));
          end
          if ((__IGOVD_i >  0.0)) begin
            __zg = (sqrt(((__Vovd * __Vovd) +  1.0e-6)) * __inv_CHIB);
            if ((__GC3OV_i <  0.0)) begin
              __zg = (((__zg + __GCQOV) - sqrt((((__zg - __GCQOV) * (__zg - __GCQOV)) +  1.0e-6))) *  0.5);
            end
            temp = (__BOV_d * ((__zg * (__GC2OV_i + (__GC3OV_i * __zg))) + -1.5));
            if ((temp >  0.0)) begin
              __TP = ((temp * (((temp * ((temp *  0.333333333333333) +  1.0)) *  0.5) +  1.0)) +  1.0);
            end
            else begin
              if ((temp > -230.258509299405)) begin
                __TP = exp(temp);
              end
              else begin
                __TP = ( 100.0e-102 / (((-230.258509299405 - temp) * ((((-230.258509299405 - temp) * (((-230.258509299405 - temp) *  0.333333333333333) +  1.0)) *  0.5) +  1.0)) +  1.0));
              end
            end
            __Fs1 = (__xd_ov +  3.0);
            __Fs2 = (-3.0 - __GCO_i);
            __Fs3 = (__VgdPrime *  30.0);
            __tme1 =  3.1;
            __tme2 = (__Fs1 + __Fs3);
            temp = (( 2.0 / __tme1) * (__tme2 - sqrt(((__tme2 * __tme2) - ((__tme1 * __Fs1) * __Fs3)))));
            __tme1 =  3.7;
            __tme2 = (__Fs2 + temp);
            __Fs = (( 2.0 / __tme1) * (__tme2 + sqrt(((__tme2 * __tme2) - ((__tme1 * __Fs2) * temp)))));
            Igdov = (__IGOVD_i * (__TP * __Fs));
          end
          if ((__IGINV_i >  0.0)) begin
            if ((xg_dc <=  0.0)) begin
              temp = pow((__Vds / __Vdsat_lim), __AX_i);
              __Udse_dc = ((__Vds * pow((temp +  1.0), (- __inv_AX))) * inv_phit1);
            end
            if (((__x_ds_dc - __Udse_dc) > -230.258509299405)) begin
              temp = exp((__x_ds_dc - __Udse_dc));
            end
            else begin
              temp = ( 100.0e-102 / (((-230.258509299405 - (__x_ds_dc - __Udse_dc)) * ((((-230.258509299405 - (__x_ds_dc - __Udse_dc)) * (((-230.258509299405 - (__x_ds_dc - __Udse_dc)) *  0.333333333333333) +  1.0)) *  0.5) +  1.0)) +  1.0));
            end
            __Vm = (__Vsbstar_dc + (phit1 * ((__x_ds_dc *  0.5) - ln(((temp +  1.0) *  0.5)))));
            __Dch = (__GCO_i * phit1);
            __arg2mina = (__Voxm_dc + __Dch);
            __psi_t = ((__arg2mina - sqrt(((( 0.0 - __arg2mina) * ( 0.0 - __arg2mina)) +  0.01))) *  0.5);
            __zg = (sqrt(((__Voxm_dc * __Voxm_dc) +  1.0e-6)) * __inv_CHIB);
            if ((__GC3_i <  0.0)) begin
              __zg = (((__zg + __GCQ) - sqrt((((__zg - __GCQ) * (__zg - __GCQ)) +  1.0e-6))) *  0.5);
            end
            __arg1 = (__x_m_dc + (((__psi_t - __alpha_b) - __Vm) * inv_phit1));
            if ((abs(__arg1) <  230.258509299405)) begin
              __Dsi = exp(__arg1);
            end
            else begin
              if ((__arg1 <  0.0)) begin
                __Dsi = ( 100.0e-102 / (((-230.258509299405 - __arg1) * ((((-230.258509299405 - __arg1) * (((-230.258509299405 - __arg1) *  0.333333333333333) +  1.0)) *  0.5) +  1.0)) +  1.0));
              end
              else begin
                __Dsi = ((((__arg1 -  230.258509299405) * ((((__arg1 -  230.258509299405) * (((__arg1 -  230.258509299405) *  0.333333333333333) +  1.0)) *  0.5) +  1.0)) +  1.0) *  10.0e+99);
              end
            end
            __arg1 = ((- ((__Vgs + __Vsbstar_dc) - __Vm)) * inv_phit1);
            if ((abs(__arg1) <  230.258509299405)) begin
              temp = exp(__arg1);
            end
            else begin
              if ((__arg1 <  0.0)) begin
                temp = ( 100.0e-102 / (((-230.258509299405 - __arg1) * ((((-230.258509299405 - __arg1) * (((-230.258509299405 - __arg1) *  0.333333333333333) +  1.0)) *  0.5) +  1.0)) +  1.0));
              end
              else begin
                temp = ((((__arg1 -  230.258509299405) * ((((__arg1 -  230.258509299405) * (((__arg1 -  230.258509299405) *  0.333333333333333) +  1.0)) *  0.5) +  1.0)) +  1.0) *  10.0e+99);
              end
            end
            __Dgate = (__Dsi * temp);
            temp = (__BCH * ((__zg * (__GC2_i + (__GC3_i * __zg))) + -1.5));
            if ((temp >  0.0)) begin
              __TP = ((temp * (((temp * ((temp *  0.333333333333333) +  1.0)) *  0.5) +  1.0)) +  1.0);
            end
            else begin
              if ((temp > -230.258509299405)) begin
                __TP = exp(temp);
              end
              else begin
                __TP = ( 100.0e-102 / (((-230.258509299405 - temp) * ((((-230.258509299405 - temp) * (((-230.258509299405 - temp) *  0.333333333333333) +  1.0)) *  0.5) +  1.0)) +  1.0));
              end
            end
            __Igc0 = (__IGINV_i * (__TP * ln(((__Dsi +  1.0) / (__Dgate +  1.0)))));
            if (((xg_dc <=  0.0) || ((__GC2_i ==  0.0) && (__GC3_i ==  0.0)))) begin
              __igc =  1.0;
              __igcd_h =  0.5;
            end
            else begin
              temp = (__GC2_i + ((__GC3_i *  2.0) * __zg));
              __u0 = (__CHIB_i / (temp * __BCH));
              __x = ((dps_dc / __u0) *  0.5);
              __u0_div_H = (__u0 / H_dc);
              __Bg = ((__u0_div_H * ( 1.0 - __u0_div_H)) *  0.5);
              __Ag = ( 0.5 - (__Bg *  3.0));
              if ((__x <  0.001)) begin
                __xsq = (__x * __x);
                __igc = ((__xsq * (((__u0_div_H *  0.333333333333333) +  0.166666666666667) + ((__xsq * ((__u0_div_H *  0.2) +  0.05)) *  0.166666666666667))) +  1.0);
                __igcd_h = ((__igc *  0.5) - ((__x * ((__xsq * (((__Bg +  0.25) *  0.4) + ((__xsq * (__Bg +  0.125)) *  0.0285714285714))) +  1.0)) *  0.166666666666667));
              end
              else begin
                __inv_x = ( 1.0 / __x);
                if ((abs(__x) <  230.258509299405)) begin
                  __ex = exp(__x);
                end
                else begin
                  if ((__x <  0.0)) begin
                    __ex = ( 100.0e-102 / (((-230.258509299405 - __x) * ((((-230.258509299405 - __x) * (((-230.258509299405 - __x) *  0.333333333333333) +  1.0)) *  0.5) +  1.0)) +  1.0));
                  end
                  else begin
                    __ex = ((((__x -  230.258509299405) * ((((__x -  230.258509299405) * (((__x -  230.258509299405) *  0.333333333333333) +  1.0)) *  0.5) +  1.0)) +  1.0) *  10.0e+99);
                  end
                end
                __inv_ex = ( 1.0 / __ex);
                temp = (__ex - __inv_ex);
                temp2 = (__ex + __inv_ex);
                __igc = ((((( 1.0 - __u0_div_H) * temp) * __inv_x) + (__u0_div_H * temp2)) *  0.5);
                __igcd_h = (((__igc - (temp * (__Bg - ((__Ag * __inv_x) * __inv_x)))) - ((__Ag * temp2) * __inv_x)) *  0.5);
              end
            end
            __Sg = (((xg_dc / sqrt(((xg_dc * xg_dc) +  1.0e-6))) +  1.0) *  0.5);
            __Igc = ((__Igc0 * __igc) * __Sg);
            Igcd = ((__Igc0 * __igcd_h) * __Sg);
            Igcs = (__Igc - Igcd);
            __Igb = ((__Igc0 * __igc) * ( 1.0 - __Sg));
          end
        end
        __Igidl =  0.0;
        __Igisl =  0.0;
        if (1) begin
          if (((__AGIDLD_i >  0.0) && (__Vovd <  0.0))) begin
            __Vtovd = sqrt((((__Vovd * __Vovd) + ((__CGIDLD_i * __CGIDLD_i) * (__VdbPrime * __VdbPrime))) +  1.0e-6));
            temp = ((- __BGIDLDs) / __Vtovd);
            if ((temp > -230.258509299405)) begin
              temp2 = exp(temp);
            end
            else begin
              temp2 = ( 100.0e-102 / (((-230.258509299405 - temp) * ((((-230.258509299405 - temp) * (((-230.258509299405 - temp) *  0.333333333333333) +  1.0)) *  0.5) +  1.0)) +  1.0));
            end
            __Igidl = ((- __AGIDLDs) * (((__VdbPrime * __Vovd) * __Vtovd) * temp2));
          end
          if (((__AGIDL_i >  0.0) && (__Vovs <  0.0))) begin
            __Vtovs = sqrt((((__Vovs * __Vovs) + ((__CGIDL_i * __CGIDL_i) * (__VsbPrime * __VsbPrime))) +  1.0e-6));
            temp = ((- __BGIDLs) / __Vtovs);
            if ((temp > -230.258509299405)) begin
              temp2 = exp(temp);
            end
            else begin
              temp2 = ( 100.0e-102 / (((-230.258509299405 - temp) * ((((-230.258509299405 - temp) * (((-230.258509299405 - temp) *  0.333333333333333) +  1.0)) *  0.5) +  1.0)) +  1.0));
            end
            __Igisl = ((- __AGIDLs) * (((__VsbPrime * __Vovs) * __Vtovs) * temp2));
          end
        end
        xgedge =  0.0;
        qdseffedge =  0.0;
        qmeffedge =  0.0;
        dsqredge =  100.0e-42;
        alphabmedge =  1.0;
        Idsedge =  0.0;
        if (0) begin
          if (0) begin
          end
          else begin
          end
          if ((__Q_EDGE_xgt > -12.0)) begin
            if (((__Q_EDGE_xgt - __Q_EDGE_qi0) <  230.258509299405)) begin
            end
            else begin
            end
          end
          else begin
            if (((__Q_EDGE_n_inv * (__Q_EDGE_xgt + __lnGfedge2)) > -230.258509299405)) begin
            end
            else begin
            end
          end
          if (((qseffedge <  0.001) && (Vdse_dc <  1.0e-6))) begin
            if ((((- xnedge_d) + xnedge_s) > -230.258509299405)) begin
            end
            else begin
            end
          end
          else begin
            if ((__Q_EDGE_xgt > -12.0)) begin
              if (((__Q_EDGE_xgt - __Q_EDGE_qi0) <  230.258509299405)) begin
              end
              else begin
              end
            end
            else begin
              if (((__Q_EDGE_n_inv * (__Q_EDGE_xgt + __lnGfedge2)) > -230.258509299405)) begin
              end
              else begin
              end
            end
          end
        end
        if (((xg_dc >  0.0) && 1)) begin
          __delVsat = (__Vds - (__A3_i * dps_dc));
          if ((__delVsat >  0.0)) begin
            temp2 = (__A2_T * (((__A4_i * (sqrt((__phib_dc + __Vsbstar_dc)) - __sqrt_phib_dc)) +  1.0) / (__delVsat +  1.0e-30)));
            if ((abs((- temp2)) <  230.258509299405)) begin
              temp = exp((- temp2));
            end
            else begin
              if (((- temp2) <  0.0)) begin
                temp = ( 100.0e-102 / (((-230.258509299405 - (- temp2)) * ((((-230.258509299405 - (- temp2)) * (((-230.258509299405 - (- temp2)) *  0.333333333333333) +  1.0)) *  0.5) +  1.0)) +  1.0));
              end
              else begin
                temp = (((((- temp2) -  230.258509299405) * (((((- temp2) -  230.258509299405) * ((((- temp2) -  230.258509299405) *  0.333333333333333) +  1.0)) *  0.5) +  1.0)) +  1.0) *  10.0e+99);
              end
            end
            mavl = (__A1_i * (__delVsat * temp));
            Iimpact = (mavl * (Ids + Idsedge));
          end
        end
        __P_D = (((__Gf_dc * __kp) *  0.25) +  1.0);
        __facvsb0 = (__phib_dc + (phit1 *  2.0));
        __facvsb = (__Vsbstar_dc + __facvsb0);
        __vts_i = (((__VFB_T + (__P_D * __facvsb)) - __Vsbstar_dc) + (__Gf_dc * sqrt((phit1 * __facvsb))));
        __vth_i = (__vts_i - __delVg);
      end
      begin : evaluateDynamic
        real Vginr, Vginreff, fqinr, dVinracc, finracc, xginrdep, finrdep, dVinrdep, finr, dVinr, xgbeff_ov_s;
        real yb_ov_s, xgbeff_ov_d, yb_ov_d;
        begin : SPcalc_ac
          real phib, G_0, Vsbstar, cfloc, thesatloc, axloc, alploc;
          real Vsbx, xg, Dnsub, Gf, Gf2, inv_Gf2, xi, inv_xi, Ux, xn_s, delta_ns, margin, x_s, delta_1s, xi0s, xi1s;
          real xi2s, Es, Ds, Ps, Rxcor, xgs, qis, qbs, rhob, GR, Eeffm, Mutmp, Gmob, xitsb, wsat, thesat1, phi_inf;
          real ysat, za, Phi_0, asat, Phi_2, Phi_0_2, Phi0_Phi2, Phi_sat, Vdse, Udse, xn_d, k_ds, delta_nd, x_d, x_ds;
          real pC, qC, dps, xi0d, Ed, Dd, Pd, sqd, qbd, x_m, Em, D_bar, Dm, Pm, xgm, eta_p, sqm, alpha, d0, x_pm, p_pd;
          real q_pd, xi_pd, u_pd, km, km0, qim, qim1, qbm, qeff, qeff1, s1, dL, GdL, Gmob_dL, zsat, Gvsat, Gvsatinv;
          real Voxm, alpha1, H, Vgsinr, Vsginr, Vgdinr, Vdginr;
          real SP_S_temp, SP_S_temp1, SP_S_temp2;
          real SP_S_yg, SP_S_ysub, SP_S_eta, SP_S_a, SP_S_c, SP_S_tau, SP_S_y0, SP_S_delta0, SP_S_delta1, SP_S_xi0;
          real SP_S_xi1, SP_S_xi2, SP_S_pC, SP_S_qC, SP_xg1, SP_S_A_fac, SP_S_xbar, SP_S_w, SP_S_x1, SP_S_bx, SP_S_b;
          real SP_S_x0;
          if (0) begin
            if (0) begin
            end
            if (0) begin
            end
            if (0) begin
            end
            else begin
            end
            if ((__DNSUB_i >  0.0)) begin
            end
            else begin
            end
            if ((__CTG_i >  0.0)) begin
              if ((temp2 > -230.258509299405)) begin
              end
              else begin
              end
            end
            if (0) begin
            end
            if ((xn_s <  460.517018598809)) begin
            end
            else begin
            end
            if ((abs(xg) <= margin)) begin
            end
            else begin
              if ((xg < (- margin))) begin
                if ((SP_S_y0 <  230.258509299405)) begin
                end
                else begin
                end
              end
              else begin
                if (((- SP_S_xbar) > -230.258509299405)) begin
                end
                else begin
                end
                if ((SP_S_x0 <  230.258509299405)) begin
                end
                else begin
                  if ((SP_S_x0 > (xn_s -  230.258509299405))) begin
                  end
                  else begin
                  end
                end
              end
            end
            if ((xg <=  0.0)) begin
            end
            else begin
              if ((x_s <  230.258509299405)) begin
              end
              else begin
                if ((x_s > (xn_s -  230.258509299405))) begin
                end
                else begin
                end
              end
              if ((x_s <  10.0e-6)) begin
              end
              else begin
              end
              if ((Ds >  100.0e-102)) begin
                if ((__RSB_i <  0.0)) begin
                end
                else begin
                end
                if ((__RSG_i <  0.0)) begin
                end
                else begin
                end
                if ((__THESATB_i <  0.0)) begin
                end
                else begin
                end
                if ((__THESATG_i <  0.0)) begin
                end
                else begin
                end
                if ((__CHNL_TYPE == -1)) begin
                end
              end
              else begin
              end
              if ((Udse <  460.517018598809)) begin
              end
              else begin
              end
              if ((abs(xg) <= margin)) begin
              end
              else begin
                if ((SP_S_x0 <  230.258509299405)) begin
                end
                else begin
                  if ((SP_S_x0 > (xn_d -  230.258509299405))) begin
                  end
                  else begin
                  end
                end
              end
              if ((x_ds <  100.0e-12)) begin
              end
              if ((x_d <  230.258509299405)) begin
                if ((x_d <  10.0e-6)) begin
                end
                else begin
                end
              end
              else begin
                if ((x_d > (xn_d -  230.258509299405))) begin
                end
                else begin
                end
              end
              if ((temp >  0.0)) begin
              end
              if ((x_m <  10.0e-6)) begin
                if ((__kp >  0.0)) begin
                end
              end
              else begin
                if ((__kp >  0.0)) begin
                end
              end
              if ((__RSG_i <  0.0)) begin
              end
              else begin
              end
              if ((__THESATG_i <  0.0)) begin
              end
              else begin
              end
              if ((__CHNL_TYPE == -1)) begin
              end
            end
          end
          else begin
            __Vgb1_ac = Vgb1_dc;
            __xg_ac = xg_dc;
            __qeff1_ac = __qeff1_dc;
            __Voxm_ac = __Voxm_dc;
            __alpha_ac = alpha_dc;
            __dps_ac = dps_dc;
            __qim_ac = qim_dc;
            __GdL_ac = __GdL_dc;
            __H_ac = H_dc;
            eta_p_ac = __eta_p_dc;
            Gvsat_ac = __Gvsat_dc;
            Gmob_dL_ac = __Gmob_dL_dc;
            __Gf_ac = __Gf_dc;
            Vgsinr_ac = Vgsinr_dc;
            Vsginr_ac = Vsginr_dc;
            Vgdinr_ac = Vgdinr_dc;
            Vdginr_ac = Vdginr_dc;
            __x_m_ac = __x_m_dc;
            __xgm_ac = __xgm_dc;
            __thesat1_ac = __thesat1_dc;
            __margin_ac = __margin_dc;
          end
        end
        COX_qm = __COX_i;
        if ((__qq >  0.0)) begin
          COX_qm = (__COX_i / ((__qq * pow(((__qeff1_ac * __qeff1_ac) + __qlim2), -0.166666666666667)) +  1.0));
        end
        if ((__xg_ac <=  0.0)) begin
          __QG = __Voxm_ac;
          __QI =  0.0;
          __QD =  0.0;
          __QB = __QG;
        end
        else begin
          __Fj = ((__dps_ac / __H_ac) *  0.5);
          __Fj2 = (__Fj * __Fj);
          __QG = (__Voxm_ac + (((eta_p_ac * __dps_ac) * ((((__Fj * __GdL_ac) *  0.333333333333333) -  1.0) + __GdL_ac)) *  0.5));
          temp = ((__alpha_ac * __dps_ac) *  0.166666666666667);
          if (0) begin
          end
          else begin
            __QCLM = (( 1.0 - __GdL_ac) * (__qim_ac - ((__alpha_ac * __dps_ac) *  0.5)));
            __QD = ((((__GdL_ac * __GdL_ac) * (__qim_ac - (temp * (( 1.0 - __Fj) - (__Fj2 *  0.2))))) + (__QCLM * (__GdL_ac +  1.0))) *  0.5);
          end
          __QI = ((__GdL_ac * (__qim_ac + (temp * __Fj))) + __QCLM);
          __QB = (__QG - __QI);
        end
        __Qg = (__QG * COX_qm);
        __Qd = ((- __QD) * COX_qm);
        __Qb = ((- __QB) * COX_qm);
        __Qsinr =  0.0;
        __Qdinr =  0.0;
        __Qginr =  0.0;
        if (((__CINR_i >  0.0) || (__CINRD_i >  0.0))) begin
          finracc =  1.0;
          dVinracc = __Vgb1_ac;
          if ((__FCINRACC_i >  100.0e-12)) begin
            Vginr = ((__Vgb1_ac - __DVFBINR_i) + __Vinr_max);
            temp = (((Vginr + __Vinr_max) + sqrt((((Vginr - __Vinr_max) * (Vginr - __Vinr_max)) + __ainr))) *  0.5);
            temp1 = (temp * (((temp *  2.0) - __Vinr_max) - Vginr));
            temp2 = (__Vinr_max / temp);
            Vginreff = (Vginr * temp2);
            fqinr = sqrt(( 1.0 - (Vginreff * __FCINRACC_i)));
            dVinracc = (((( 1.0 - fqinr) / __FCINRACC_i) + Vginr) - Vginreff);
            finracc = (((((( 0.5 / fqinr) -  1.0) * (temp1 + (Vginr * (__Vinr_max - temp)))) * temp2) / temp1) +  1.0);
          end
          finrdep =  1.0;
          dVinrdep =  0.0;
          if ((__FCINRDEP_i >  0.0)) begin
            temp = ((__phib_ac *  0.5) + (phit1 * ((__Gf_ac *  0.707106781186547) +  1.0)));
            xginrdep = (__Vgb1_ac / temp);
            if ((abs(xginrdep) <  230.258509299405)) begin
              finrdep = ( 1.0 / (exp((- xginrdep)) +  1.0));
            end
            else begin
              if ((xginrdep <  0.0)) begin
                finrdep = ( 100.0e-102 / (((xginrdep + -230.258509299405) * ((((xginrdep + -230.258509299405) * (((xginrdep + -230.258509299405) *  0.333333333333333) +  1.0)) *  0.5) +  1.0)) +  1.0));
              end
            end
            if ((xginrdep <  230.258509299405)) begin
              temp1 = ln((exp(xginrdep) +  1.0));
            end
            else begin
              temp1 = xginrdep;
            end
            dVinrdep = (temp * temp1);
          end
          finr = ((__FCINRDEP_i * (finrdep - finracc)) + finracc);
          dVinr = ((__FCINRDEP_i * (dVinrdep - dVinracc)) + dVinracc);
          if ((sigVds >  0.0)) begin
            __Qginr = (finr * ((__CINRD_i * Vgdinr_ac) + (__CINR_i * Vgsinr_ac)));
            __Qsinr = (__CINR_i * (Vsginr_ac - dVinr));
            __Qdinr = (__CINRD_i * (Vdginr_ac - dVinr));
          end
          else begin
            __Qginr = (finr * ((__CINR_i * Vgdinr_ac) + (__CINRD_i * Vgsinr_ac)));
            __Qsinr = (__CINRD_i * (Vsginr_ac - dVinr));
            __Qdinr = (__CINR_i * (Vdginr_ac - dVinr));
          end
          __Qg = (__Qg + __Qginr);
          __Qd = (__Qd + __Qdinr);
          __Qb = (((__Qb - __Qginr) - __Qdinr) - __Qsinr);
        end
        __Qgs_ov = (__CGOV_i * __Vovs);
        __Qgd_ov = (__CGOVD_i * __Vovd);
        __Qg_ov_s =  0.0;
        yb_ov_s =  0.0;
        if (((__CGOV_i >  0.0) && (__FCGOVACC_i >  0.0))) begin
          temp = (__CGOVACCG_i * ((__xgb_ov *  0.5) + __dxgb_ov_s));
          if ((temp <  230.258509299405)) begin
            if ((temp > -230.258509299405)) begin
              yb_ov_s = exp(temp);
            end
            else begin
              yb_ov_s = ( 100.0e-102 / (((-230.258509299405 - temp) * ((((-230.258509299405 - temp) * (((-230.258509299405 - temp) *  0.333333333333333) +  1.0)) *  0.5) +  1.0)) +  1.0));
            end
            if ((yb_ov_s >  100.0e-12)) begin
              xgbeff_ov_s = ln((yb_ov_s +  1.0));
              temp1 = (xgbeff_ov_s * ( 1.0 - (ln((xgbeff_ov_s +  1.0)) / (xgbeff_ov_s +  2.0))));
            end
            else begin
              xgbeff_ov_s = yb_ov_s;
              temp1 = ((xgbeff_ov_s *  2.0) / (xgbeff_ov_s +  2.0));
            end
          end
          else begin
            xgbeff_ov_s = temp;
            temp1 = (xgbeff_ov_s * ( 1.0 - (ln((xgbeff_ov_s +  1.0)) / (xgbeff_ov_s +  2.0))));
          end
          __Qg_ov_s = (((((__FCGOVACC_i * -2.0) / __CGOVACCG_i) * __CGOV_i) * __phita) * temp1);
        end
        __Qg_ov_d =  0.0;
        yb_ov_d =  0.0;
        if (((__CGOVD_i >  0.0) && (__FCGOVACCD_i >  0.0))) begin
          temp = (__CGOVACCG_i * ((__xgb_ov *  0.5) + __dxgb_ov_d));
          if ((temp <  230.258509299405)) begin
            if ((temp > -230.258509299405)) begin
              yb_ov_d = exp(temp);
            end
            else begin
              yb_ov_d = ( 100.0e-102 / (((-230.258509299405 - temp) * ((((-230.258509299405 - temp) * (((-230.258509299405 - temp) *  0.333333333333333) +  1.0)) *  0.5) +  1.0)) +  1.0));
            end
            if ((yb_ov_d >  100.0e-12)) begin
              xgbeff_ov_d = ln((yb_ov_d +  1.0));
              temp1 = (xgbeff_ov_d * ( 1.0 - (ln((xgbeff_ov_d +  1.0)) / (xgbeff_ov_d +  2.0))));
            end
            else begin
              xgbeff_ov_d = yb_ov_d;
              temp1 = ((xgbeff_ov_d *  2.0) / (xgbeff_ov_d +  2.0));
            end
          end
          else begin
            xgbeff_ov_d = temp;
            temp1 = (xgbeff_ov_d * ( 1.0 - (ln((xgbeff_ov_d +  1.0)) / (xgbeff_ov_d +  2.0))));
          end
          __Qg_ov_d = (((((__FCGOVACCD_i * -2.0) / __CGOVACCG_i) * __CGOVD_i) * __phita) * temp1);
        end
        __Qg_ov = (__Qg_ov_s + __Qg_ov_d);
        __Qgb_ov = ((__CGBOV_i * __Vgb) + __Qg_ov);
        __Qfgs = (__CFR_i * __VgsPrime);
        __Qfgd = (__CFRD_i * __VgdPrime);
        __Gp =  0.0;
        __Gp2 =  0.0;
        __a_factrp =  0.0;
        __marginp =  0.0;
        if ((__SWNQS_i != 0)) begin
          if ((__xg_ac <=  0.0)) begin
            __ym =  0.5;
            __pd =  1.0;
            __Gp = __Gf_ac;
          end
          else begin
            __ym = ((((__dps_ac / __H_ac) *  0.25) +  1.0) *  0.5);
            __pd = (__xgm_ac / (__xg_ac - __x_m_ac));
            __Gp = (__Gf_ac / __pd);
          end
          __Gp2 = (__Gp * __Gp);
          __a_factrp = ((__Gp *  0.707106781186547) +  1.0);
          __marginp = (__a_factrp *  10.0e-6);
        end
      end
      begin : evaluateStaticDynamic
        real ysq, terfc, erfcpos;
        real h1, h2, h2d, h3, h4, h5;
        real idmult, vj, z, zinv, two_psistar, vjlim, vjsrh, vbbt, vav;
        real tmp, id;
        real isrh, vbi_minus_vjsrh, wsrhstep, dwsrh, wsrh, wdep, asrh;
        real itat, btat, twoatatoverthreebtat, umaxbeforelimiting, umax, sqrtumax, umaxpoweronepointfive;
        real wgamma, wtat, ktat, ltat, mtat, xerfc, erfctimesexpmtat, gammamax;
        real ibbt, Fmaxr;
        real fbreakdown;
        ysq =  0.0;
        terfc =  0.0;
        erfcpos =  0.0;
        h1 =  0.0;
        h2 =  0.0;
        h2d =  0.0;
        h3 =  0.0;
        h4 =  0.0;
        h5 =  0.0;
        idmult =  0.0;
        vj =  0.0;
        z =  0.0;
        zinv =  0.0;
        two_psistar =  0.0;
        vjlim =  0.0;
        vjsrh =  0.0;
        vbbt =  0.0;
        vav =  0.0;
        tmp =  0.0;
        id =  0.0;
        isrh =  0.0;
        vbi_minus_vjsrh =  0.0;
        wsrhstep =  0.0;
        dwsrh =  0.0;
        wsrh =  0.0;
        wdep =  0.0;
        asrh =  0.0;
        itat =  0.0;
        btat =  0.0;
        twoatatoverthreebtat =  0.0;
        umaxbeforelimiting =  0.0;
        umax =  0.0;
        sqrtumax =  0.0;
        umaxpoweronepointfive =  0.0;
        wgamma =  0.0;
        wtat =  0.0;
        ktat =  0.0;
        ltat =  0.0;
        mtat =  0.0;
        xerfc =  0.0;
        erfctimesexpmtat =  0.0;
        gammamax =  0.0;
        ibbt =  0.0;
        Fmaxr =  0.0;
        fbreakdown =  0.0;
        ijun_s =  0.0;
        ijunbot_s =  0.0;
        ijunsti_s =  0.0;
        ijungat_s =  0.0;
        ijun_d =  0.0;
        ijunbot_d =  0.0;
        ijunsti_d =  0.0;
        ijungat_d =  0.0;
        qjun_s =  0.0;
        qjunbot_s =  0.0;
        qjunsti_s =  0.0;
        qjungat_s =  0.0;
        qjun_d =  0.0;
        qjunbot_d =  0.0;
        qjunsti_d =  0.0;
        qjungat_d =  0.0;
        if (1) begin
          if ((__SWJUNEXP_i == 1)) begin
            __tm0 = ((__Vjun_s * __phitdinv) * __MFOR1_s);
            __tm1 = (((__tm0 < -230.258509299405))? (( 100.0e-102 / (-229.258509299405 - __tm0))):((((__tm0 > __xhighf1_s))? ((__expxhf1_s * ((__tm0 - __xhighf1_s) +  1.0))):(exp(__tm0)))));
            __ijunfor1 = (__ISATFOR1_s * (__tm1 -  1.0));
            __tm0 = ((__Vjun_s * __phitdinv) * __MFOR2_s);
            __tm1 = (((__tm0 < -230.258509299405))? (( 100.0e-102 / (-229.258509299405 - __tm0))):((((__tm0 > __xhighf2_s))? ((__expxhf2_s * ((__tm0 - __xhighf2_s) +  1.0))):(exp(__tm0)))));
            __ijunfor2 = (__ISATFOR2_s * (__tm1 -  1.0));
            __ijunrev =  0.0;
            if ((__m0flag_s >  0.0)) begin
              __ijunrev = (__Vjun_s * (__ISATREV_s + (__Vjun_s * __MREV_s)));
            end
            else begin
              __tm0 = (((- __Vjun_s) * __phitdinv) * __MREV_s);
              __tm1 = (((__tm0 < -230.258509299405))? (( 100.0e-102 / (-229.258509299405 - __tm0))):((((__tm0 > __xhighr_s))? ((__expxhr_s * ((__tm0 - __xhighr_s) +  1.0))):(exp(__tm0)))));
              __ijunrev = ((- __ISATREV_s) * (__tm1 -  1.0));
            end
            ijun_s = ((__ijunfor1 + __ijunfor2) + __ijunrev);
            __tm0 = ((__Vjun_d * __phitdinv) * __MFOR1_d);
            __tm1 = (((__tm0 < -230.258509299405))? (( 100.0e-102 / (-229.258509299405 - __tm0))):((((__tm0 > __xhighf1_d))? ((__expxhf1_d * ((__tm0 - __xhighf1_d) +  1.0))):(exp(__tm0)))));
            __ijunfor1 = (__ISATFOR1_d * (__tm1 -  1.0));
            __tm0 = ((__Vjun_d * __phitdinv) * __MFOR2_d);
            __tm1 = (((__tm0 < -230.258509299405))? (( 100.0e-102 / (-229.258509299405 - __tm0))):((((__tm0 > __xhighf2_d))? ((__expxhf2_d * ((__tm0 - __xhighf2_d) +  1.0))):(exp(__tm0)))));
            __ijunfor2 = (__ISATFOR2_d * (__tm1 -  1.0));
            __ijunrev =  0.0;
            if ((__m0flag_d >  0.0)) begin
              __ijunrev = (__Vjun_d * (__ISATREV_d + (__Vjun_d * __MREV_d)));
            end
            else begin
              __tm0 = (((- __Vjun_d) * __phitdinv) * __MREV_d);
              __tm1 = (((__tm0 < -230.258509299405))? (( 100.0e-102 / (-229.258509299405 - __tm0))):((((__tm0 > __xhighr_d))? ((__expxhr_d * ((__tm0 - __xhighr_d) +  1.0))):(exp(__tm0)))));
              __ijunrev = ((- __ISATREV_d) * (__tm1 -  1.0));
            end
            ijun_d = ((__ijunfor1 + __ijunfor2) + __ijunrev);
            begin : evaluateDynamic
              real tmpv, vjv;
              tmpv =  0.0;
              vjv =  0.0;
              h1 = ((__vch_s *  4.0) * __vch_s);
              h2 = (__vch_s / __vfmin_s);
              h2d = (__Vjun_s + (__vch_s * h2));
              h3 = (__vfmin_s + h2d);
              h4 = (__vfmin_s - h2d);
              h5 = sqrt(((h4 * h4) + h1));
              vjv = (((__Vjun_s * __vfmin_s) / (h3 + h5)) *  2.0);
              if ((__zflagbot_s >  0.5)) begin
                if ((__one_minus_PBOT ==  0.5)) begin
                  tmpv = sqrt(( 1.0 - (vjv * __vbiinvbot)));
                end
                else begin
                  tmpv = pow(( 1.0 - (vjv * __vbiinvbot)), __one_minus_PBOT);
                end
                qjunbot_s = ((__qprefbot * ( 1.0 - tmpv)) + (__qpref2bot * (__Vjun_s - vjv)));
              end
              if ((__zflagsti_s >  0.5)) begin
                if ((__one_minus_PSTI ==  0.5)) begin
                  tmpv = sqrt(( 1.0 - (vjv * __vbiinvsti)));
                end
                else begin
                  tmpv = pow(( 1.0 - (vjv * __vbiinvsti)), __one_minus_PSTI);
                end
                qjunsti_s = ((__qprefsti * ( 1.0 - tmpv)) + (__qpref2sti * (__Vjun_s - vjv)));
              end
              if ((__zflaggat_s >  0.5)) begin
                if ((__one_minus_PGAT ==  0.5)) begin
                  tmpv = sqrt(( 1.0 - (vjv * __vbiinvgat)));
                end
                else begin
                  tmpv = pow(( 1.0 - (vjv * __vbiinvgat)), __one_minus_PGAT);
                end
                qjungat_s = ((__qprefgat * ( 1.0 - tmpv)) + (__qpref2gat * (__Vjun_s - vjv)));
              end
              tmpv =  0.0;
              vjv =  0.0;
              h1 = ((__vch_d *  4.0) * __vch_d);
              h2 = (__vch_d / __vfmin_d);
              h2d = (__Vjun_d + (__vch_d * h2));
              h3 = (__vfmin_d + h2d);
              h4 = (__vfmin_d - h2d);
              h5 = sqrt(((h4 * h4) + h1));
              vjv = (((__Vjun_d * __vfmin_d) / (h3 + h5)) *  2.0);
              if ((__zflagbot_d >  0.5)) begin
                if ((__one_minus_PBOT_d ==  0.5)) begin
                  tmpv = sqrt(( 1.0 - (vjv * __vbiinvbot_d)));
                end
                else begin
                  tmpv = pow(( 1.0 - (vjv * __vbiinvbot_d)), __one_minus_PBOT_d);
                end
                qjunbot_d = ((__qprefbot_d * ( 1.0 - tmpv)) + (__qpref2bot_d * (__Vjun_d - vjv)));
              end
              if ((__zflagsti_d >  0.5)) begin
                if ((__one_minus_PSTI_d ==  0.5)) begin
                  tmpv = sqrt(( 1.0 - (vjv * __vbiinvsti_d)));
                end
                else begin
                  tmpv = pow(( 1.0 - (vjv * __vbiinvsti_d)), __one_minus_PSTI_d);
                end
                qjunsti_d = ((__qprefsti_d * ( 1.0 - tmpv)) + (__qpref2sti_d * (__Vjun_d - vjv)));
              end
              if ((__zflaggat_d >  0.5)) begin
                if ((__one_minus_PGAT_d ==  0.5)) begin
                  tmpv = sqrt(( 1.0 - (vjv * __vbiinvgat_d)));
                end
                else begin
                  tmpv = pow(( 1.0 - (vjv * __vbiinvgat_d)), __one_minus_PGAT_d);
                end
                qjungat_d = ((__qprefgat_d * ( 1.0 - tmpv)) + (__qpref2gat_d * (__Vjun_d - vjv)));
              end
            end
          end
          else begin
            vbbt =  0.0;
            two_psistar =  0.0;
            if ((! (((__ABSOURCE_i ==  0.0) && (__LSSOURCE_i ==  0.0)) && (__LGSOURCE_i ==  0.0)))) begin
              h1 = ((__vch_s *  4.0) * __vch_s);
              h2 = (__vch_s / __vfmin_s);
              h2d = (__Vjun_s + (__vch_s * h2));
              h3 = (__vfmin_s + h2d);
              h4 = (__vfmin_s - h2d);
              h5 = sqrt(((h4 * h4) + h1));
              vj = (((__Vjun_s * __vfmin_s) / (h3 + h5)) *  2.0);
              if ((__Vjun_s < __VMAX_s)) begin
                if ((abs(((__Vjun_s * __phitdinv) *  0.5)) <  230.258509299405)) begin
                  zinv = exp(((__Vjun_s * __phitdinv) *  0.5));
                end
                else begin
                  if ((((__Vjun_s * __phitdinv) *  0.5) <  0.0)) begin
                    zinv = ( 100.0e-102 / (((-230.258509299405 - ((__Vjun_s * __phitdinv) *  0.5)) * ((((-230.258509299405 - ((__Vjun_s * __phitdinv) *  0.5)) * (((-230.258509299405 - ((__Vjun_s * __phitdinv) *  0.5)) *  0.333333333333333) +  1.0)) *  0.5) +  1.0)) +  1.0));
                  end
                  else begin
                    zinv = ((((((__Vjun_s * __phitdinv) *  0.5) -  230.258509299405) * ((((((__Vjun_s * __phitdinv) *  0.5) -  230.258509299405) * (((((__Vjun_s * __phitdinv) *  0.5) -  230.258509299405) *  0.333333333333333) +  1.0)) *  0.5) +  1.0)) +  1.0) *  10.0e+99);
                  end
                end
                idmult = (zinv * zinv);
              end
              else begin
                idmult = ((((__Vjun_s - __VMAX_s) * __phitdinv) +  1.0) * __exp_VMAX_over_phitd_s);
                zinv = sqrt(idmult);
              end
              idmult = (idmult -  1.0);
              z = ( 1.0 / zinv);
              if ((__Vjun_s >  0.0)) begin
                two_psistar = ((__phitd * ln(((z +  2.0) + sqrt(((z +  1.0) * (z +  3.0)))))) *  2.0);
              end
              else begin
                two_psistar = ((- __Vjun_s) + ((__phitd * ln((((zinv *  2.0) +  1.0) + sqrt(((zinv +  1.0) * ((zinv *  3.0) +  1.0)))))) *  2.0));
              end
              vjlim = (__vbimin_s - two_psistar);
              vjsrh = (((__Vjun_s + vjlim) - sqrt((((__Vjun_s - vjlim) * (__Vjun_s - vjlim)) + ((__phitd *  4.0) * __phitd)))) *  0.5);
              vbbt = (((__Vjun_s + __vbbtlim_s) - sqrt((((__Vjun_s - __vbbtlim_s) * (__Vjun_s - __vbbtlim_s)) + ((__phitr *  4.0) * __phitr)))) *  0.5);
              vav = ((__Vjun_s - sqrt(((__Vjun_s * __Vjun_s) +  4.0e-12))) *  0.5);
            end
            if ((__ABSOURCE_i ==  0.0)) begin
              ijunbot_s =  0.0;
              qjunbot_s =  0.0;
            end
            else begin
              if ((__one_minus_PBOT ==  0.5)) begin
                tmp = sqrt(( 1.0 - (vj * __vbiinvbot)));
              end
              else begin
                tmp = pow(( 1.0 - (vj * __vbiinvbot)), __one_minus_PBOT);
              end
              qjunbot_s = ((__qprefbot * ( 1.0 - tmp)) + (__qpref2bot * (__Vjun_s - vj)));
              id = (__idsatbot * idmult);
              if (0) begin
              end
              else begin
                vbi_minus_vjsrh = (__vbibot - vjsrh);
                wsrhstep = ( 1.0 - sqrt(( 1.0 - (two_psistar / vbi_minus_vjsrh))));
                if (0) begin
                end
                else begin
                  dwsrh = (((((wsrhstep * wsrhstep) * ln(wsrhstep)) / ( 1.0 - wsrhstep)) + wsrhstep) *  0.37382);
                end
                wsrh = (wsrhstep + dwsrh);
                if (0) begin
                end
                else begin
                  tmp = pow((vbi_minus_vjsrh * __VBIRBOTinv),  0.31309);
                end
                wdep = (__wdepnulrbot * tmp);
                asrh = (__ftdbot * ((zinv -  1.0) * wdep));
                isrh = ((asrh * wsrh) *  100.0);
              end
              if (0) begin
              end
              else begin
                btat = (__btatpartbot * ((wdep * __one_minus_PBOT) / vbi_minus_vjsrh));
                twoatatoverthreebtat = ((__atatbot *  0.666666666666667) / btat);
                umaxbeforelimiting = (twoatatoverthreebtat * twoatatoverthreebtat);
                umax = sqrt(((umaxbeforelimiting * umaxbeforelimiting) / ((umaxbeforelimiting * umaxbeforelimiting) +  1.0)));
                sqrtumax = sqrt(umax);
                umaxpoweronepointfive = (umax * sqrtumax);
                if (((__one_over_one_minus_PBOT * -0.31309) == -1.0)) begin
                  wgamma = ( 1.0 / ((btat * umaxpoweronepointfive) +  1.0));
                end
                else begin
                  wgamma = pow(((btat * umaxpoweronepointfive) +  1.0), (__one_over_one_minus_PBOT * -0.31309));
                end
                wtat = ((wsrh * wgamma) / (wsrh + wgamma));
                ktat = sqrt(((btat / sqrtumax) *  0.375));
                ltat = (((twoatatoverthreebtat * sqrtumax) *  2.0) - umax);
                mtat = ((((__atatbot * twoatatoverthreebtat) * sqrtumax) - (__atatbot * umax)) + ((btat * umaxpoweronepointfive) *  0.5));
                xerfc = ((ltat -  1.0) * ktat);
                ysq = (xerfc * xerfc);
                if ((xerfc >  0.0)) begin
                  terfc = ( 1.0 / ((__perfc * xerfc) +  1.0));
                end
                else begin
                  terfc = ( 1.0 / ( 1.0 - (__perfc * xerfc)));
                end
                if ((((- ysq) + mtat) > -230.258509299405)) begin
                  tmp = exp(((- ysq) + mtat));
                end
                else begin
                  tmp = ( 100.0e-102 / (((-230.258509299405 - ((- ysq) + mtat)) * ((((-230.258509299405 - ((- ysq) + mtat)) * (((-230.258509299405 - ((- ysq) + mtat)) *  0.333333333333333) +  1.0)) *  0.5) +  1.0)) +  1.0));
                end
                erfcpos = ((((terfc *  0.29214664) + (__berfc * (terfc * terfc))) + (__cerfc * ((terfc * terfc) * terfc))) * tmp);
                if ((xerfc >  0.0)) begin
                  erfctimesexpmtat = erfcpos;
                end
                else begin
                  if ((mtat > -230.258509299405)) begin
                    tmp = exp(mtat);
                  end
                  else begin
                    tmp = ( 100.0e-102 / (((-230.258509299405 - mtat) * ((((-230.258509299405 - mtat) * (((-230.258509299405 - mtat) *  0.333333333333333) +  1.0)) *  0.5) +  1.0)) +  1.0));
                  end
                  erfctimesexpmtat = ((tmp *  2.0) - erfcpos);
                end
                gammamax = (((__atatbot * erfctimesexpmtat) / ktat) *  0.886226925452758);
                itat = (((asrh * gammamax) * wtat) *  100.0);
              end
              if (0) begin
              end
              else begin
                if (0) begin
                end
                else begin
                  tmp = pow((( 0.70829 - vbbt) * __VBIRBOTinv),  0.31309);
                end
                Fmaxr = (__one_over_one_minus_PBOT * ((( 0.70829 - vbbt) * __wdepnulrinvbot) / tmp));
                if ((abs(((- __fbbtbot) / Fmaxr)) <  230.258509299405)) begin
                  tmp = exp(((- __fbbtbot) / Fmaxr));
                end
                else begin
                  if ((((- __fbbtbot) / Fmaxr) <  0.0)) begin
                    tmp = ( 100.0e-102 / (((-230.258509299405 - ((- __fbbtbot) / Fmaxr)) * ((((-230.258509299405 - ((- __fbbtbot) / Fmaxr)) * (((-230.258509299405 - ((- __fbbtbot) / Fmaxr)) *  0.333333333333333) +  1.0)) *  0.5) +  1.0)) +  1.0));
                  end
                  else begin
                    tmp = ((((((- __fbbtbot) / Fmaxr) -  230.258509299405) * ((((((- __fbbtbot) / Fmaxr) -  230.258509299405) * (((((- __fbbtbot) / Fmaxr) -  230.258509299405) *  0.333333333333333) +  1.0)) *  0.5) +  1.0)) +  1.0) *  10.0e+99);
                  end
                end
                ibbt = ((((__Vjun_s * Fmaxr) * Fmaxr) * tmp) *  1.0e-12);
              end
              if (0) begin
              end
              else begin
                if ((vav > ((- __alphaav) *  10.0))) begin
                  if (1) begin
                    tmp = ((((vav * __VBRinvbot) * (vav * __VBRinvbot)) * (vav * __VBRinvbot)) * (vav * __VBRinvbot));
                  end
                  else begin
                  end
                  fbreakdown = ( 1.0 / ( 1.0 - tmp));
                end
                else begin
                  fbreakdown = (__fstopbot + ((vav + (__alphaav *  10.0)) * __slopebot));
                end
              end
              ijunbot_s = ((((id + isrh) + itat) + ibbt) * fbreakdown);
            end
            if ((__LSSOURCE_i ==  0.0)) begin
              ijunsti_s =  0.0;
              qjunsti_s =  0.0;
            end
            else begin
              if ((__one_minus_PSTI ==  0.5)) begin
                tmp = sqrt(( 1.0 - (vj * __vbiinvsti)));
              end
              else begin
                tmp = pow(( 1.0 - (vj * __vbiinvsti)), __one_minus_PSTI);
              end
              qjunsti_s = ((__qprefsti * ( 1.0 - tmp)) + (__qpref2sti * (__Vjun_s - vj)));
              id = (__idsatsti * idmult);
              if (0) begin
              end
              else begin
                vbi_minus_vjsrh = (__vbisti - vjsrh);
                wsrhstep = ( 1.0 - sqrt(( 1.0 - (two_psistar / vbi_minus_vjsrh))));
                if (0) begin
                end
                else begin
                  dwsrh = (((((wsrhstep * wsrhstep) * ln(wsrhstep)) / ( 1.0 - wsrhstep)) + wsrhstep) *  0.45276);
                end
                wsrh = (wsrhstep + dwsrh);
                if (0) begin
                end
                else begin
                  tmp = pow((vbi_minus_vjsrh * __VBIRSTIinv),  0.27362);
                end
                wdep = (__wdepnulrsti * tmp);
                asrh = (__ftdsti * ((zinv -  1.0) * wdep));
                isrh = ((asrh * wsrh) *  100.0e-6);
              end
              if (0) begin
              end
              else begin
                btat = (__btatpartsti * ((wdep * __one_minus_PSTI) / vbi_minus_vjsrh));
                twoatatoverthreebtat = ((__atatsti *  0.666666666666667) / btat);
                umaxbeforelimiting = (twoatatoverthreebtat * twoatatoverthreebtat);
                umax = sqrt(((umaxbeforelimiting * umaxbeforelimiting) / ((umaxbeforelimiting * umaxbeforelimiting) +  1.0)));
                sqrtumax = sqrt(umax);
                umaxpoweronepointfive = (umax * sqrtumax);
                if (((__one_over_one_minus_PSTI * -0.27362) == -1.0)) begin
                  wgamma = ( 1.0 / ((btat * umaxpoweronepointfive) +  1.0));
                end
                else begin
                  wgamma = pow(((btat * umaxpoweronepointfive) +  1.0), (__one_over_one_minus_PSTI * -0.27362));
                end
                wtat = ((wsrh * wgamma) / (wsrh + wgamma));
                ktat = sqrt(((btat / sqrtumax) *  0.375));
                ltat = (((twoatatoverthreebtat * sqrtumax) *  2.0) - umax);
                mtat = ((((__atatsti * twoatatoverthreebtat) * sqrtumax) - (__atatsti * umax)) + ((btat * umaxpoweronepointfive) *  0.5));
                xerfc = ((ltat -  1.0) * ktat);
                ysq = (xerfc * xerfc);
                if ((xerfc >  0.0)) begin
                  terfc = ( 1.0 / ((__perfc * xerfc) +  1.0));
                end
                else begin
                  terfc = ( 1.0 / ( 1.0 - (__perfc * xerfc)));
                end
                if ((((- ysq) + mtat) > -230.258509299405)) begin
                  tmp = exp(((- ysq) + mtat));
                end
                else begin
                  tmp = ( 100.0e-102 / (((-230.258509299405 - ((- ysq) + mtat)) * ((((-230.258509299405 - ((- ysq) + mtat)) * (((-230.258509299405 - ((- ysq) + mtat)) *  0.333333333333333) +  1.0)) *  0.5) +  1.0)) +  1.0));
                end
                erfcpos = ((((terfc *  0.29214664) + (__berfc * (terfc * terfc))) + (__cerfc * ((terfc * terfc) * terfc))) * tmp);
                if ((xerfc >  0.0)) begin
                  erfctimesexpmtat = erfcpos;
                end
                else begin
                  if ((mtat > -230.258509299405)) begin
                    tmp = exp(mtat);
                  end
                  else begin
                    tmp = ( 100.0e-102 / (((-230.258509299405 - mtat) * ((((-230.258509299405 - mtat) * (((-230.258509299405 - mtat) *  0.333333333333333) +  1.0)) *  0.5) +  1.0)) +  1.0));
                  end
                  erfctimesexpmtat = ((tmp *  2.0) - erfcpos);
                end
                gammamax = (((__atatsti * erfctimesexpmtat) / ktat) *  0.886226925452758);
                itat = (((asrh * gammamax) * wtat) *  100.0e-6);
              end
              if (0) begin
              end
              else begin
                if (0) begin
                end
                else begin
                  tmp = pow((( 0.79368 - vbbt) * __VBIRSTIinv),  0.27362);
                end
                Fmaxr = (__one_over_one_minus_PSTI * ((( 0.79368 - vbbt) * __wdepnulrinvsti) / tmp));
                if ((abs(((- __fbbtsti) / Fmaxr)) <  230.258509299405)) begin
                  tmp = exp(((- __fbbtsti) / Fmaxr));
                end
                else begin
                  if ((((- __fbbtsti) / Fmaxr) <  0.0)) begin
                    tmp = ( 100.0e-102 / (((-230.258509299405 - ((- __fbbtsti) / Fmaxr)) * ((((-230.258509299405 - ((- __fbbtsti) / Fmaxr)) * (((-230.258509299405 - ((- __fbbtsti) / Fmaxr)) *  0.333333333333333) +  1.0)) *  0.5) +  1.0)) +  1.0));
                  end
                  else begin
                    tmp = ((((((- __fbbtsti) / Fmaxr) -  230.258509299405) * ((((((- __fbbtsti) / Fmaxr) -  230.258509299405) * (((((- __fbbtsti) / Fmaxr) -  230.258509299405) *  0.333333333333333) +  1.0)) *  0.5) +  1.0)) +  1.0) *  10.0e+99);
                  end
                end
                ibbt = ((((__Vjun_s * Fmaxr) * Fmaxr) * tmp) *  1.0e-21);
              end
              if (0) begin
              end
              else begin
                if ((vav > ((- __alphaav) *  10.0))) begin
                  if (1) begin
                    tmp = ((((vav * __VBRinvsti) * (vav * __VBRinvsti)) * (vav * __VBRinvsti)) * (vav * __VBRinvsti));
                  end
                  else begin
                  end
                  fbreakdown = ( 1.0 / ( 1.0 - tmp));
                end
                else begin
                  fbreakdown = (__fstopsti + ((vav + (__alphaav *  10.0)) * __slopesti));
                end
              end
              ijunsti_s = ((((id + isrh) + itat) + ibbt) * fbreakdown);
            end
            if ((__LGSOURCE_i ==  0.0)) begin
              ijungat_s =  0.0;
              qjungat_s =  0.0;
            end
            else begin
              if ((__one_minus_PGAT ==  0.5)) begin
                tmp = sqrt(( 1.0 - (vj * __vbiinvgat)));
              end
              else begin
                tmp = pow(( 1.0 - (vj * __vbiinvgat)), __one_minus_PGAT);
              end
              qjungat_s = ((__qprefgat * ( 1.0 - tmp)) + (__qpref2gat * (__Vjun_s - vj)));
              id = (__idsatgat * idmult);
              if (0) begin
              end
              else begin
                vbi_minus_vjsrh = (__vbigat - vjsrh);
                wsrhstep = ( 1.0 - sqrt(( 1.0 - (two_psistar / vbi_minus_vjsrh))));
                if (0) begin
                end
                else begin
                  dwsrh = (((((wsrhstep * wsrhstep) * ln(wsrhstep)) / ( 1.0 - wsrhstep)) + wsrhstep) * -0.0848);
                end
                wsrh = (wsrhstep + dwsrh);
                if (0) begin
                end
                else begin
                  tmp = pow((vbi_minus_vjsrh * __VBIRGATinv),  0.5424);
                end
                wdep = (__wdepnulrgat * tmp);
                asrh = (__ftdgat * ((zinv -  1.0) * wdep));
                isrh = ((asrh * wsrh) *  6.682e-6);
              end
              if (0) begin
              end
              else begin
                btat = (__btatpartgat * ((wdep * __one_minus_PGAT) / vbi_minus_vjsrh));
                twoatatoverthreebtat = ((__atatgat *  0.666666666666667) / btat);
                umaxbeforelimiting = (twoatatoverthreebtat * twoatatoverthreebtat);
                umax = sqrt(((umaxbeforelimiting * umaxbeforelimiting) / ((umaxbeforelimiting * umaxbeforelimiting) +  1.0)));
                sqrtumax = sqrt(umax);
                umaxpoweronepointfive = (umax * sqrtumax);
                if (((__one_over_one_minus_PGAT * -0.5424) == -1.0)) begin
                  wgamma = ( 1.0 / ((btat * umaxpoweronepointfive) +  1.0));
                end
                else begin
                  wgamma = pow(((btat * umaxpoweronepointfive) +  1.0), (__one_over_one_minus_PGAT * -0.5424));
                end
                wtat = ((wsrh * wgamma) / (wsrh + wgamma));
                ktat = sqrt(((btat / sqrtumax) *  0.375));
                ltat = (((twoatatoverthreebtat * sqrtumax) *  2.0) - umax);
                mtat = ((((__atatgat * twoatatoverthreebtat) * sqrtumax) - (__atatgat * umax)) + ((btat * umaxpoweronepointfive) *  0.5));
                xerfc = ((ltat -  1.0) * ktat);
                ysq = (xerfc * xerfc);
                if ((xerfc >  0.0)) begin
                  terfc = ( 1.0 / ((__perfc * xerfc) +  1.0));
                end
                else begin
                  terfc = ( 1.0 / ( 1.0 - (__perfc * xerfc)));
                end
                if ((((- ysq) + mtat) > -230.258509299405)) begin
                  tmp = exp(((- ysq) + mtat));
                end
                else begin
                  tmp = ( 100.0e-102 / (((-230.258509299405 - ((- ysq) + mtat)) * ((((-230.258509299405 - ((- ysq) + mtat)) * (((-230.258509299405 - ((- ysq) + mtat)) *  0.333333333333333) +  1.0)) *  0.5) +  1.0)) +  1.0));
                end
                erfcpos = ((((terfc *  0.29214664) + (__berfc * (terfc * terfc))) + (__cerfc * ((terfc * terfc) * terfc))) * tmp);
                if ((xerfc >  0.0)) begin
                  erfctimesexpmtat = erfcpos;
                end
                else begin
                  if ((mtat > -230.258509299405)) begin
                    tmp = exp(mtat);
                  end
                  else begin
                    tmp = ( 100.0e-102 / (((-230.258509299405 - mtat) * ((((-230.258509299405 - mtat) * (((-230.258509299405 - mtat) *  0.333333333333333) +  1.0)) *  0.5) +  1.0)) +  1.0));
                  end
                  erfctimesexpmtat = ((tmp *  2.0) - erfcpos);
                end
                gammamax = (((__atatgat * erfctimesexpmtat) / ktat) *  0.886226925452758);
                itat = (((asrh * gammamax) * wtat) *  100.0e-6);
              end
              if (0) begin
              end
              else begin
                if (0) begin
                end
                else begin
                  tmp = pow((( 2.0 - vbbt) * __VBIRGATinv),  0.5424);
                end
                Fmaxr = (__one_over_one_minus_PGAT * ((( 2.0 - vbbt) * __wdepnulrinvgat) / tmp));
                if ((abs(((- __fbbtgat) / Fmaxr)) <  230.258509299405)) begin
                  tmp = exp(((- __fbbtgat) / Fmaxr));
                end
                else begin
                  if ((((- __fbbtgat) / Fmaxr) <  0.0)) begin
                    tmp = ( 100.0e-102 / (((-230.258509299405 - ((- __fbbtgat) / Fmaxr)) * ((((-230.258509299405 - ((- __fbbtgat) / Fmaxr)) * (((-230.258509299405 - ((- __fbbtgat) / Fmaxr)) *  0.333333333333333) +  1.0)) *  0.5) +  1.0)) +  1.0));
                  end
                  else begin
                    tmp = ((((((- __fbbtgat) / Fmaxr) -  230.258509299405) * ((((((- __fbbtgat) / Fmaxr) -  230.258509299405) * (((((- __fbbtgat) / Fmaxr) -  230.258509299405) *  0.333333333333333) +  1.0)) *  0.5) +  1.0)) +  1.0) *  10.0e+99);
                  end
                end
                ibbt = ((((__Vjun_s * Fmaxr) * Fmaxr) * tmp) *  1.0e-18);
              end
              if (0) begin
              end
              else begin
                if ((vav > ((- __alphaav) *  10.0))) begin
                  if (1) begin
                    tmp = ((((vav * __VBRinvgat) * (vav * __VBRinvgat)) * (vav * __VBRinvgat)) * (vav * __VBRinvgat));
                  end
                  else begin
                  end
                  fbreakdown = ( 1.0 / ( 1.0 - tmp));
                end
                else begin
                  fbreakdown = (__fstopgat + ((vav + (__alphaav *  10.0)) * __slopegat));
                end
              end
              ijungat_s = ((((id + isrh) + itat) + ibbt) * fbreakdown);
            end
            ijun_s = (((__ABSOURCE_i * ijunbot_s) + (__LSSOURCE_i * ijunsti_s)) + (__LGSOURCE_i * ijungat_s));
            vbbt =  0.0;
            two_psistar =  0.0;
            if ((! (((__ABDRAIN_i ==  0.0) && (__LSDRAIN_i ==  0.0)) && (__LGDRAIN_i ==  0.0)))) begin
              h1 = ((__vch_d *  4.0) * __vch_d);
              h2 = (__vch_d / __vfmin_d);
              h2d = (__Vjun_d + (__vch_d * h2));
              h3 = (__vfmin_d + h2d);
              h4 = (__vfmin_d - h2d);
              h5 = sqrt(((h4 * h4) + h1));
              vj = (((__Vjun_d * __vfmin_d) / (h3 + h5)) *  2.0);
              if ((__Vjun_d < __VMAX_d)) begin
                if ((abs(((__Vjun_d * __phitdinv) *  0.5)) <  230.258509299405)) begin
                  zinv = exp(((__Vjun_d * __phitdinv) *  0.5));
                end
                else begin
                  if ((((__Vjun_d * __phitdinv) *  0.5) <  0.0)) begin
                    zinv = ( 100.0e-102 / (((-230.258509299405 - ((__Vjun_d * __phitdinv) *  0.5)) * ((((-230.258509299405 - ((__Vjun_d * __phitdinv) *  0.5)) * (((-230.258509299405 - ((__Vjun_d * __phitdinv) *  0.5)) *  0.333333333333333) +  1.0)) *  0.5) +  1.0)) +  1.0));
                  end
                  else begin
                    zinv = ((((((__Vjun_d * __phitdinv) *  0.5) -  230.258509299405) * ((((((__Vjun_d * __phitdinv) *  0.5) -  230.258509299405) * (((((__Vjun_d * __phitdinv) *  0.5) -  230.258509299405) *  0.333333333333333) +  1.0)) *  0.5) +  1.0)) +  1.0) *  10.0e+99);
                  end
                end
                idmult = (zinv * zinv);
              end
              else begin
                idmult = ((((__Vjun_d - __VMAX_d) * __phitdinv) +  1.0) * __exp_VMAX_over_phitd_d);
                zinv = sqrt(idmult);
              end
              idmult = (idmult -  1.0);
              z = ( 1.0 / zinv);
              if ((__Vjun_d >  0.0)) begin
                two_psistar = ((__phitd * ln(((z +  2.0) + sqrt(((z +  1.0) * (z +  3.0)))))) *  2.0);
              end
              else begin
                two_psistar = ((- __Vjun_d) + ((__phitd * ln((((zinv *  2.0) +  1.0) + sqrt(((zinv +  1.0) * ((zinv *  3.0) +  1.0)))))) *  2.0));
              end
              vjlim = (__vbimin_d - two_psistar);
              vjsrh = (((__Vjun_d + vjlim) - sqrt((((__Vjun_d - vjlim) * (__Vjun_d - vjlim)) + ((__phitd *  4.0) * __phitd)))) *  0.5);
              vbbt = (((__Vjun_d + __vbbtlim_d) - sqrt((((__Vjun_d - __vbbtlim_d) * (__Vjun_d - __vbbtlim_d)) + ((__phitr *  4.0) * __phitr)))) *  0.5);
              vav = ((__Vjun_d - sqrt(((__Vjun_d * __Vjun_d) +  4.0e-12))) *  0.5);
            end
            if ((__ABDRAIN_i ==  0.0)) begin
              ijunbot_d =  0.0;
              qjunbot_d =  0.0;
            end
            else begin
              if ((__one_minus_PBOT_d ==  0.5)) begin
                tmp = sqrt(( 1.0 - (vj * __vbiinvbot_d)));
              end
              else begin
                tmp = pow(( 1.0 - (vj * __vbiinvbot_d)), __one_minus_PBOT_d);
              end
              qjunbot_d = ((__qprefbot_d * ( 1.0 - tmp)) + (__qpref2bot_d * (__Vjun_d - vj)));
              id = (__idsatbot_d * idmult);
              if (((__CSRHBOTD_i ==  0.0) && (__CTATBOTD_i ==  0.0))) begin
                isrh =  0.0;
              end
              else begin
                vbi_minus_vjsrh = (__vbibot_d - vjsrh);
                wsrhstep = ( 1.0 - sqrt(( 1.0 - (two_psistar / vbi_minus_vjsrh))));
                if ((__PBOTD_i ==  0.5)) begin
                  dwsrh =  0.0;
                end
                else begin
                  dwsrh = (((((wsrhstep * wsrhstep) * ln(wsrhstep)) / ( 1.0 - wsrhstep)) + wsrhstep) * ( 1.0 - (__PBOTD_i *  2.0)));
                end
                wsrh = (wsrhstep + dwsrh);
                if ((__PBOTD_i ==  0.5)) begin
                  tmp = sqrt((vbi_minus_vjsrh * __VBIRBOTinv_d));
                end
                else begin
                  tmp = pow((vbi_minus_vjsrh * __VBIRBOTinv_d), __PBOTD_i);
                end
                wdep = (__wdepnulrbot_d * tmp);
                asrh = (__ftdbot_d * ((zinv -  1.0) * wdep));
                isrh = (__CSRHBOTD_i * (asrh * wsrh));
              end
              if ((__CTATBOTD_i ==  0.0)) begin
                itat =  0.0;
              end
              else begin
                btat = (__btatpartbot_d * ((wdep * __one_minus_PBOT_d) / vbi_minus_vjsrh));
                twoatatoverthreebtat = ((__atatbot_d *  0.666666666666667) / btat);
                umaxbeforelimiting = (twoatatoverthreebtat * twoatatoverthreebtat);
                umax = sqrt(((umaxbeforelimiting * umaxbeforelimiting) / ((umaxbeforelimiting * umaxbeforelimiting) +  1.0)));
                sqrtumax = sqrt(umax);
                umaxpoweronepointfive = (umax * sqrtumax);
                if ((((- __PBOTD_i) * __one_over_one_minus_PBOT_d) == -1.0)) begin
                  wgamma = ( 1.0 / ((btat * umaxpoweronepointfive) +  1.0));
                end
                else begin
                  wgamma = pow(((btat * umaxpoweronepointfive) +  1.0), ((- __PBOTD_i) * __one_over_one_minus_PBOT_d));
                end
                wtat = ((wsrh * wgamma) / (wsrh + wgamma));
                ktat = sqrt(((btat / sqrtumax) *  0.375));
                ltat = (((twoatatoverthreebtat * sqrtumax) *  2.0) - umax);
                mtat = ((((__atatbot_d * twoatatoverthreebtat) * sqrtumax) - (__atatbot_d * umax)) + ((btat * umaxpoweronepointfive) *  0.5));
                xerfc = ((ltat -  1.0) * ktat);
                ysq = (xerfc * xerfc);
                if ((xerfc >  0.0)) begin
                  terfc = ( 1.0 / ((__perfc * xerfc) +  1.0));
                end
                else begin
                  terfc = ( 1.0 / ( 1.0 - (__perfc * xerfc)));
                end
                if ((((- ysq) + mtat) > -230.258509299405)) begin
                  tmp = exp(((- ysq) + mtat));
                end
                else begin
                  tmp = ( 100.0e-102 / (((-230.258509299405 - ((- ysq) + mtat)) * ((((-230.258509299405 - ((- ysq) + mtat)) * (((-230.258509299405 - ((- ysq) + mtat)) *  0.333333333333333) +  1.0)) *  0.5) +  1.0)) +  1.0));
                end
                erfcpos = ((((terfc *  0.29214664) + (__berfc * (terfc * terfc))) + (__cerfc * ((terfc * terfc) * terfc))) * tmp);
                if ((xerfc >  0.0)) begin
                  erfctimesexpmtat = erfcpos;
                end
                else begin
                  if ((mtat > -230.258509299405)) begin
                    tmp = exp(mtat);
                  end
                  else begin
                    tmp = ( 100.0e-102 / (((-230.258509299405 - mtat) * ((((-230.258509299405 - mtat) * (((-230.258509299405 - mtat) *  0.333333333333333) +  1.0)) *  0.5) +  1.0)) +  1.0));
                  end
                  erfctimesexpmtat = ((tmp *  2.0) - erfcpos);
                end
                gammamax = (((__atatbot_d * erfctimesexpmtat) / ktat) *  0.886226925452758);
                itat = (__CTATBOTD_i * ((asrh * gammamax) * wtat));
              end
              if ((__CBBTBOTD_i ==  0.0)) begin
                ibbt =  0.0;
              end
              else begin
                if ((__PBOTD_i ==  0.5)) begin
                  tmp = sqrt(((__VBIRBOTD_i - vbbt) * __VBIRBOTinv_d));
                end
                else begin
                  tmp = pow(((__VBIRBOTD_i - vbbt) * __VBIRBOTinv_d), __PBOTD_i);
                end
                Fmaxr = (__one_over_one_minus_PBOT_d * (((__VBIRBOTD_i - vbbt) * __wdepnulrinvbot_d) / tmp));
                if ((abs(((- __fbbtbot_d) / Fmaxr)) <  230.258509299405)) begin
                  tmp = exp(((- __fbbtbot_d) / Fmaxr));
                end
                else begin
                  if ((((- __fbbtbot_d) / Fmaxr) <  0.0)) begin
                    tmp = ( 100.0e-102 / (((-230.258509299405 - ((- __fbbtbot_d) / Fmaxr)) * ((((-230.258509299405 - ((- __fbbtbot_d) / Fmaxr)) * (((-230.258509299405 - ((- __fbbtbot_d) / Fmaxr)) *  0.333333333333333) +  1.0)) *  0.5) +  1.0)) +  1.0));
                  end
                  else begin
                    tmp = ((((((- __fbbtbot_d) / Fmaxr) -  230.258509299405) * ((((((- __fbbtbot_d) / Fmaxr) -  230.258509299405) * (((((- __fbbtbot_d) / Fmaxr) -  230.258509299405) *  0.333333333333333) +  1.0)) *  0.5) +  1.0)) +  1.0) *  10.0e+99);
                  end
                end
                ibbt = (__CBBTBOTD_i * (((__Vjun_d * Fmaxr) * Fmaxr) * tmp));
              end
              if ((__VBRBOTD_i >  1.0e+3)) begin
                fbreakdown =  1.0;
              end
              else begin
                if ((vav > ((- __alphaav) * __VBRBOTD_i))) begin
                  if ((__PBRBOTD_i ==  4.0)) begin
                    tmp = ((((vav * __VBRinvbot_d) * (vav * __VBRinvbot_d)) * (vav * __VBRinvbot_d)) * (vav * __VBRinvbot_d));
                  end
                  else begin
                    tmp = pow(abs((vav * __VBRinvbot_d)), __PBRBOTD_i);
                  end
                  fbreakdown = ( 1.0 / ( 1.0 - tmp));
                end
                else begin
                  fbreakdown = (__fstopbot_d + ((vav + (__alphaav * __VBRBOTD_i)) * __slopebot_d));
                end
              end
              ijunbot_d = ((((id + isrh) + itat) + ibbt) * fbreakdown);
            end
            if ((__LSDRAIN_i ==  0.0)) begin
              ijunsti_d =  0.0;
              qjunsti_d =  0.0;
            end
            else begin
              if ((__one_minus_PSTI_d ==  0.5)) begin
                tmp = sqrt(( 1.0 - (vj * __vbiinvsti_d)));
              end
              else begin
                tmp = pow(( 1.0 - (vj * __vbiinvsti_d)), __one_minus_PSTI_d);
              end
              qjunsti_d = ((__qprefsti_d * ( 1.0 - tmp)) + (__qpref2sti_d * (__Vjun_d - vj)));
              id = (__idsatsti_d * idmult);
              if (((__CSRHSTID_i ==  0.0) && (__CTATSTID_i ==  0.0))) begin
                isrh =  0.0;
              end
              else begin
                vbi_minus_vjsrh = (__vbisti_d - vjsrh);
                wsrhstep = ( 1.0 - sqrt(( 1.0 - (two_psistar / vbi_minus_vjsrh))));
                if ((__PSTID_i ==  0.5)) begin
                  dwsrh =  0.0;
                end
                else begin
                  dwsrh = (((((wsrhstep * wsrhstep) * ln(wsrhstep)) / ( 1.0 - wsrhstep)) + wsrhstep) * ( 1.0 - (__PSTID_i *  2.0)));
                end
                wsrh = (wsrhstep + dwsrh);
                if ((__PSTID_i ==  0.5)) begin
                  tmp = sqrt((vbi_minus_vjsrh * __VBIRSTIinv_d));
                end
                else begin
                  tmp = pow((vbi_minus_vjsrh * __VBIRSTIinv_d), __PSTID_i);
                end
                wdep = (__wdepnulrsti_d * tmp);
                asrh = (__ftdsti_d * ((zinv -  1.0) * wdep));
                isrh = (__CSRHSTID_i * (asrh * wsrh));
              end
              if ((__CTATSTID_i ==  0.0)) begin
                itat =  0.0;
              end
              else begin
                btat = (__btatpartsti_d * ((wdep * __one_minus_PSTI_d) / vbi_minus_vjsrh));
                twoatatoverthreebtat = ((__atatsti_d *  0.666666666666667) / btat);
                umaxbeforelimiting = (twoatatoverthreebtat * twoatatoverthreebtat);
                umax = sqrt(((umaxbeforelimiting * umaxbeforelimiting) / ((umaxbeforelimiting * umaxbeforelimiting) +  1.0)));
                sqrtumax = sqrt(umax);
                umaxpoweronepointfive = (umax * sqrtumax);
                if ((((- __PSTID_i) * __one_over_one_minus_PSTI_d) == -1.0)) begin
                  wgamma = ( 1.0 / ((btat * umaxpoweronepointfive) +  1.0));
                end
                else begin
                  wgamma = pow(((btat * umaxpoweronepointfive) +  1.0), ((- __PSTID_i) * __one_over_one_minus_PSTI_d));
                end
                wtat = ((wsrh * wgamma) / (wsrh + wgamma));
                ktat = sqrt(((btat / sqrtumax) *  0.375));
                ltat = (((twoatatoverthreebtat * sqrtumax) *  2.0) - umax);
                mtat = ((((__atatsti_d * twoatatoverthreebtat) * sqrtumax) - (__atatsti_d * umax)) + ((btat * umaxpoweronepointfive) *  0.5));
                xerfc = ((ltat -  1.0) * ktat);
                ysq = (xerfc * xerfc);
                if ((xerfc >  0.0)) begin
                  terfc = ( 1.0 / ((__perfc * xerfc) +  1.0));
                end
                else begin
                  terfc = ( 1.0 / ( 1.0 - (__perfc * xerfc)));
                end
                if ((((- ysq) + mtat) > -230.258509299405)) begin
                  tmp = exp(((- ysq) + mtat));
                end
                else begin
                  tmp = ( 100.0e-102 / (((-230.258509299405 - ((- ysq) + mtat)) * ((((-230.258509299405 - ((- ysq) + mtat)) * (((-230.258509299405 - ((- ysq) + mtat)) *  0.333333333333333) +  1.0)) *  0.5) +  1.0)) +  1.0));
                end
                erfcpos = ((((terfc *  0.29214664) + (__berfc * (terfc * terfc))) + (__cerfc * ((terfc * terfc) * terfc))) * tmp);
                if ((xerfc >  0.0)) begin
                  erfctimesexpmtat = erfcpos;
                end
                else begin
                  if ((mtat > -230.258509299405)) begin
                    tmp = exp(mtat);
                  end
                  else begin
                    tmp = ( 100.0e-102 / (((-230.258509299405 - mtat) * ((((-230.258509299405 - mtat) * (((-230.258509299405 - mtat) *  0.333333333333333) +  1.0)) *  0.5) +  1.0)) +  1.0));
                  end
                  erfctimesexpmtat = ((tmp *  2.0) - erfcpos);
                end
                gammamax = (((__atatsti_d * erfctimesexpmtat) / ktat) *  0.886226925452758);
                itat = (__CTATSTID_i * ((asrh * gammamax) * wtat));
              end
              if ((__CBBTSTID_i ==  0.0)) begin
                ibbt =  0.0;
              end
              else begin
                if ((__PSTID_i ==  0.5)) begin
                  tmp = sqrt(((__VBIRSTID_i - vbbt) * __VBIRSTIinv_d));
                end
                else begin
                  tmp = pow(((__VBIRSTID_i - vbbt) * __VBIRSTIinv_d), __PSTID_i);
                end
                Fmaxr = (__one_over_one_minus_PSTI_d * (((__VBIRSTID_i - vbbt) * __wdepnulrinvsti_d) / tmp));
                if ((abs(((- __fbbtsti_d) / Fmaxr)) <  230.258509299405)) begin
                  tmp = exp(((- __fbbtsti_d) / Fmaxr));
                end
                else begin
                  if ((((- __fbbtsti_d) / Fmaxr) <  0.0)) begin
                    tmp = ( 100.0e-102 / (((-230.258509299405 - ((- __fbbtsti_d) / Fmaxr)) * ((((-230.258509299405 - ((- __fbbtsti_d) / Fmaxr)) * (((-230.258509299405 - ((- __fbbtsti_d) / Fmaxr)) *  0.333333333333333) +  1.0)) *  0.5) +  1.0)) +  1.0));
                  end
                  else begin
                    tmp = ((((((- __fbbtsti_d) / Fmaxr) -  230.258509299405) * ((((((- __fbbtsti_d) / Fmaxr) -  230.258509299405) * (((((- __fbbtsti_d) / Fmaxr) -  230.258509299405) *  0.333333333333333) +  1.0)) *  0.5) +  1.0)) +  1.0) *  10.0e+99);
                  end
                end
                ibbt = (__CBBTSTID_i * (((__Vjun_d * Fmaxr) * Fmaxr) * tmp));
              end
              if ((__VBRSTID_i >  1.0e+3)) begin
                fbreakdown =  1.0;
              end
              else begin
                if ((vav > ((- __alphaav) * __VBRSTID_i))) begin
                  if ((__PBRSTID_i ==  4.0)) begin
                    tmp = ((((vav * __VBRinvsti_d) * (vav * __VBRinvsti_d)) * (vav * __VBRinvsti_d)) * (vav * __VBRinvsti_d));
                  end
                  else begin
                    tmp = pow(abs((vav * __VBRinvsti_d)), __PBRSTID_i);
                  end
                  fbreakdown = ( 1.0 / ( 1.0 - tmp));
                end
                else begin
                  fbreakdown = (__fstopsti_d + ((vav + (__alphaav * __VBRSTID_i)) * __slopesti_d));
                end
              end
              ijunsti_d = ((((id + isrh) + itat) + ibbt) * fbreakdown);
            end
            if ((__LGDRAIN_i ==  0.0)) begin
              ijungat_d =  0.0;
              qjungat_d =  0.0;
            end
            else begin
              if ((__one_minus_PGAT_d ==  0.5)) begin
                tmp = sqrt(( 1.0 - (vj * __vbiinvgat_d)));
              end
              else begin
                tmp = pow(( 1.0 - (vj * __vbiinvgat_d)), __one_minus_PGAT_d);
              end
              qjungat_d = ((__qprefgat_d * ( 1.0 - tmp)) + (__qpref2gat_d * (__Vjun_d - vj)));
              id = (__idsatgat_d * idmult);
              if (((__CSRHGATD_i ==  0.0) && (__CTATGATD_i ==  0.0))) begin
                isrh =  0.0;
              end
              else begin
                vbi_minus_vjsrh = (__vbigat_d - vjsrh);
                wsrhstep = ( 1.0 - sqrt(( 1.0 - (two_psistar / vbi_minus_vjsrh))));
                if ((__PGATD_i ==  0.5)) begin
                  dwsrh =  0.0;
                end
                else begin
                  dwsrh = (((((wsrhstep * wsrhstep) * ln(wsrhstep)) / ( 1.0 - wsrhstep)) + wsrhstep) * ( 1.0 - (__PGATD_i *  2.0)));
                end
                wsrh = (wsrhstep + dwsrh);
                if ((__PGATD_i ==  0.5)) begin
                  tmp = sqrt((vbi_minus_vjsrh * __VBIRGATinv_d));
                end
                else begin
                  tmp = pow((vbi_minus_vjsrh * __VBIRGATinv_d), __PGATD_i);
                end
                wdep = (__wdepnulrgat_d * tmp);
                asrh = (__ftdgat_d * ((zinv -  1.0) * wdep));
                isrh = (__CSRHGATD_i * (asrh * wsrh));
              end
              if ((__CTATGATD_i ==  0.0)) begin
                itat =  0.0;
              end
              else begin
                btat = (__btatpartgat_d * ((wdep * __one_minus_PGAT_d) / vbi_minus_vjsrh));
                twoatatoverthreebtat = ((__atatgat_d *  0.666666666666667) / btat);
                umaxbeforelimiting = (twoatatoverthreebtat * twoatatoverthreebtat);
                umax = sqrt(((umaxbeforelimiting * umaxbeforelimiting) / ((umaxbeforelimiting * umaxbeforelimiting) +  1.0)));
                sqrtumax = sqrt(umax);
                umaxpoweronepointfive = (umax * sqrtumax);
                if ((((- __PGATD_i) * __one_over_one_minus_PGAT_d) == -1.0)) begin
                  wgamma = ( 1.0 / ((btat * umaxpoweronepointfive) +  1.0));
                end
                else begin
                  wgamma = pow(((btat * umaxpoweronepointfive) +  1.0), ((- __PGATD_i) * __one_over_one_minus_PGAT_d));
                end
                wtat = ((wsrh * wgamma) / (wsrh + wgamma));
                ktat = sqrt(((btat / sqrtumax) *  0.375));
                ltat = (((twoatatoverthreebtat * sqrtumax) *  2.0) - umax);
                mtat = ((((__atatgat_d * twoatatoverthreebtat) * sqrtumax) - (__atatgat_d * umax)) + ((btat * umaxpoweronepointfive) *  0.5));
                xerfc = ((ltat -  1.0) * ktat);
                ysq = (xerfc * xerfc);
                if ((xerfc >  0.0)) begin
                  terfc = ( 1.0 / ((__perfc * xerfc) +  1.0));
                end
                else begin
                  terfc = ( 1.0 / ( 1.0 - (__perfc * xerfc)));
                end
                if ((((- ysq) + mtat) > -230.258509299405)) begin
                  tmp = exp(((- ysq) + mtat));
                end
                else begin
                  tmp = ( 100.0e-102 / (((-230.258509299405 - ((- ysq) + mtat)) * ((((-230.258509299405 - ((- ysq) + mtat)) * (((-230.258509299405 - ((- ysq) + mtat)) *  0.333333333333333) +  1.0)) *  0.5) +  1.0)) +  1.0));
                end
                erfcpos = ((((terfc *  0.29214664) + (__berfc * (terfc * terfc))) + (__cerfc * ((terfc * terfc) * terfc))) * tmp);
                if ((xerfc >  0.0)) begin
                  erfctimesexpmtat = erfcpos;
                end
                else begin
                  if ((mtat > -230.258509299405)) begin
                    tmp = exp(mtat);
                  end
                  else begin
                    tmp = ( 100.0e-102 / (((-230.258509299405 - mtat) * ((((-230.258509299405 - mtat) * (((-230.258509299405 - mtat) *  0.333333333333333) +  1.0)) *  0.5) +  1.0)) +  1.0));
                  end
                  erfctimesexpmtat = ((tmp *  2.0) - erfcpos);
                end
                gammamax = (((__atatgat_d * erfctimesexpmtat) / ktat) *  0.886226925452758);
                itat = (__CTATGATD_i * ((asrh * gammamax) * wtat));
              end
              if ((__CBBTGATD_i ==  0.0)) begin
                ibbt =  0.0;
              end
              else begin
                if ((__PGATD_i ==  0.5)) begin
                  tmp = sqrt(((__VBIRGATD_i - vbbt) * __VBIRGATinv_d));
                end
                else begin
                  tmp = pow(((__VBIRGATD_i - vbbt) * __VBIRGATinv_d), __PGATD_i);
                end
                Fmaxr = (__one_over_one_minus_PGAT_d * (((__VBIRGATD_i - vbbt) * __wdepnulrinvgat_d) / tmp));
                if ((abs(((- __fbbtgat_d) / Fmaxr)) <  230.258509299405)) begin
                  tmp = exp(((- __fbbtgat_d) / Fmaxr));
                end
                else begin
                  if ((((- __fbbtgat_d) / Fmaxr) <  0.0)) begin
                    tmp = ( 100.0e-102 / (((-230.258509299405 - ((- __fbbtgat_d) / Fmaxr)) * ((((-230.258509299405 - ((- __fbbtgat_d) / Fmaxr)) * (((-230.258509299405 - ((- __fbbtgat_d) / Fmaxr)) *  0.333333333333333) +  1.0)) *  0.5) +  1.0)) +  1.0));
                  end
                  else begin
                    tmp = ((((((- __fbbtgat_d) / Fmaxr) -  230.258509299405) * ((((((- __fbbtgat_d) / Fmaxr) -  230.258509299405) * (((((- __fbbtgat_d) / Fmaxr) -  230.258509299405) *  0.333333333333333) +  1.0)) *  0.5) +  1.0)) +  1.0) *  10.0e+99);
                  end
                end
                ibbt = (__CBBTGATD_i * (((__Vjun_d * Fmaxr) * Fmaxr) * tmp));
              end
              if ((__VBRGATD_i >  1.0e+3)) begin
                fbreakdown =  1.0;
              end
              else begin
                if ((vav > ((- __alphaav) * __VBRGATD_i))) begin
                  if ((__PBRGATD_i ==  4.0)) begin
                    tmp = ((((vav * __VBRinvgat_d) * (vav * __VBRinvgat_d)) * (vav * __VBRinvgat_d)) * (vav * __VBRinvgat_d));
                  end
                  else begin
                    tmp = pow(abs((vav * __VBRinvgat_d)), __PBRGATD_i);
                  end
                  fbreakdown = ( 1.0 / ( 1.0 - tmp));
                end
                else begin
                  fbreakdown = (__fstopgat_d + ((vav + (__alphaav * __VBRGATD_i)) * __slopegat_d));
                end
              end
              ijungat_d = ((((id + isrh) + itat) + ibbt) * fbreakdown);
            end
            ijun_d = (((__ABDRAIN_i * ijunbot_d) + (__LSDRAIN_i * ijunsti_d)) + (__LGDRAIN_i * ijungat_d));
          end
        end
        __Qp1_0 =  0.0;
        __Qp2_0 =  0.0;
        __Qp3_0 =  0.0;
        __Qp4_0 =  0.0;
        __Qp5_0 =  0.0;
        __Qp6_0 =  0.0;
        __Qp7_0 =  0.0;
        __Qp8_0 =  0.0;
        __Qp9_0 =  0.0;
        __fk1 =  0.0;
        __fk2 =  0.0;
        __fk3 =  0.0;
        __fk4 =  0.0;
        __fk5 =  0.0;
        __fk6 =  0.0;
        __fk7 =  0.0;
        __fk8 =  0.0;
        __fk9 =  0.0;
        if ((__SWNQS_i != 0)) begin
          __dQis =  0.0;
          __dQy =  0.0;
          __dfQi =  0.0;
          __fQi =  0.0;
          __d2Qy =  0.0;
          __Qp1 =  0.0;
          __Qp2 =  0.0;
          __Qp3 =  0.0;
          __Qp4 =  0.0;
          __Qp5 =  0.0;
          __Qp6 =  0.0;
          __Qp7 =  0.0;
          __Qp8 =  0.0;
          __Qp9 =  0.0;
          __phi_p1 =  0.0;
          __phi_p2 =  0.0;
          __phi_p3 =  0.0;
          __phi_p4 =  0.0;
          __phi_p5 =  0.0;
          __phi_p6 =  0.0;
          __phi_p7 =  0.0;
          __phi_p8 =  0.0;
          __phi_p9 =  0.0;
          if ((__xg_ac >  0.0)) begin
            if ((__SWNQS_i == 1)) begin
              __phi_p1 = (__x_m_ac + ((__H_ac * ( 1.0 - sqrt(( 1.0 - (((__dps_ac *  2.0) / __H_ac) * ( 0.5 - __ym)))))) * inv_phit1));
              if ((abs(__phi_p1) <= __margin_ac)) begin
                __Qb_tmp = (((__phi_p1 * -0.70710678) * __Gf_ac) * ( 1.0 - ((__phi_p1 *  0.166666666666667) * ( 1.0 - (__phi_p1 *  0.166666666666667)))));
              end
              else begin
                if ((abs((- __phi_p1)) <  230.258509299405)) begin
                  temp = exp((- __phi_p1));
                end
                else begin
                  if (((- __phi_p1) <  0.0)) begin
                    temp = ( 100.0e-102 / (((-230.258509299405 - (- __phi_p1)) * ((((-230.258509299405 - (- __phi_p1)) * (((-230.258509299405 - (- __phi_p1)) *  0.333333333333333) +  1.0)) *  0.5) +  1.0)) +  1.0));
                  end
                  else begin
                    temp = (((((- __phi_p1) -  230.258509299405) * (((((- __phi_p1) -  230.258509299405) * ((((- __phi_p1) -  230.258509299405) *  0.333333333333333) +  1.0)) *  0.5) +  1.0)) +  1.0) *  10.0e+99);
                  end
                end
                __Qb_tmp = (__Gf_ac * sqrt(((temp + __phi_p1) -  1.0)));
                if ((__phi_p1 > __margin_ac)) begin
                  __Qb_tmp = (- __Qb_tmp);
                end
              end
              __Qp1_0 = (((- __pd) * (__xg_ac - __phi_p1)) - __Qb_tmp);
            end
            else begin
              if ((__SWNQS_i == 2)) begin
                __phi_p1 = (__x_m_ac + ((__H_ac * ( 1.0 - sqrt(( 1.0 - (((__dps_ac *  2.0) / __H_ac) * ( 0.333333333333333 - __ym)))))) * inv_phit1));
                if ((abs(__phi_p1) <= __margin_ac)) begin
                  __Qb_tmp = (((__phi_p1 * -0.70710678) * __Gf_ac) * ( 1.0 - ((__phi_p1 *  0.166666666666667) * ( 1.0 - (__phi_p1 *  0.166666666666667)))));
                end
                else begin
                  if ((abs((- __phi_p1)) <  230.258509299405)) begin
                    temp = exp((- __phi_p1));
                  end
                  else begin
                    if (((- __phi_p1) <  0.0)) begin
                      temp = ( 100.0e-102 / (((-230.258509299405 - (- __phi_p1)) * ((((-230.258509299405 - (- __phi_p1)) * (((-230.258509299405 - (- __phi_p1)) *  0.333333333333333) +  1.0)) *  0.5) +  1.0)) +  1.0));
                    end
                    else begin
                      temp = (((((- __phi_p1) -  230.258509299405) * (((((- __phi_p1) -  230.258509299405) * ((((- __phi_p1) -  230.258509299405) *  0.333333333333333) +  1.0)) *  0.5) +  1.0)) +  1.0) *  10.0e+99);
                    end
                  end
                  __Qb_tmp = (__Gf_ac * sqrt(((temp + __phi_p1) -  1.0)));
                  if ((__phi_p1 > __margin_ac)) begin
                    __Qb_tmp = (- __Qb_tmp);
                  end
                end
                __Qp1_0 = (((- __pd) * (__xg_ac - __phi_p1)) - __Qb_tmp);
                __phi_p2 = (__x_m_ac + ((__H_ac * ( 1.0 - sqrt(( 1.0 - (((__dps_ac *  2.0) / __H_ac) * ( 0.666666666666667 - __ym)))))) * inv_phit1));
                if ((abs(__phi_p2) <= __margin_ac)) begin
                  __Qb_tmp = (((__phi_p2 * -0.70710678) * __Gf_ac) * ( 1.0 - ((__phi_p2 *  0.166666666666667) * ( 1.0 - (__phi_p2 *  0.166666666666667)))));
                end
                else begin
                  if ((abs((- __phi_p2)) <  230.258509299405)) begin
                    temp = exp((- __phi_p2));
                  end
                  else begin
                    if (((- __phi_p2) <  0.0)) begin
                      temp = ( 100.0e-102 / (((-230.258509299405 - (- __phi_p2)) * ((((-230.258509299405 - (- __phi_p2)) * (((-230.258509299405 - (- __phi_p2)) *  0.333333333333333) +  1.0)) *  0.5) +  1.0)) +  1.0));
                    end
                    else begin
                      temp = (((((- __phi_p2) -  230.258509299405) * (((((- __phi_p2) -  230.258509299405) * ((((- __phi_p2) -  230.258509299405) *  0.333333333333333) +  1.0)) *  0.5) +  1.0)) +  1.0) *  10.0e+99);
                    end
                  end
                  __Qb_tmp = (__Gf_ac * sqrt(((temp + __phi_p2) -  1.0)));
                  if ((__phi_p2 > __margin_ac)) begin
                    __Qb_tmp = (- __Qb_tmp);
                  end
                end
                __Qp2_0 = (((- __pd) * (__xg_ac - __phi_p2)) - __Qb_tmp);
                if ((sigVds < 0)) begin
                  temp = __Qp1_0;
                  __Qp1_0 = __Qp2_0;
                  __Qp2_0 = temp;
                end
              end
              else begin
                if ((__SWNQS_i == 3)) begin
                  __phi_p1 = (__x_m_ac + ((__H_ac * ( 1.0 - sqrt(( 1.0 - (((__dps_ac *  2.0) / __H_ac) * ( 0.25 - __ym)))))) * inv_phit1));
                  if ((abs(__phi_p1) <= __margin_ac)) begin
                    __Qb_tmp = (((__phi_p1 * -0.70710678) * __Gf_ac) * ( 1.0 - ((__phi_p1 *  0.166666666666667) * ( 1.0 - (__phi_p1 *  0.166666666666667)))));
                  end
                  else begin
                    if ((abs((- __phi_p1)) <  230.258509299405)) begin
                      temp = exp((- __phi_p1));
                    end
                    else begin
                      if (((- __phi_p1) <  0.0)) begin
                        temp = ( 100.0e-102 / (((-230.258509299405 - (- __phi_p1)) * ((((-230.258509299405 - (- __phi_p1)) * (((-230.258509299405 - (- __phi_p1)) *  0.333333333333333) +  1.0)) *  0.5) +  1.0)) +  1.0));
                      end
                      else begin
                        temp = (((((- __phi_p1) -  230.258509299405) * (((((- __phi_p1) -  230.258509299405) * ((((- __phi_p1) -  230.258509299405) *  0.333333333333333) +  1.0)) *  0.5) +  1.0)) +  1.0) *  10.0e+99);
                      end
                    end
                    __Qb_tmp = (__Gf_ac * sqrt(((temp + __phi_p1) -  1.0)));
                    if ((__phi_p1 > __margin_ac)) begin
                      __Qb_tmp = (- __Qb_tmp);
                    end
                  end
                  __Qp1_0 = (((- __pd) * (__xg_ac - __phi_p1)) - __Qb_tmp);
                  __phi_p2 = (__x_m_ac + ((__H_ac * ( 1.0 - sqrt(( 1.0 - (((__dps_ac *  2.0) / __H_ac) * ( 0.5 - __ym)))))) * inv_phit1));
                  if ((abs(__phi_p2) <= __margin_ac)) begin
                    __Qb_tmp = (((__phi_p2 * -0.70710678) * __Gf_ac) * ( 1.0 - ((__phi_p2 *  0.166666666666667) * ( 1.0 - (__phi_p2 *  0.166666666666667)))));
                  end
                  else begin
                    if ((abs((- __phi_p2)) <  230.258509299405)) begin
                      temp = exp((- __phi_p2));
                    end
                    else begin
                      if (((- __phi_p2) <  0.0)) begin
                        temp = ( 100.0e-102 / (((-230.258509299405 - (- __phi_p2)) * ((((-230.258509299405 - (- __phi_p2)) * (((-230.258509299405 - (- __phi_p2)) *  0.333333333333333) +  1.0)) *  0.5) +  1.0)) +  1.0));
                      end
                      else begin
                        temp = (((((- __phi_p2) -  230.258509299405) * (((((- __phi_p2) -  230.258509299405) * ((((- __phi_p2) -  230.258509299405) *  0.333333333333333) +  1.0)) *  0.5) +  1.0)) +  1.0) *  10.0e+99);
                      end
                    end
                    __Qb_tmp = (__Gf_ac * sqrt(((temp + __phi_p2) -  1.0)));
                    if ((__phi_p2 > __margin_ac)) begin
                      __Qb_tmp = (- __Qb_tmp);
                    end
                  end
                  __Qp2_0 = (((- __pd) * (__xg_ac - __phi_p2)) - __Qb_tmp);
                  __phi_p3 = (__x_m_ac + ((__H_ac * ( 1.0 - sqrt(( 1.0 - (((__dps_ac *  2.0) / __H_ac) * ( 0.75 - __ym)))))) * inv_phit1));
                  if ((abs(__phi_p3) <= __margin_ac)) begin
                    __Qb_tmp = (((__phi_p3 * -0.70710678) * __Gf_ac) * ( 1.0 - ((__phi_p3 *  0.166666666666667) * ( 1.0 - (__phi_p3 *  0.166666666666667)))));
                  end
                  else begin
                    if ((abs((- __phi_p3)) <  230.258509299405)) begin
                      temp = exp((- __phi_p3));
                    end
                    else begin
                      if (((- __phi_p3) <  0.0)) begin
                        temp = ( 100.0e-102 / (((-230.258509299405 - (- __phi_p3)) * ((((-230.258509299405 - (- __phi_p3)) * (((-230.258509299405 - (- __phi_p3)) *  0.333333333333333) +  1.0)) *  0.5) +  1.0)) +  1.0));
                      end
                      else begin
                        temp = (((((- __phi_p3) -  230.258509299405) * (((((- __phi_p3) -  230.258509299405) * ((((- __phi_p3) -  230.258509299405) *  0.333333333333333) +  1.0)) *  0.5) +  1.0)) +  1.0) *  10.0e+99);
                      end
                    end
                    __Qb_tmp = (__Gf_ac * sqrt(((temp + __phi_p3) -  1.0)));
                    if ((__phi_p3 > __margin_ac)) begin
                      __Qb_tmp = (- __Qb_tmp);
                    end
                  end
                  __Qp3_0 = (((- __pd) * (__xg_ac - __phi_p3)) - __Qb_tmp);
                  if ((sigVds < 0)) begin
                    temp = __Qp1_0;
                    __Qp1_0 = __Qp3_0;
                    __Qp3_0 = temp;
                  end
                end
                else begin
                  if ((__SWNQS_i == 5)) begin
                    __phi_p1 = (__x_m_ac + ((__H_ac * ( 1.0 - sqrt(( 1.0 - (((__dps_ac *  2.0) / __H_ac) * ( 0.166666666666667 - __ym)))))) * inv_phit1));
                    if ((abs(__phi_p1) <= __margin_ac)) begin
                      __Qb_tmp = (((__phi_p1 * -0.70710678) * __Gf_ac) * ( 1.0 - ((__phi_p1 *  0.166666666666667) * ( 1.0 - (__phi_p1 *  0.166666666666667)))));
                    end
                    else begin
                      if ((abs((- __phi_p1)) <  230.258509299405)) begin
                        temp = exp((- __phi_p1));
                      end
                      else begin
                        if (((- __phi_p1) <  0.0)) begin
                          temp = ( 100.0e-102 / (((-230.258509299405 - (- __phi_p1)) * ((((-230.258509299405 - (- __phi_p1)) * (((-230.258509299405 - (- __phi_p1)) *  0.333333333333333) +  1.0)) *  0.5) +  1.0)) +  1.0));
                        end
                        else begin
                          temp = (((((- __phi_p1) -  230.258509299405) * (((((- __phi_p1) -  230.258509299405) * ((((- __phi_p1) -  230.258509299405) *  0.333333333333333) +  1.0)) *  0.5) +  1.0)) +  1.0) *  10.0e+99);
                        end
                      end
                      __Qb_tmp = (__Gf_ac * sqrt(((temp + __phi_p1) -  1.0)));
                      if ((__phi_p1 > __margin_ac)) begin
                        __Qb_tmp = (- __Qb_tmp);
                      end
                    end
                    __Qp1_0 = (((- __pd) * (__xg_ac - __phi_p1)) - __Qb_tmp);
                    __phi_p2 = (__x_m_ac + ((__H_ac * ( 1.0 - sqrt(( 1.0 - (((__dps_ac *  2.0) / __H_ac) * ( 0.333333333333333 - __ym)))))) * inv_phit1));
                    if ((abs(__phi_p2) <= __margin_ac)) begin
                      __Qb_tmp = (((__phi_p2 * -0.70710678) * __Gf_ac) * ( 1.0 - ((__phi_p2 *  0.166666666666667) * ( 1.0 - (__phi_p2 *  0.166666666666667)))));
                    end
                    else begin
                      if ((abs((- __phi_p2)) <  230.258509299405)) begin
                        temp = exp((- __phi_p2));
                      end
                      else begin
                        if (((- __phi_p2) <  0.0)) begin
                          temp = ( 100.0e-102 / (((-230.258509299405 - (- __phi_p2)) * ((((-230.258509299405 - (- __phi_p2)) * (((-230.258509299405 - (- __phi_p2)) *  0.333333333333333) +  1.0)) *  0.5) +  1.0)) +  1.0));
                        end
                        else begin
                          temp = (((((- __phi_p2) -  230.258509299405) * (((((- __phi_p2) -  230.258509299405) * ((((- __phi_p2) -  230.258509299405) *  0.333333333333333) +  1.0)) *  0.5) +  1.0)) +  1.0) *  10.0e+99);
                        end
                      end
                      __Qb_tmp = (__Gf_ac * sqrt(((temp + __phi_p2) -  1.0)));
                      if ((__phi_p2 > __margin_ac)) begin
                        __Qb_tmp = (- __Qb_tmp);
                      end
                    end
                    __Qp2_0 = (((- __pd) * (__xg_ac - __phi_p2)) - __Qb_tmp);
                    __phi_p3 = (__x_m_ac + ((__H_ac * ( 1.0 - sqrt(( 1.0 - (((__dps_ac *  2.0) / __H_ac) * ( 0.5 - __ym)))))) * inv_phit1));
                    if ((abs(__phi_p3) <= __margin_ac)) begin
                      __Qb_tmp = (((__phi_p3 * -0.70710678) * __Gf_ac) * ( 1.0 - ((__phi_p3 *  0.166666666666667) * ( 1.0 - (__phi_p3 *  0.166666666666667)))));
                    end
                    else begin
                      if ((abs((- __phi_p3)) <  230.258509299405)) begin
                        temp = exp((- __phi_p3));
                      end
                      else begin
                        if (((- __phi_p3) <  0.0)) begin
                          temp = ( 100.0e-102 / (((-230.258509299405 - (- __phi_p3)) * ((((-230.258509299405 - (- __phi_p3)) * (((-230.258509299405 - (- __phi_p3)) *  0.333333333333333) +  1.0)) *  0.5) +  1.0)) +  1.0));
                        end
                        else begin
                          temp = (((((- __phi_p3) -  230.258509299405) * (((((- __phi_p3) -  230.258509299405) * ((((- __phi_p3) -  230.258509299405) *  0.333333333333333) +  1.0)) *  0.5) +  1.0)) +  1.0) *  10.0e+99);
                        end
                      end
                      __Qb_tmp = (__Gf_ac * sqrt(((temp + __phi_p3) -  1.0)));
                      if ((__phi_p3 > __margin_ac)) begin
                        __Qb_tmp = (- __Qb_tmp);
                      end
                    end
                    __Qp3_0 = (((- __pd) * (__xg_ac - __phi_p3)) - __Qb_tmp);
                    __phi_p4 = (__x_m_ac + ((__H_ac * ( 1.0 - sqrt(( 1.0 - (((__dps_ac *  2.0) / __H_ac) * ( 0.666666666666667 - __ym)))))) * inv_phit1));
                    if ((abs(__phi_p4) <= __margin_ac)) begin
                      __Qb_tmp = (((__phi_p4 * -0.70710678) * __Gf_ac) * ( 1.0 - ((__phi_p4 *  0.166666666666667) * ( 1.0 - (__phi_p4 *  0.166666666666667)))));
                    end
                    else begin
                      if ((abs((- __phi_p4)) <  230.258509299405)) begin
                        temp = exp((- __phi_p4));
                      end
                      else begin
                        if (((- __phi_p4) <  0.0)) begin
                          temp = ( 100.0e-102 / (((-230.258509299405 - (- __phi_p4)) * ((((-230.258509299405 - (- __phi_p4)) * (((-230.258509299405 - (- __phi_p4)) *  0.333333333333333) +  1.0)) *  0.5) +  1.0)) +  1.0));
                        end
                        else begin
                          temp = (((((- __phi_p4) -  230.258509299405) * (((((- __phi_p4) -  230.258509299405) * ((((- __phi_p4) -  230.258509299405) *  0.333333333333333) +  1.0)) *  0.5) +  1.0)) +  1.0) *  10.0e+99);
                        end
                      end
                      __Qb_tmp = (__Gf_ac * sqrt(((temp + __phi_p4) -  1.0)));
                      if ((__phi_p4 > __margin_ac)) begin
                        __Qb_tmp = (- __Qb_tmp);
                      end
                    end
                    __Qp4_0 = (((- __pd) * (__xg_ac - __phi_p4)) - __Qb_tmp);
                    __phi_p5 = (__x_m_ac + ((__H_ac * ( 1.0 - sqrt(( 1.0 - (((__dps_ac *  2.0) / __H_ac) * ( 0.833333333333333 - __ym)))))) * inv_phit1));
                    if ((abs(__phi_p5) <= __margin_ac)) begin
                      __Qb_tmp = (((__phi_p5 * -0.70710678) * __Gf_ac) * ( 1.0 - ((__phi_p5 *  0.166666666666667) * ( 1.0 - (__phi_p5 *  0.166666666666667)))));
                    end
                    else begin
                      if ((abs((- __phi_p5)) <  230.258509299405)) begin
                        temp = exp((- __phi_p5));
                      end
                      else begin
                        if (((- __phi_p5) <  0.0)) begin
                          temp = ( 100.0e-102 / (((-230.258509299405 - (- __phi_p5)) * ((((-230.258509299405 - (- __phi_p5)) * (((-230.258509299405 - (- __phi_p5)) *  0.333333333333333) +  1.0)) *  0.5) +  1.0)) +  1.0));
                        end
                        else begin
                          temp = (((((- __phi_p5) -  230.258509299405) * (((((- __phi_p5) -  230.258509299405) * ((((- __phi_p5) -  230.258509299405) *  0.333333333333333) +  1.0)) *  0.5) +  1.0)) +  1.0) *  10.0e+99);
                        end
                      end
                      __Qb_tmp = (__Gf_ac * sqrt(((temp + __phi_p5) -  1.0)));
                      if ((__phi_p5 > __margin_ac)) begin
                        __Qb_tmp = (- __Qb_tmp);
                      end
                    end
                    __Qp5_0 = (((- __pd) * (__xg_ac - __phi_p5)) - __Qb_tmp);
                    if ((sigVds <  0.0)) begin
                      temp = __Qp1_0;
                      __Qp1_0 = __Qp5_0;
                      __Qp5_0 = temp;
                      temp = __Qp2_0;
                      __Qp2_0 = __Qp4_0;
                      __Qp4_0 = temp;
                    end
                  end
                  else begin
                    if ((__SWNQS_i == 9)) begin
                      __phi_p1 = (__x_m_ac + ((__H_ac * ( 1.0 - sqrt(( 1.0 - (((__dps_ac *  2.0) / __H_ac) * ( 0.1 - __ym)))))) * inv_phit1));
                      if ((abs(__phi_p1) <= __margin_ac)) begin
                        __Qb_tmp = (((__phi_p1 * -0.70710678) * __Gf_ac) * ( 1.0 - ((__phi_p1 *  0.166666666666667) * ( 1.0 - (__phi_p1 *  0.166666666666667)))));
                      end
                      else begin
                        if ((abs((- __phi_p1)) <  230.258509299405)) begin
                          temp = exp((- __phi_p1));
                        end
                        else begin
                          if (((- __phi_p1) <  0.0)) begin
                            temp = ( 100.0e-102 / (((-230.258509299405 - (- __phi_p1)) * ((((-230.258509299405 - (- __phi_p1)) * (((-230.258509299405 - (- __phi_p1)) *  0.333333333333333) +  1.0)) *  0.5) +  1.0)) +  1.0));
                          end
                          else begin
                            temp = (((((- __phi_p1) -  230.258509299405) * (((((- __phi_p1) -  230.258509299405) * ((((- __phi_p1) -  230.258509299405) *  0.333333333333333) +  1.0)) *  0.5) +  1.0)) +  1.0) *  10.0e+99);
                          end
                        end
                        __Qb_tmp = (__Gf_ac * sqrt(((temp + __phi_p1) -  1.0)));
                        if ((__phi_p1 > __margin_ac)) begin
                          __Qb_tmp = (- __Qb_tmp);
                        end
                      end
                      __Qp1_0 = (((- __pd) * (__xg_ac - __phi_p1)) - __Qb_tmp);
                      __phi_p2 = (__x_m_ac + ((__H_ac * ( 1.0 - sqrt(( 1.0 - (((__dps_ac *  2.0) / __H_ac) * ( 0.2 - __ym)))))) * inv_phit1));
                      if ((abs(__phi_p2) <= __margin_ac)) begin
                        __Qb_tmp = (((__phi_p2 * -0.70710678) * __Gf_ac) * ( 1.0 - ((__phi_p2 *  0.166666666666667) * ( 1.0 - (__phi_p2 *  0.166666666666667)))));
                      end
                      else begin
                        if ((abs((- __phi_p2)) <  230.258509299405)) begin
                          temp = exp((- __phi_p2));
                        end
                        else begin
                          if (((- __phi_p2) <  0.0)) begin
                            temp = ( 100.0e-102 / (((-230.258509299405 - (- __phi_p2)) * ((((-230.258509299405 - (- __phi_p2)) * (((-230.258509299405 - (- __phi_p2)) *  0.333333333333333) +  1.0)) *  0.5) +  1.0)) +  1.0));
                          end
                          else begin
                            temp = (((((- __phi_p2) -  230.258509299405) * (((((- __phi_p2) -  230.258509299405) * ((((- __phi_p2) -  230.258509299405) *  0.333333333333333) +  1.0)) *  0.5) +  1.0)) +  1.0) *  10.0e+99);
                          end
                        end
                        __Qb_tmp = (__Gf_ac * sqrt(((temp + __phi_p2) -  1.0)));
                        if ((__phi_p2 > __margin_ac)) begin
                          __Qb_tmp = (- __Qb_tmp);
                        end
                      end
                      __Qp2_0 = (((- __pd) * (__xg_ac - __phi_p2)) - __Qb_tmp);
                      __phi_p3 = (__x_m_ac + ((__H_ac * ( 1.0 - sqrt(( 1.0 - (((__dps_ac *  2.0) / __H_ac) * ( 0.3 - __ym)))))) * inv_phit1));
                      if ((abs(__phi_p3) <= __margin_ac)) begin
                        __Qb_tmp = (((__phi_p3 * -0.70710678) * __Gf_ac) * ( 1.0 - ((__phi_p3 *  0.166666666666667) * ( 1.0 - (__phi_p3 *  0.166666666666667)))));
                      end
                      else begin
                        if ((abs((- __phi_p3)) <  230.258509299405)) begin
                          temp = exp((- __phi_p3));
                        end
                        else begin
                          if (((- __phi_p3) <  0.0)) begin
                            temp = ( 100.0e-102 / (((-230.258509299405 - (- __phi_p3)) * ((((-230.258509299405 - (- __phi_p3)) * (((-230.258509299405 - (- __phi_p3)) *  0.333333333333333) +  1.0)) *  0.5) +  1.0)) +  1.0));
                          end
                          else begin
                            temp = (((((- __phi_p3) -  230.258509299405) * (((((- __phi_p3) -  230.258509299405) * ((((- __phi_p3) -  230.258509299405) *  0.333333333333333) +  1.0)) *  0.5) +  1.0)) +  1.0) *  10.0e+99);
                          end
                        end
                        __Qb_tmp = (__Gf_ac * sqrt(((temp + __phi_p3) -  1.0)));
                        if ((__phi_p3 > __margin_ac)) begin
                          __Qb_tmp = (- __Qb_tmp);
                        end
                      end
                      __Qp3_0 = (((- __pd) * (__xg_ac - __phi_p3)) - __Qb_tmp);
                      __phi_p4 = (__x_m_ac + ((__H_ac * ( 1.0 - sqrt(( 1.0 - (((__dps_ac *  2.0) / __H_ac) * ( 0.4 - __ym)))))) * inv_phit1));
                      if ((abs(__phi_p4) <= __margin_ac)) begin
                        __Qb_tmp = (((__phi_p4 * -0.70710678) * __Gf_ac) * ( 1.0 - ((__phi_p4 *  0.166666666666667) * ( 1.0 - (__phi_p4 *  0.166666666666667)))));
                      end
                      else begin
                        if ((abs((- __phi_p4)) <  230.258509299405)) begin
                          temp = exp((- __phi_p4));
                        end
                        else begin
                          if (((- __phi_p4) <  0.0)) begin
                            temp = ( 100.0e-102 / (((-230.258509299405 - (- __phi_p4)) * ((((-230.258509299405 - (- __phi_p4)) * (((-230.258509299405 - (- __phi_p4)) *  0.333333333333333) +  1.0)) *  0.5) +  1.0)) +  1.0));
                          end
                          else begin
                            temp = (((((- __phi_p4) -  230.258509299405) * (((((- __phi_p4) -  230.258509299405) * ((((- __phi_p4) -  230.258509299405) *  0.333333333333333) +  1.0)) *  0.5) +  1.0)) +  1.0) *  10.0e+99);
                          end
                        end
                        __Qb_tmp = (__Gf_ac * sqrt(((temp + __phi_p4) -  1.0)));
                        if ((__phi_p4 > __margin_ac)) begin
                          __Qb_tmp = (- __Qb_tmp);
                        end
                      end
                      __Qp4_0 = (((- __pd) * (__xg_ac - __phi_p4)) - __Qb_tmp);
                      __phi_p5 = (__x_m_ac + ((__H_ac * ( 1.0 - sqrt(( 1.0 - (((__dps_ac *  2.0) / __H_ac) * ( 0.5 - __ym)))))) * inv_phit1));
                      if ((abs(__phi_p5) <= __margin_ac)) begin
                        __Qb_tmp = (((__phi_p5 * -0.70710678) * __Gf_ac) * ( 1.0 - ((__phi_p5 *  0.166666666666667) * ( 1.0 - (__phi_p5 *  0.166666666666667)))));
                      end
                      else begin
                        if ((abs((- __phi_p5)) <  230.258509299405)) begin
                          temp = exp((- __phi_p5));
                        end
                        else begin
                          if (((- __phi_p5) <  0.0)) begin
                            temp = ( 100.0e-102 / (((-230.258509299405 - (- __phi_p5)) * ((((-230.258509299405 - (- __phi_p5)) * (((-230.258509299405 - (- __phi_p5)) *  0.333333333333333) +  1.0)) *  0.5) +  1.0)) +  1.0));
                          end
                          else begin
                            temp = (((((- __phi_p5) -  230.258509299405) * (((((- __phi_p5) -  230.258509299405) * ((((- __phi_p5) -  230.258509299405) *  0.333333333333333) +  1.0)) *  0.5) +  1.0)) +  1.0) *  10.0e+99);
                          end
                        end
                        __Qb_tmp = (__Gf_ac * sqrt(((temp + __phi_p5) -  1.0)));
                        if ((__phi_p5 > __margin_ac)) begin
                          __Qb_tmp = (- __Qb_tmp);
                        end
                      end
                      __Qp5_0 = (((- __pd) * (__xg_ac - __phi_p5)) - __Qb_tmp);
                      __phi_p6 = (__x_m_ac + ((__H_ac * ( 1.0 - sqrt(( 1.0 - (((__dps_ac *  2.0) / __H_ac) * ( 0.6 - __ym)))))) * inv_phit1));
                      if ((abs(__phi_p6) <= __margin_ac)) begin
                        __Qb_tmp = (((__phi_p6 * -0.70710678) * __Gf_ac) * ( 1.0 - ((__phi_p6 *  0.166666666666667) * ( 1.0 - (__phi_p6 *  0.166666666666667)))));
                      end
                      else begin
                        if ((abs((- __phi_p6)) <  230.258509299405)) begin
                          temp = exp((- __phi_p6));
                        end
                        else begin
                          if (((- __phi_p6) <  0.0)) begin
                            temp = ( 100.0e-102 / (((-230.258509299405 - (- __phi_p6)) * ((((-230.258509299405 - (- __phi_p6)) * (((-230.258509299405 - (- __phi_p6)) *  0.333333333333333) +  1.0)) *  0.5) +  1.0)) +  1.0));
                          end
                          else begin
                            temp = (((((- __phi_p6) -  230.258509299405) * (((((- __phi_p6) -  230.258509299405) * ((((- __phi_p6) -  230.258509299405) *  0.333333333333333) +  1.0)) *  0.5) +  1.0)) +  1.0) *  10.0e+99);
                          end
                        end
                        __Qb_tmp = (__Gf_ac * sqrt(((temp + __phi_p6) -  1.0)));
                        if ((__phi_p6 > __margin_ac)) begin
                          __Qb_tmp = (- __Qb_tmp);
                        end
                      end
                      __Qp6_0 = (((- __pd) * (__xg_ac - __phi_p6)) - __Qb_tmp);
                      __phi_p7 = (__x_m_ac + ((__H_ac * ( 1.0 - sqrt(( 1.0 - (((__dps_ac *  2.0) / __H_ac) * ( 0.7 - __ym)))))) * inv_phit1));
                      if ((abs(__phi_p7) <= __margin_ac)) begin
                        __Qb_tmp = (((__phi_p7 * -0.70710678) * __Gf_ac) * ( 1.0 - ((__phi_p7 *  0.166666666666667) * ( 1.0 - (__phi_p7 *  0.166666666666667)))));
                      end
                      else begin
                        if ((abs((- __phi_p7)) <  230.258509299405)) begin
                          temp = exp((- __phi_p7));
                        end
                        else begin
                          if (((- __phi_p7) <  0.0)) begin
                            temp = ( 100.0e-102 / (((-230.258509299405 - (- __phi_p7)) * ((((-230.258509299405 - (- __phi_p7)) * (((-230.258509299405 - (- __phi_p7)) *  0.333333333333333) +  1.0)) *  0.5) +  1.0)) +  1.0));
                          end
                          else begin
                            temp = (((((- __phi_p7) -  230.258509299405) * (((((- __phi_p7) -  230.258509299405) * ((((- __phi_p7) -  230.258509299405) *  0.333333333333333) +  1.0)) *  0.5) +  1.0)) +  1.0) *  10.0e+99);
                          end
                        end
                        __Qb_tmp = (__Gf_ac * sqrt(((temp + __phi_p7) -  1.0)));
                        if ((__phi_p7 > __margin_ac)) begin
                          __Qb_tmp = (- __Qb_tmp);
                        end
                      end
                      __Qp7_0 = (((- __pd) * (__xg_ac - __phi_p7)) - __Qb_tmp);
                      __phi_p8 = (__x_m_ac + ((__H_ac * ( 1.0 - sqrt(( 1.0 - (((__dps_ac *  2.0) / __H_ac) * ( 0.8 - __ym)))))) * inv_phit1));
                      if ((abs(__phi_p8) <= __margin_ac)) begin
                        __Qb_tmp = (((__phi_p8 * -0.70710678) * __Gf_ac) * ( 1.0 - ((__phi_p8 *  0.166666666666667) * ( 1.0 - (__phi_p8 *  0.166666666666667)))));
                      end
                      else begin
                        if ((abs((- __phi_p8)) <  230.258509299405)) begin
                          temp = exp((- __phi_p8));
                        end
                        else begin
                          if (((- __phi_p8) <  0.0)) begin
                            temp = ( 100.0e-102 / (((-230.258509299405 - (- __phi_p8)) * ((((-230.258509299405 - (- __phi_p8)) * (((-230.258509299405 - (- __phi_p8)) *  0.333333333333333) +  1.0)) *  0.5) +  1.0)) +  1.0));
                          end
                          else begin
                            temp = (((((- __phi_p8) -  230.258509299405) * (((((- __phi_p8) -  230.258509299405) * ((((- __phi_p8) -  230.258509299405) *  0.333333333333333) +  1.0)) *  0.5) +  1.0)) +  1.0) *  10.0e+99);
                          end
                        end
                        __Qb_tmp = (__Gf_ac * sqrt(((temp + __phi_p8) -  1.0)));
                        if ((__phi_p8 > __margin_ac)) begin
                          __Qb_tmp = (- __Qb_tmp);
                        end
                      end
                      __Qp8_0 = (((- __pd) * (__xg_ac - __phi_p8)) - __Qb_tmp);
                      __phi_p9 = (__x_m_ac + ((__H_ac * ( 1.0 - sqrt(( 1.0 - (((__dps_ac *  2.0) / __H_ac) * ( 0.9 - __ym)))))) * inv_phit1));
                      if ((abs(__phi_p9) <= __margin_ac)) begin
                        __Qb_tmp = (((__phi_p9 * -0.70710678) * __Gf_ac) * ( 1.0 - ((__phi_p9 *  0.166666666666667) * ( 1.0 - (__phi_p9 *  0.166666666666667)))));
                      end
                      else begin
                        if ((abs((- __phi_p9)) <  230.258509299405)) begin
                          temp = exp((- __phi_p9));
                        end
                        else begin
                          if (((- __phi_p9) <  0.0)) begin
                            temp = ( 100.0e-102 / (((-230.258509299405 - (- __phi_p9)) * ((((-230.258509299405 - (- __phi_p9)) * (((-230.258509299405 - (- __phi_p9)) *  0.333333333333333) +  1.0)) *  0.5) +  1.0)) +  1.0));
                          end
                          else begin
                            temp = (((((- __phi_p9) -  230.258509299405) * (((((- __phi_p9) -  230.258509299405) * ((((- __phi_p9) -  230.258509299405) *  0.333333333333333) +  1.0)) *  0.5) +  1.0)) +  1.0) *  10.0e+99);
                          end
                        end
                        __Qb_tmp = (__Gf_ac * sqrt(((temp + __phi_p9) -  1.0)));
                        if ((__phi_p9 > __margin_ac)) begin
                          __Qb_tmp = (- __Qb_tmp);
                        end
                      end
                      __Qp9_0 = (((- __pd) * (__xg_ac - __phi_p9)) - __Qb_tmp);
                      if ((sigVds <  0.0)) begin
                        temp = __Qp1_0;
                        __Qp1_0 = __Qp9_0;
                        __Qp9_0 = temp;
                        temp = __Qp2_0;
                        __Qp2_0 = __Qp8_0;
                        __Qp8_0 = temp;
                        temp = __Qp3_0;
                        __Qp3_0 = __Qp7_0;
                        __Qp7_0 = temp;
                        temp = __Qp4_0;
                        __Qp4_0 = __Qp6_0;
                        __Qp6_0 = temp;
                      end
                    end
                  end
                end
              end
            end
          end
        end
        __x_sp =  0.0;
        __x_dp =  0.0;
        __Qp0 =  0.0;
        __QpN =  0.0;
        if ((__SWNQS_i != 0)) begin
          __x_sp = (__x_m_ac - (((sigVds *  0.5) * __dps_ac) * inv_phit1));
          __x_dp = (__x_m_ac + (((sigVds *  0.5) * __dps_ac) * inv_phit1));
          __Qp0 =  0.0;
          __QpN =  0.0;
          if ((__x_sp >  0.0)) begin
            if ((abs(__x_sp) <= __margin_ac)) begin
              __QbSIGN = (((__x_sp * -0.70710678) * __Gf_ac) * ( 1.0 - ((__x_sp *  0.166666666666667) * ( 1.0 - (__x_sp *  0.166666666666667)))));
            end
            else begin
              if ((abs((- __x_sp)) <  230.258509299405)) begin
                temp = exp((- __x_sp));
              end
              else begin
                if (((- __x_sp) <  0.0)) begin
                  temp = ( 100.0e-102 / (((-230.258509299405 - (- __x_sp)) * ((((-230.258509299405 - (- __x_sp)) * (((-230.258509299405 - (- __x_sp)) *  0.333333333333333) +  1.0)) *  0.5) +  1.0)) +  1.0));
                end
                else begin
                  temp = (((((- __x_sp) -  230.258509299405) * (((((- __x_sp) -  230.258509299405) * ((((- __x_sp) -  230.258509299405) *  0.333333333333333) +  1.0)) *  0.5) +  1.0)) +  1.0) *  10.0e+99);
                end
              end
              __QbSIGN = (__Gf_ac * sqrt(((temp + __x_sp) -  1.0)));
              if ((__x_sp > __margin_ac)) begin
                __QbSIGN = (- __QbSIGN);
              end
            end
            __Qp0 = (((- __pd) * (__xg_ac - __x_sp)) - __QbSIGN);
          end
          if ((__x_dp >  0.0)) begin
            if ((abs(__x_dp) <= __margin_ac)) begin
              __QbSIGN = (((__x_dp * -0.70710678) * __Gf_ac) * ( 1.0 - ((__x_dp *  0.166666666666667) * ( 1.0 - (__x_dp *  0.166666666666667)))));
            end
            else begin
              if ((abs((- __x_dp)) <  230.258509299405)) begin
                temp = exp((- __x_dp));
              end
              else begin
                if (((- __x_dp) <  0.0)) begin
                  temp = ( 100.0e-102 / (((-230.258509299405 - (- __x_dp)) * ((((-230.258509299405 - (- __x_dp)) * (((-230.258509299405 - (- __x_dp)) *  0.333333333333333) +  1.0)) *  0.5) +  1.0)) +  1.0));
                end
                else begin
                  temp = (((((- __x_dp) -  230.258509299405) * (((((- __x_dp) -  230.258509299405) * ((((- __x_dp) -  230.258509299405) *  0.333333333333333) +  1.0)) *  0.5) +  1.0)) +  1.0) *  10.0e+99);
                end
              end
              __QbSIGN = (__Gf_ac * sqrt(((temp + __x_dp) -  1.0)));
              if ((__x_dp > __margin_ac)) begin
                __QbSIGN = (- __QbSIGN);
              end
            end
            __QpN = (((- __pd) * (__xg_ac - __x_dp)) - __QbSIGN);
          end
        end
        __rgatenoise = (__nt0 * __ggate);
        __rsourcenoise = (__nt0 * __gsource);
        __rdrainnoise = (__nt0 * __gdrain);
        __rbulknoise = (__nt0 * __gbulk);
        __rjunsnoise = (__nt0 * __gjuns);
        __rjundnoise = (__nt0 * __gjund);
        __rwellnoise = (__nt0 * __gwell);
      end
      begin : loadStatic
        if ((sigVds >  0.0)) begin
          I(DI, BP) <+ ((__CHNL_TYPE * __MULT_i) * Iimpact);
          I(DI, SI) <+ ((__CHNL_TYPE * __MULT_i) * (Ids + Idsedge));
          I(GP, SI) <+ ((__CHNL_TYPE * __MULT_i) * Igcs);
          I(GP, DI) <+ ((__CHNL_TYPE * __MULT_i) * Igcd);
        end
        else begin
          I(SI, BP) <+ ((__CHNL_TYPE * __MULT_i) * Iimpact);
          I(SI, DI) <+ ((__CHNL_TYPE * __MULT_i) * (Ids + Idsedge));
          I(GP, DI) <+ ((__CHNL_TYPE * __MULT_i) * Igcs);
          I(GP, SI) <+ ((__CHNL_TYPE * __MULT_i) * Igcd);
        end
        I(GP, BP) <+ ((__CHNL_TYPE * __MULT_i) * __Igb);
        I(GP, SI) <+ ((__CHNL_TYPE * __MULT_i) * Igsov);
        I(GP, DI) <+ ((__CHNL_TYPE * __MULT_i) * Igdov);
        I(SI, BP) <+ ((__CHNL_TYPE * __MULT_i) * __Igisl);
        I(DI, BP) <+ ((__CHNL_TYPE * __MULT_i) * __Igidl);
        I(BS, SI) <+ ((__CHNL_TYPE * __MULT_i) * ijun_s);
        I(BD, DI) <+ ((__CHNL_TYPE * __MULT_i) * ijun_d);
        if ((__RG_i >  0.0)) begin
          I(G, GP) <+ ((__MULT_i * __ggate) * V(G, GP));
          I(G, GP) <+ white_noise((__MULT_i * __rgatenoise), "rgate");
        end
        else begin
          V(G, GP) <+  0.0;
        end
        if ((__RSE_i >  0.0)) begin
          I(S, SI) <+ ((__MULT_i * __gsource) * V(S, SI));
          I(S, SI) <+ white_noise((__MULT_i * __rsourcenoise), "rsource");
        end
        else begin
          V(S, SI) <+  0.0;
        end
        if ((__RDE_i >  0.0)) begin
          I(D, DI) <+ ((__MULT_i * __gdrain) * V(D, DI));
          I(D, DI) <+ white_noise((__MULT_i * __rdrainnoise), "rdrain");
        end
        else begin
          V(D, DI) <+  0.0;
        end
        if ((__RBULK_i >  0.0)) begin
          I(BP, BI) <+ ((__MULT_i * __gbulk) * V(BP, BI));
          I(BP, BI) <+ white_noise((__MULT_i * __rbulknoise), "rbulk");
        end
        else begin
          V(BP, BI) <+  0.0;
        end
        if ((__RJUNS_i >  0.0)) begin
          I(BS, BI) <+ ((__MULT_i * __gjuns) * V(BS, BI));
          I(BS, BI) <+ white_noise((__MULT_i * __rjunsnoise), "rjuns");
        end
        else begin
          V(BS, BI) <+  0.0;
        end
        if ((__RJUND_i >  0.0)) begin
          I(BD, BI) <+ ((__MULT_i * __gjund) * V(BD, BI));
          I(BD, BI) <+ white_noise((__MULT_i * __rjundnoise), "rjund");
        end
        else begin
          V(BD, BI) <+  0.0;
        end
        if ((__RWELL_i >  0.0)) begin
          I(B, BI) <+ ((__MULT_i * __gwell) * V(B, BI));
          I(B, BI) <+ white_noise((__MULT_i * __rwellnoise), "rwell");
        end
        else begin
          V(B, BI) <+  0.0;
        end
        I(DI, BP) <+ (__gmin * V(DI, BP));
        I(SI, BP) <+ (__gmin * V(SI, BP));
      end
      begin : loadStaticDynamic
        __Qp1 = (__vnorm * V(SPLINE1));
        __Qp2 = (__vnorm * V(SPLINE2));
        __Qp3 = (__vnorm * V(SPLINE3));
        __Qp4 = (__vnorm * V(SPLINE4));
        __Qp5 = (__vnorm * V(SPLINE5));
        __Qp6 = (__vnorm * V(SPLINE6));
        __Qp7 = (__vnorm * V(SPLINE7));
        __Qp8 = (__vnorm * V(SPLINE8));
        __Qp9 = (__vnorm * V(SPLINE9));
        __Tnorm =  0.0;
        if ((__SWNQS_i != 0)) begin
          __Tnorm = (((__MUNQS_i * phit1) * __BET_i) / (COX_qm * Gmob_dL_ac));
          __thesat2 = (((__thesat1_ac * __thesat1_ac) * phit1) * phit1);
          if ((__SWNQS_i == 1)) begin
            __dQy = (__QpN - __Qp0);
            __d2Qy = (((__Qp0 + __QpN) *  6.0) - (__Qp1 *  12.0));
          end
          else begin
            if ((__SWNQS_i == 2)) begin
              __dQy = (((((__Qp0 * -7.0) - (__Qp1 *  3.0)) + (__Qp2 *  12.0)) - (__QpN *  2.0)) /  5.0);
              __d2Qy = (((((__Qp0 * -4.0) + (__Qp1 *  9.0)) - (__Qp2 *  6.0)) + __QpN) * -3.6);
            end
            else begin
              if ((__SWNQS_i == 3)) begin
                __dQy = ((((((__Qp0 * -13.0) - (__Qp1 *  6.0)) + (__Qp2 *  24.0)) - (__Qp3 *  6.0)) + __QpN) /  7.0);
                __d2Qy = ((((((__Qp0 *  180.0) - (__Qp1 *  408.0)) + (__Qp2 *  288.0)) - (__Qp3 *  72.0)) + (__QpN *  12.0)) /  7.0);
              end
              else begin
                if ((__SWNQS_i == 5)) begin
                  __dQy = ((((((((__Qp0 * -181.0) - (__Qp1 *  84.0)) + (__Qp4 *  24.0)) - (__Qp5 *  6.0)) - (__Qp3 *  90.0)) + __QpN) + (__Qp2 *  336.0)) /  65.0);
                  __d2Qy = ((((((((__Qp4 *  432.0) - (__Qp5 *  108.0)) - (__Qp3 *  1.62e+3)) + (__QpN *  18.0)) + (__Qp0 *  3.762e+3)) - (__Qp1 *  8.532e+3)) + (__Qp2 *  6.048e+3)) /  65.0);
                end
                else begin
                  if ((__SWNQS_i == 9)) begin
                    __dQy = ((((((((((((__Qp6 *  1.68e+3) + (__Qp4 *  23.4e+3)) + (__QpN *  5.0)) - (__Qp3 *  87.33e+3)) + (__Qp8 *  120.0)) - (__Qp7 *  450.0)) - (__Qp1 *  81.48e+3)) + (__Qp2 *  325.92e+3)) - (__Qp0 *  175.565e+3)) - (__Qp9 *  30.0)) /  37.829e+3) - (__Qp5 *  0.165745856353591));
                    __d2Qy = ((((((((((((__Qp7 * -13.5e+3) + (__Qp4 *  702.0e+3)) - (__Qp3 * 2619900)) - (__Qp1 *  13.7931e+6)) + (__Qp2 *  9.7776e+6)) + (__Qp0 *  6.08175e+6)) + (__QpN *  150.0)) + (__Qp8 *  3.6e+3)) - (__Qp9 *  900.0)) + (__Qp6 *  50.4e+3)) /  37.829e+3) - (__Qp5 *  4.97237569060773));
                  end
                  else begin
                    __dQy =  0.0;
                    __d2Qy =  0.0;
                  end
                end
              end
            end
          end
          temp = ((__Qp1 / __pd) + __xg_ac);
          if ((abs(temp) <= __marginp)) begin
            __xphi = (temp / __a_factrp);
          end
          else begin
            if ((temp < (- __marginp))) begin
              __NQS_yg = (- temp);
              __NQS_z = ((__NQS_yg *  1.25) / __a_factrp);
              __NQS_eta = (((__NQS_z +  10.0) - sqrt((((__NQS_z -  6.0) * (__NQS_z -  6.0)) +  64.0))) *  0.5);
              __NQS_a = (((__NQS_yg - __NQS_eta) * (__NQS_yg - __NQS_eta)) + (__Gp2 * (__NQS_eta +  1.0)));
              __NQS_c = (((__NQS_yg - __NQS_eta) *  2.0) - __Gp2);
              __NQS_tau = (ln((__NQS_a / __Gp2)) - __NQS_eta);
              __nu = (__NQS_a + __NQS_c);
              __mutau = ((__nu * __nu) + (__NQS_tau * (((__NQS_c * __NQS_c) *  0.5) - __NQS_a)));
              __NQS_y0 = (__NQS_eta + (((__NQS_a * __nu) * __NQS_tau) / (__mutau + (((((__nu / __mutau) * __NQS_tau) * __NQS_tau) * __NQS_c) * (((__NQS_c * __NQS_c) *  0.333333333333333) - __NQS_a)))));
              if ((abs(__NQS_y0) <  230.258509299405)) begin
                __NQS_D0 = exp(__NQS_y0);
              end
              else begin
                if ((__NQS_y0 <  0.0)) begin
                  __NQS_D0 = ( 100.0e-102 / (((-230.258509299405 - __NQS_y0) * ((((-230.258509299405 - __NQS_y0) * (((-230.258509299405 - __NQS_y0) *  0.333333333333333) +  1.0)) *  0.5) +  1.0)) +  1.0));
                end
                else begin
                  __NQS_D0 = ((((__NQS_y0 -  230.258509299405) * ((((__NQS_y0 -  230.258509299405) * (((__NQS_y0 -  230.258509299405) *  0.333333333333333) +  1.0)) *  0.5) +  1.0)) +  1.0) *  10.0e+99);
                end
              end
              __NQS_xi = ( 1.0 - ((__Gp2 * __NQS_D0) *  0.5));
              __NQS_p = (((__NQS_yg - __NQS_y0) *  2.0) + (__Gp2 * (__NQS_D0 -  1.0)));
              __NQS_q = (((__NQS_yg - __NQS_y0) * (__NQS_yg - __NQS_y0)) + (__Gp2 * ((__NQS_y0 +  1.0) - __NQS_D0)));
              __NQS_temp = ((__NQS_p * __NQS_p) - ((__NQS_xi *  4.0) * __NQS_q));
              __NQS_w = ((__NQS_q *  2.0) / (__NQS_p + sqrt(__NQS_temp)));
              __xphi = (- (__NQS_y0 + __NQS_w));
            end
            else begin
              __NQS_xg1 = ( 1.0 / ((__Gp *  0.732464877560822) +  1.25));
              __NQS_A_fac = ((((__a_factrp *  1.25) * __NQS_xg1) -  1.0) * __NQS_xg1);
              __NQS_xbar = ((temp / __a_factrp) * ((__NQS_A_fac * temp) +  1.0));
              if ((abs((- __NQS_xbar)) <  230.258509299405)) begin
                __NQS_temp = exp((- __NQS_xbar));
              end
              else begin
                if (((- __NQS_xbar) <  0.0)) begin
                  __NQS_temp = ( 100.0e-102 / (((-230.258509299405 - (- __NQS_xbar)) * ((((-230.258509299405 - (- __NQS_xbar)) * (((-230.258509299405 - (- __NQS_xbar)) *  0.333333333333333) +  1.0)) *  0.5) +  1.0)) +  1.0));
                end
                else begin
                  __NQS_temp = (((((- __NQS_xbar) -  230.258509299405) * (((((- __NQS_xbar) -  230.258509299405) * ((((- __NQS_xbar) -  230.258509299405) *  0.333333333333333) +  1.0)) *  0.5) +  1.0)) +  1.0) *  10.0e+99);
                end
              end
              __NQS_w = ( 1.0 - __NQS_temp);
              __NQS_x0 = ((temp + (__Gp2 *  0.5)) - (__Gp * sqrt(((temp + (__Gp2 *  0.25)) - __NQS_w))));
              if ((abs((- __NQS_x0)) <  230.258509299405)) begin
                __NQS_D0 = exp((- __NQS_x0));
              end
              else begin
                if (((- __NQS_x0) <  0.0)) begin
                  __NQS_D0 = ( 100.0e-102 / (((-230.258509299405 - (- __NQS_x0)) * ((((-230.258509299405 - (- __NQS_x0)) * (((-230.258509299405 - (- __NQS_x0)) *  0.333333333333333) +  1.0)) *  0.5) +  1.0)) +  1.0));
                end
                else begin
                  __NQS_D0 = (((((- __NQS_x0) -  230.258509299405) * (((((- __NQS_x0) -  230.258509299405) * ((((- __NQS_x0) -  230.258509299405) *  0.333333333333333) +  1.0)) *  0.5) +  1.0)) +  1.0) *  10.0e+99);
                end
              end
              __NQS_xi = ( 1.0 - ((__Gp2 *  0.5) * __NQS_D0));
              __NQS_p = (((temp - __NQS_x0) *  2.0) + (__Gp2 * ( 1.0 - __NQS_D0)));
              __NQS_q = (((temp - __NQS_x0) * (temp - __NQS_x0)) - (__Gp2 * ((__NQS_x0 -  1.0) + __NQS_D0)));
              __NQS_temp = ((__NQS_p * __NQS_p) - ((__NQS_xi *  4.0) * __NQS_q));
              __NQS_u = ((__NQS_q *  2.0) / (__NQS_p + sqrt(__NQS_temp)));
              __xphi = (__NQS_x0 + __NQS_u);
            end
          end
          if ((abs(__xphi) <= __margin_ac)) begin
            __Qb_tmp = (((__xphi * -0.70710678) * __Gf_ac) * ( 1.0 - ((__xphi *  0.166666666666667) * ( 1.0 - (__xphi *  0.166666666666667)))));
            __dQbs = ((__Gf_ac * -0.70710678) * ( 1.0 - ((__xphi *  0.333333333333333) * ( 1.0 - (__xphi *  0.25)))));
            __d2Qis = ((__Gf_ac * -0.235702) * ( 1.0 - (__xphi *  0.5)));
          end
          else begin
            if ((abs((- __xphi)) <  230.258509299405)) begin
              temp = exp((- __xphi));
            end
            else begin
              if (((- __xphi) <  0.0)) begin
                temp = ( 100.0e-102 / (((-230.258509299405 - (- __xphi)) * ((((-230.258509299405 - (- __xphi)) * (((-230.258509299405 - (- __xphi)) *  0.333333333333333) +  1.0)) *  0.5) +  1.0)) +  1.0));
              end
              else begin
                temp = (((((- __xphi) -  230.258509299405) * (((((- __xphi) -  230.258509299405) * ((((- __xphi) -  230.258509299405) *  0.333333333333333) +  1.0)) *  0.5) +  1.0)) +  1.0) *  10.0e+99);
              end
            end
            __Qb_tmp = (__Gf_ac * sqrt(((temp + __xphi) -  1.0)));
            if ((__xphi > __margin_ac)) begin
              __Qb_tmp = (- __Qb_tmp);
            end
            __dQbs = ((((__Gf_ac *  0.5) * __Gf_ac) * ( 1.0 - temp)) / __Qb_tmp);
            __d2Qis = ((((__dQbs * __dQbs) - ((__Gf_ac *  0.5) * __Gf_ac)) / __Qb_tmp) + __dQbs);
          end
          __dQis = (__pd - __dQbs);
          __dQis_1 = ( 1.0 / __dQis);
          __fQi = ((__Qp1 * __dQis_1) -  1.0);
          __dfQi = (( 1.0 - (((__Qp1 * __d2Qis) * __dQis_1) * __dQis_1)) * __dQis_1);
          __fk0 = (((__dfQi * __dQy) * __dQy) + (__fQi * __d2Qy));
          __dpsy2 = (((__dQy * __dQy) * __dQis_1) * __dQis_1);
          __zsat_nqs = (__thesat2 * __dpsy2);
          if ((__CHNL_TYPE == -1)) begin
            __zsat_nqs = (__zsat_nqs / ((__thesat1_ac * __dps_ac) +  1.0));
          end
          temp = sqrt(((__zsat_nqs *  2.0) +  1.0));
          __Fvsat = ( 2.0 / (temp +  1.0));
          temp1 = (__d2Qy - (__dpsy2 * __d2Qis));
          __fk1 = (__Fvsat * (__fk0 - ((((__zsat_nqs * __fQi) * temp1) * __Fvsat) / temp)));
        end
        else begin
          __thesat2 =  0.0;
        end
        if ((__SWNQS_i >= 2)) begin
          if ((__SWNQS_i == 2)) begin
            __dQy = (((((__Qp0 *  2.0) - (__Qp1 *  12.0)) + (__Qp2 *  3.0)) + (__QpN *  7.0)) /  5.0);
            __d2Qy = (((((__QpN * -4.0) + (__Qp2 *  9.0)) - (__Qp1 *  6.0)) + __Qp0) * -3.6);
          end
          else begin
            if ((__SWNQS_i == 3)) begin
              __dQy = ((((__Qp0 *  0.5) - (__Qp1 *  3.0)) + (__Qp3 *  3.0)) - (__QpN *  0.5));
              __d2Qy = ((((((__Qp0 * -48.0) + (__Qp1 *  288.0)) - (__Qp2 *  480.0)) + (__Qp3 *  288.0)) - (__QpN *  48.0)) /  7.0);
            end
            else begin
              if ((__SWNQS_i == 5)) begin
                __dQy = ((((((__Qp1 * -291.0) - (__Qp2 *  6.0)) - (__Qp4 *  84.0)) + (__Qp5 *  21.0)) /  65.0) + ((((__Qp3 *  630.0) - (__QpN *  7.0)) + (__Qp0 *  97.0)) /  130.0));
                __d2Qy = ((((((((__Qp4 * -1.728e+3) + (__Qp5 *  432.0)) + (__Qp3 *  6.48e+3)) - (__QpN *  72.0)) - (__Qp0 *  1.008e+3)) + (__Qp1 *  6.048e+3)) - (__Qp2 *  10.152e+3)) /  65.0);
              end
              else begin
                if ((__SWNQS_i == 9)) begin
                  __dQy = (((((((((((__Qp6 * -5.88e+3) - (__Qp4 *  81.9e+3)) + (__Qp3 *  305.655e+3)) - (__Qp8 *  420.0)) + (__Qp9 *  105.0)) - (__Qp1 *  282.255e+3)) + (__Qp7 *  1.575e+3)) - (__Qp2 *  5.85e+3)) /  37.829e+3) + (__Qp5 *  0.580110497237569)) + (((__Qp0 *  94.085e+3) - (__QpN *  35.0)) /  75.658e+3));
                  __d2Qy = ((((((((((((__Qp1 *  9.7776e+6) + (__Qp7 *  54.0e+3)) - (__Qp4 *  2.808e+6)) + (__Qp3 *  10.4796e+6)) - (__Qp2 *  16.413e+6)) - (__Qp0 *  1.6296e+6)) - (__QpN *  600.0)) - (__Qp8 *  14.4e+3)) + (__Qp9 *  3.6e+3)) - (__Qp6 *  201.6e+3)) /  37.829e+3) + (__Qp5 *  19.8895027624309));
                end
                else begin
                  __dQy =  0.0;
                  __d2Qy =  0.0;
                end
              end
            end
          end
          temp = ((__Qp2 / __pd) + __xg_ac);
          if ((abs(temp) <= __marginp)) begin
            __xphi = (temp / __a_factrp);
          end
          else begin
            if ((temp < (- __marginp))) begin
              __NQS_yg = (- temp);
              __NQS_z = ((__NQS_yg *  1.25) / __a_factrp);
              __NQS_eta = (((__NQS_z +  10.0) - sqrt((((__NQS_z -  6.0) * (__NQS_z -  6.0)) +  64.0))) *  0.5);
              __NQS_a = (((__NQS_yg - __NQS_eta) * (__NQS_yg - __NQS_eta)) + (__Gp2 * (__NQS_eta +  1.0)));
              __NQS_c = (((__NQS_yg - __NQS_eta) *  2.0) - __Gp2);
              __NQS_tau = (ln((__NQS_a / __Gp2)) - __NQS_eta);
              __nu = (__NQS_a + __NQS_c);
              __mutau = ((__nu * __nu) + (__NQS_tau * (((__NQS_c * __NQS_c) *  0.5) - __NQS_a)));
              __NQS_y0 = (__NQS_eta + (((__NQS_a * __nu) * __NQS_tau) / (__mutau + (((((__nu / __mutau) * __NQS_tau) * __NQS_tau) * __NQS_c) * (((__NQS_c * __NQS_c) *  0.333333333333333) - __NQS_a)))));
              if ((abs(__NQS_y0) <  230.258509299405)) begin
                __NQS_D0 = exp(__NQS_y0);
              end
              else begin
                if ((__NQS_y0 <  0.0)) begin
                  __NQS_D0 = ( 100.0e-102 / (((-230.258509299405 - __NQS_y0) * ((((-230.258509299405 - __NQS_y0) * (((-230.258509299405 - __NQS_y0) *  0.333333333333333) +  1.0)) *  0.5) +  1.0)) +  1.0));
                end
                else begin
                  __NQS_D0 = ((((__NQS_y0 -  230.258509299405) * ((((__NQS_y0 -  230.258509299405) * (((__NQS_y0 -  230.258509299405) *  0.333333333333333) +  1.0)) *  0.5) +  1.0)) +  1.0) *  10.0e+99);
                end
              end
              __NQS_xi = ( 1.0 - ((__Gp2 * __NQS_D0) *  0.5));
              __NQS_p = (((__NQS_yg - __NQS_y0) *  2.0) + (__Gp2 * (__NQS_D0 -  1.0)));
              __NQS_q = (((__NQS_yg - __NQS_y0) * (__NQS_yg - __NQS_y0)) + (__Gp2 * ((__NQS_y0 +  1.0) - __NQS_D0)));
              __NQS_temp = ((__NQS_p * __NQS_p) - ((__NQS_xi *  4.0) * __NQS_q));
              __NQS_w = ((__NQS_q *  2.0) / (__NQS_p + sqrt(__NQS_temp)));
              __xphi = (- (__NQS_y0 + __NQS_w));
            end
            else begin
              __NQS_xg1 = ( 1.0 / ((__Gp *  0.732464877560822) +  1.25));
              __NQS_A_fac = ((((__a_factrp *  1.25) * __NQS_xg1) -  1.0) * __NQS_xg1);
              __NQS_xbar = ((temp / __a_factrp) * ((__NQS_A_fac * temp) +  1.0));
              if ((abs((- __NQS_xbar)) <  230.258509299405)) begin
                __NQS_temp = exp((- __NQS_xbar));
              end
              else begin
                if (((- __NQS_xbar) <  0.0)) begin
                  __NQS_temp = ( 100.0e-102 / (((-230.258509299405 - (- __NQS_xbar)) * ((((-230.258509299405 - (- __NQS_xbar)) * (((-230.258509299405 - (- __NQS_xbar)) *  0.333333333333333) +  1.0)) *  0.5) +  1.0)) +  1.0));
                end
                else begin
                  __NQS_temp = (((((- __NQS_xbar) -  230.258509299405) * (((((- __NQS_xbar) -  230.258509299405) * ((((- __NQS_xbar) -  230.258509299405) *  0.333333333333333) +  1.0)) *  0.5) +  1.0)) +  1.0) *  10.0e+99);
                end
              end
              __NQS_w = ( 1.0 - __NQS_temp);
              __NQS_x0 = ((temp + (__Gp2 *  0.5)) - (__Gp * sqrt(((temp + (__Gp2 *  0.25)) - __NQS_w))));
              if ((abs((- __NQS_x0)) <  230.258509299405)) begin
                __NQS_D0 = exp((- __NQS_x0));
              end
              else begin
                if (((- __NQS_x0) <  0.0)) begin
                  __NQS_D0 = ( 100.0e-102 / (((-230.258509299405 - (- __NQS_x0)) * ((((-230.258509299405 - (- __NQS_x0)) * (((-230.258509299405 - (- __NQS_x0)) *  0.333333333333333) +  1.0)) *  0.5) +  1.0)) +  1.0));
                end
                else begin
                  __NQS_D0 = (((((- __NQS_x0) -  230.258509299405) * (((((- __NQS_x0) -  230.258509299405) * ((((- __NQS_x0) -  230.258509299405) *  0.333333333333333) +  1.0)) *  0.5) +  1.0)) +  1.0) *  10.0e+99);
                end
              end
              __NQS_xi = ( 1.0 - ((__Gp2 *  0.5) * __NQS_D0));
              __NQS_p = (((temp - __NQS_x0) *  2.0) + (__Gp2 * ( 1.0 - __NQS_D0)));
              __NQS_q = (((temp - __NQS_x0) * (temp - __NQS_x0)) - (__Gp2 * ((__NQS_x0 -  1.0) + __NQS_D0)));
              __NQS_temp = ((__NQS_p * __NQS_p) - ((__NQS_xi *  4.0) * __NQS_q));
              __NQS_u = ((__NQS_q *  2.0) / (__NQS_p + sqrt(__NQS_temp)));
              __xphi = (__NQS_x0 + __NQS_u);
            end
          end
          if ((abs(__xphi) <= __margin_ac)) begin
            __Qb_tmp = (((__xphi * -0.70710678) * __Gf_ac) * ( 1.0 - ((__xphi *  0.166666666666667) * ( 1.0 - (__xphi *  0.166666666666667)))));
            __dQbs = ((__Gf_ac * -0.70710678) * ( 1.0 - ((__xphi *  0.333333333333333) * ( 1.0 - (__xphi *  0.25)))));
            __d2Qis = ((__Gf_ac * -0.235702) * ( 1.0 - (__xphi *  0.5)));
          end
          else begin
            if ((abs((- __xphi)) <  230.258509299405)) begin
              temp = exp((- __xphi));
            end
            else begin
              if (((- __xphi) <  0.0)) begin
                temp = ( 100.0e-102 / (((-230.258509299405 - (- __xphi)) * ((((-230.258509299405 - (- __xphi)) * (((-230.258509299405 - (- __xphi)) *  0.333333333333333) +  1.0)) *  0.5) +  1.0)) +  1.0));
              end
              else begin
                temp = (((((- __xphi) -  230.258509299405) * (((((- __xphi) -  230.258509299405) * ((((- __xphi) -  230.258509299405) *  0.333333333333333) +  1.0)) *  0.5) +  1.0)) +  1.0) *  10.0e+99);
              end
            end
            __Qb_tmp = (__Gf_ac * sqrt(((temp + __xphi) -  1.0)));
            if ((__xphi > __margin_ac)) begin
              __Qb_tmp = (- __Qb_tmp);
            end
            __dQbs = ((((__Gf_ac *  0.5) * __Gf_ac) * ( 1.0 - temp)) / __Qb_tmp);
            __d2Qis = ((((__dQbs * __dQbs) - ((__Gf_ac *  0.5) * __Gf_ac)) / __Qb_tmp) + __dQbs);
          end
          __dQis = (__pd - __dQbs);
          __dQis_1 = ( 1.0 / __dQis);
          __fQi = ((__Qp2 * __dQis_1) -  1.0);
          __dfQi = (( 1.0 - (((__Qp2 * __d2Qis) * __dQis_1) * __dQis_1)) * __dQis_1);
          __fk0 = (((__dfQi * __dQy) * __dQy) + (__fQi * __d2Qy));
          __dpsy2 = (((__dQy * __dQy) * __dQis_1) * __dQis_1);
          __zsat_nqs = (__thesat2 * __dpsy2);
          if ((__CHNL_TYPE == -1)) begin
            __zsat_nqs = (__zsat_nqs / ((__thesat1_ac * __dps_ac) +  1.0));
          end
          temp = sqrt(((__zsat_nqs *  2.0) +  1.0));
          __Fvsat = ( 2.0 / (temp +  1.0));
          temp1 = (__d2Qy - (__dpsy2 * __d2Qis));
          __fk2 = (__Fvsat * (__fk0 - ((((__zsat_nqs * __fQi) * temp1) * __Fvsat) / temp)));
        end
        if ((__SWNQS_i >= 3)) begin
          if ((__SWNQS_i == 3)) begin
            __dQy = ((((((__QpN *  13.0) + (__Qp3 *  6.0)) - (__Qp2 *  24.0)) + (__Qp1 *  6.0)) - __Qp0) /  7.0);
            __d2Qy = ((((((__QpN *  180.0) - (__Qp3 *  408.0)) + (__Qp2 *  288.0)) - (__Qp1 *  72.0)) + (__Qp0 *  12.0)) /  7.0);
          end
          else begin
            if ((__SWNQS_i == 5)) begin
              __dQy = ((((((__QpN - (__Qp5 *  6.0)) + (__Qp4 *  24.0)) - (__Qp2 *  24.0)) + (__Qp1 *  6.0)) - __Qp0) /  5.0);
              __d2Qy = ((((((__Qp4 + __Qp2) *  1.296e+3) - ((__Qp5 + __Qp1) *  324.0)) - (__Qp3 *  2.052e+3)) + ((__QpN + __Qp0) *  54.0)) /  13.0);
            end
            else begin
              if ((__SWNQS_i == 9)) begin
                __dQy = ((((((((((((__Qp6 *  21.84e+3) + (__Qp4 *  304.2e+3)) + (__QpN *  65.0)) - (__Qp3 *  420.0)) + (__Qp8 *  1.56e+3)) - (__Qp0 *  12.605e+3)) - (__Qp9 *  390.0)) + (__Qp1 *  75.63e+3)) - (__Qp7 *  5.85e+3)) - (__Qp2 *  302.52e+3)) /  37.829e+3) - (__Qp5 *  2.15469613259669));
                __d2Qy = ((((((((((((__Qp1 * -2.6199e+6) - (__Qp7 *  202.5e+3)) + (__Qp4 *  10.53e+6)) - (__Qp3 *  16.6011e+6)) + (__Qp2 *  10.4796e+6)) + (__Qp0 *  436.65e+3)) + (__QpN *  2.25e+3)) + (__Qp8 *  54.0e+3)) - (__Qp9 *  13.5e+3)) + (__Qp6 *  756.0e+3)) /  37.829e+3) - (__Qp5 *  74.585635359116));
              end
              else begin
                __dQy =  0.0;
                __d2Qy =  0.0;
              end
            end
          end
          temp = ((__Qp3 / __pd) + __xg_ac);
          if ((abs(temp) <= __marginp)) begin
            __xphi = (temp / __a_factrp);
          end
          else begin
            if ((temp < (- __marginp))) begin
              __NQS_yg = (- temp);
              __NQS_z = ((__NQS_yg *  1.25) / __a_factrp);
              __NQS_eta = (((__NQS_z +  10.0) - sqrt((((__NQS_z -  6.0) * (__NQS_z -  6.0)) +  64.0))) *  0.5);
              __NQS_a = (((__NQS_yg - __NQS_eta) * (__NQS_yg - __NQS_eta)) + (__Gp2 * (__NQS_eta +  1.0)));
              __NQS_c = (((__NQS_yg - __NQS_eta) *  2.0) - __Gp2);
              __NQS_tau = (ln((__NQS_a / __Gp2)) - __NQS_eta);
              __nu = (__NQS_a + __NQS_c);
              __mutau = ((__nu * __nu) + (__NQS_tau * (((__NQS_c * __NQS_c) *  0.5) - __NQS_a)));
              __NQS_y0 = (__NQS_eta + (((__NQS_a * __nu) * __NQS_tau) / (__mutau + (((((__nu / __mutau) * __NQS_tau) * __NQS_tau) * __NQS_c) * (((__NQS_c * __NQS_c) *  0.333333333333333) - __NQS_a)))));
              if ((abs(__NQS_y0) <  230.258509299405)) begin
                __NQS_D0 = exp(__NQS_y0);
              end
              else begin
                if ((__NQS_y0 <  0.0)) begin
                  __NQS_D0 = ( 100.0e-102 / (((-230.258509299405 - __NQS_y0) * ((((-230.258509299405 - __NQS_y0) * (((-230.258509299405 - __NQS_y0) *  0.333333333333333) +  1.0)) *  0.5) +  1.0)) +  1.0));
                end
                else begin
                  __NQS_D0 = ((((__NQS_y0 -  230.258509299405) * ((((__NQS_y0 -  230.258509299405) * (((__NQS_y0 -  230.258509299405) *  0.333333333333333) +  1.0)) *  0.5) +  1.0)) +  1.0) *  10.0e+99);
                end
              end
              __NQS_xi = ( 1.0 - ((__Gp2 * __NQS_D0) *  0.5));
              __NQS_p = (((__NQS_yg - __NQS_y0) *  2.0) + (__Gp2 * (__NQS_D0 -  1.0)));
              __NQS_q = (((__NQS_yg - __NQS_y0) * (__NQS_yg - __NQS_y0)) + (__Gp2 * ((__NQS_y0 +  1.0) - __NQS_D0)));
              __NQS_temp = ((__NQS_p * __NQS_p) - ((__NQS_xi *  4.0) * __NQS_q));
              __NQS_w = ((__NQS_q *  2.0) / (__NQS_p + sqrt(__NQS_temp)));
              __xphi = (- (__NQS_y0 + __NQS_w));
            end
            else begin
              __NQS_xg1 = ( 1.0 / ((__Gp *  0.732464877560822) +  1.25));
              __NQS_A_fac = ((((__a_factrp *  1.25) * __NQS_xg1) -  1.0) * __NQS_xg1);
              __NQS_xbar = ((temp / __a_factrp) * ((__NQS_A_fac * temp) +  1.0));
              if ((abs((- __NQS_xbar)) <  230.258509299405)) begin
                __NQS_temp = exp((- __NQS_xbar));
              end
              else begin
                if (((- __NQS_xbar) <  0.0)) begin
                  __NQS_temp = ( 100.0e-102 / (((-230.258509299405 - (- __NQS_xbar)) * ((((-230.258509299405 - (- __NQS_xbar)) * (((-230.258509299405 - (- __NQS_xbar)) *  0.333333333333333) +  1.0)) *  0.5) +  1.0)) +  1.0));
                end
                else begin
                  __NQS_temp = (((((- __NQS_xbar) -  230.258509299405) * (((((- __NQS_xbar) -  230.258509299405) * ((((- __NQS_xbar) -  230.258509299405) *  0.333333333333333) +  1.0)) *  0.5) +  1.0)) +  1.0) *  10.0e+99);
                end
              end
              __NQS_w = ( 1.0 - __NQS_temp);
              __NQS_x0 = ((temp + (__Gp2 *  0.5)) - (__Gp * sqrt(((temp + (__Gp2 *  0.25)) - __NQS_w))));
              if ((abs((- __NQS_x0)) <  230.258509299405)) begin
                __NQS_D0 = exp((- __NQS_x0));
              end
              else begin
                if (((- __NQS_x0) <  0.0)) begin
                  __NQS_D0 = ( 100.0e-102 / (((-230.258509299405 - (- __NQS_x0)) * ((((-230.258509299405 - (- __NQS_x0)) * (((-230.258509299405 - (- __NQS_x0)) *  0.333333333333333) +  1.0)) *  0.5) +  1.0)) +  1.0));
                end
                else begin
                  __NQS_D0 = (((((- __NQS_x0) -  230.258509299405) * (((((- __NQS_x0) -  230.258509299405) * ((((- __NQS_x0) -  230.258509299405) *  0.333333333333333) +  1.0)) *  0.5) +  1.0)) +  1.0) *  10.0e+99);
                end
              end
              __NQS_xi = ( 1.0 - ((__Gp2 *  0.5) * __NQS_D0));
              __NQS_p = (((temp - __NQS_x0) *  2.0) + (__Gp2 * ( 1.0 - __NQS_D0)));
              __NQS_q = (((temp - __NQS_x0) * (temp - __NQS_x0)) - (__Gp2 * ((__NQS_x0 -  1.0) + __NQS_D0)));
              __NQS_temp = ((__NQS_p * __NQS_p) - ((__NQS_xi *  4.0) * __NQS_q));
              __NQS_u = ((__NQS_q *  2.0) / (__NQS_p + sqrt(__NQS_temp)));
              __xphi = (__NQS_x0 + __NQS_u);
            end
          end
          if ((abs(__xphi) <= __margin_ac)) begin
            __Qb_tmp = (((__xphi * -0.70710678) * __Gf_ac) * ( 1.0 - ((__xphi *  0.166666666666667) * ( 1.0 - (__xphi *  0.166666666666667)))));
            __dQbs = ((__Gf_ac * -0.70710678) * ( 1.0 - ((__xphi *  0.333333333333333) * ( 1.0 - (__xphi *  0.25)))));
            __d2Qis = ((__Gf_ac * -0.235702) * ( 1.0 - (__xphi *  0.5)));
          end
          else begin
            if ((abs((- __xphi)) <  230.258509299405)) begin
              temp = exp((- __xphi));
            end
            else begin
              if (((- __xphi) <  0.0)) begin
                temp = ( 100.0e-102 / (((-230.258509299405 - (- __xphi)) * ((((-230.258509299405 - (- __xphi)) * (((-230.258509299405 - (- __xphi)) *  0.333333333333333) +  1.0)) *  0.5) +  1.0)) +  1.0));
              end
              else begin
                temp = (((((- __xphi) -  230.258509299405) * (((((- __xphi) -  230.258509299405) * ((((- __xphi) -  230.258509299405) *  0.333333333333333) +  1.0)) *  0.5) +  1.0)) +  1.0) *  10.0e+99);
              end
            end
            __Qb_tmp = (__Gf_ac * sqrt(((temp + __xphi) -  1.0)));
            if ((__xphi > __margin_ac)) begin
              __Qb_tmp = (- __Qb_tmp);
            end
            __dQbs = ((((__Gf_ac *  0.5) * __Gf_ac) * ( 1.0 - temp)) / __Qb_tmp);
            __d2Qis = ((((__dQbs * __dQbs) - ((__Gf_ac *  0.5) * __Gf_ac)) / __Qb_tmp) + __dQbs);
          end
          __dQis = (__pd - __dQbs);
          __dQis_1 = ( 1.0 / __dQis);
          __fQi = ((__Qp3 * __dQis_1) -  1.0);
          __dfQi = (( 1.0 - (((__Qp3 * __d2Qis) * __dQis_1) * __dQis_1)) * __dQis_1);
          __fk0 = (((__dfQi * __dQy) * __dQy) + (__fQi * __d2Qy));
          __dpsy2 = (((__dQy * __dQy) * __dQis_1) * __dQis_1);
          __zsat_nqs = (__thesat2 * __dpsy2);
          if ((__CHNL_TYPE == -1)) begin
            __zsat_nqs = (__zsat_nqs / ((__thesat1_ac * __dps_ac) +  1.0));
          end
          temp = sqrt(((__zsat_nqs *  2.0) +  1.0));
          __Fvsat = ( 2.0 / (temp +  1.0));
          temp1 = (__d2Qy - (__dpsy2 * __d2Qis));
          __fk3 = (__Fvsat * (__fk0 - ((((__zsat_nqs * __fQi) * temp1) * __Fvsat) / temp)));
        end
        if ((__SWNQS_i >= 4)) begin
          if ((__SWNQS_i == 5)) begin
            __dQy = ((((((((__Qp3 * -630.0) + (__Qp4 *  12.0)) + (__Qp5 *  582.0)) - (__QpN *  97.0)) + (__Qp0 *  7.0)) - (__Qp1 *  42.0)) + (__Qp2 *  168.0)) /  130.0);
            __d2Qy = ((((((((__Qp4 * -10.152e+3) + (__Qp5 *  6.048e+3)) + (__Qp3 *  6.48e+3)) - (__QpN *  1.008e+3)) - (__Qp0 *  72.0)) + (__Qp1 *  432.0)) - (__Qp2 *  1.728e+3)) /  65.0);
          end
          else begin
            if ((__SWNQS_i == 9)) begin
              __dQy = ((((((((((((__Qp6 * -81.48e+3) - (__Qp4 *  30.0)) - (__Qp3 *  303.975e+3)) - (__Qp8 *  5.82e+3)) + (__Qp9 *  1.455e+3)) - (__Qp1 *  20.265e+3)) + (__Qp7 *  21.825e+3)) + (__Qp2 *  81.06e+3)) /  37.829e+3) - (__QpN *  0.00641042586375532)) + (__Qp5 *  8.03867403314917)) + (__Qp0 *  0.0892833540405509));
              __d2Qy = ((((((((((((__Qp1 *  702.0e+3) + (__Qp7 *  756.0e+3)) - (__Qp4 *  16.6146e+6)) + (__Qp3 *  10.53e+6)) - (__Qp2 *  2.808e+6)) - (__Qp0 *  117.0e+3)) - (__QpN *  8.4e+3)) - (__Qp8 *  201.6e+3)) + (__Qp9 *  50.4e+3)) - (__Qp6 *  2.8224e+6)) /  37.829e+3) + (__Qp5 *  278.453038674033));
            end
            else begin
              __dQy =  0.0;
              __d2Qy =  0.0;
            end
          end
          temp = ((__Qp4 / __pd) + __xg_ac);
          if ((abs(temp) <= __marginp)) begin
            __xphi = (temp / __a_factrp);
          end
          else begin
            if ((temp < (- __marginp))) begin
              __NQS_yg = (- temp);
              __NQS_z = ((__NQS_yg *  1.25) / __a_factrp);
              __NQS_eta = (((__NQS_z +  10.0) - sqrt((((__NQS_z -  6.0) * (__NQS_z -  6.0)) +  64.0))) *  0.5);
              __NQS_a = (((__NQS_yg - __NQS_eta) * (__NQS_yg - __NQS_eta)) + (__Gp2 * (__NQS_eta +  1.0)));
              __NQS_c = (((__NQS_yg - __NQS_eta) *  2.0) - __Gp2);
              __NQS_tau = (ln((__NQS_a / __Gp2)) - __NQS_eta);
              __nu = (__NQS_a + __NQS_c);
              __mutau = ((__nu * __nu) + (__NQS_tau * (((__NQS_c * __NQS_c) *  0.5) - __NQS_a)));
              __NQS_y0 = (__NQS_eta + (((__NQS_a * __nu) * __NQS_tau) / (__mutau + (((((__nu / __mutau) * __NQS_tau) * __NQS_tau) * __NQS_c) * (((__NQS_c * __NQS_c) *  0.333333333333333) - __NQS_a)))));
              if ((abs(__NQS_y0) <  230.258509299405)) begin
                __NQS_D0 = exp(__NQS_y0);
              end
              else begin
                if ((__NQS_y0 <  0.0)) begin
                  __NQS_D0 = ( 100.0e-102 / (((-230.258509299405 - __NQS_y0) * ((((-230.258509299405 - __NQS_y0) * (((-230.258509299405 - __NQS_y0) *  0.333333333333333) +  1.0)) *  0.5) +  1.0)) +  1.0));
                end
                else begin
                  __NQS_D0 = ((((__NQS_y0 -  230.258509299405) * ((((__NQS_y0 -  230.258509299405) * (((__NQS_y0 -  230.258509299405) *  0.333333333333333) +  1.0)) *  0.5) +  1.0)) +  1.0) *  10.0e+99);
                end
              end
              __NQS_xi = ( 1.0 - ((__Gp2 * __NQS_D0) *  0.5));
              __NQS_p = (((__NQS_yg - __NQS_y0) *  2.0) + (__Gp2 * (__NQS_D0 -  1.0)));
              __NQS_q = (((__NQS_yg - __NQS_y0) * (__NQS_yg - __NQS_y0)) + (__Gp2 * ((__NQS_y0 +  1.0) - __NQS_D0)));
              __NQS_temp = ((__NQS_p * __NQS_p) - ((__NQS_xi *  4.0) * __NQS_q));
              __NQS_w = ((__NQS_q *  2.0) / (__NQS_p + sqrt(__NQS_temp)));
              __xphi = (- (__NQS_y0 + __NQS_w));
            end
            else begin
              __NQS_xg1 = ( 1.0 / ((__Gp *  0.732464877560822) +  1.25));
              __NQS_A_fac = ((((__a_factrp *  1.25) * __NQS_xg1) -  1.0) * __NQS_xg1);
              __NQS_xbar = ((temp / __a_factrp) * ((__NQS_A_fac * temp) +  1.0));
              if ((abs((- __NQS_xbar)) <  230.258509299405)) begin
                __NQS_temp = exp((- __NQS_xbar));
              end
              else begin
                if (((- __NQS_xbar) <  0.0)) begin
                  __NQS_temp = ( 100.0e-102 / (((-230.258509299405 - (- __NQS_xbar)) * ((((-230.258509299405 - (- __NQS_xbar)) * (((-230.258509299405 - (- __NQS_xbar)) *  0.333333333333333) +  1.0)) *  0.5) +  1.0)) +  1.0));
                end
                else begin
                  __NQS_temp = (((((- __NQS_xbar) -  230.258509299405) * (((((- __NQS_xbar) -  230.258509299405) * ((((- __NQS_xbar) -  230.258509299405) *  0.333333333333333) +  1.0)) *  0.5) +  1.0)) +  1.0) *  10.0e+99);
                end
              end
              __NQS_w = ( 1.0 - __NQS_temp);
              __NQS_x0 = ((temp + (__Gp2 *  0.5)) - (__Gp * sqrt(((temp + (__Gp2 *  0.25)) - __NQS_w))));
              if ((abs((- __NQS_x0)) <  230.258509299405)) begin
                __NQS_D0 = exp((- __NQS_x0));
              end
              else begin
                if (((- __NQS_x0) <  0.0)) begin
                  __NQS_D0 = ( 100.0e-102 / (((-230.258509299405 - (- __NQS_x0)) * ((((-230.258509299405 - (- __NQS_x0)) * (((-230.258509299405 - (- __NQS_x0)) *  0.333333333333333) +  1.0)) *  0.5) +  1.0)) +  1.0));
                end
                else begin
                  __NQS_D0 = (((((- __NQS_x0) -  230.258509299405) * (((((- __NQS_x0) -  230.258509299405) * ((((- __NQS_x0) -  230.258509299405) *  0.333333333333333) +  1.0)) *  0.5) +  1.0)) +  1.0) *  10.0e+99);
                end
              end
              __NQS_xi = ( 1.0 - ((__Gp2 *  0.5) * __NQS_D0));
              __NQS_p = (((temp - __NQS_x0) *  2.0) + (__Gp2 * ( 1.0 - __NQS_D0)));
              __NQS_q = (((temp - __NQS_x0) * (temp - __NQS_x0)) - (__Gp2 * ((__NQS_x0 -  1.0) + __NQS_D0)));
              __NQS_temp = ((__NQS_p * __NQS_p) - ((__NQS_xi *  4.0) * __NQS_q));
              __NQS_u = ((__NQS_q *  2.0) / (__NQS_p + sqrt(__NQS_temp)));
              __xphi = (__NQS_x0 + __NQS_u);
            end
          end
          if ((abs(__xphi) <= __margin_ac)) begin
            __Qb_tmp = (((__xphi * -0.70710678) * __Gf_ac) * ( 1.0 - ((__xphi *  0.166666666666667) * ( 1.0 - (__xphi *  0.166666666666667)))));
            __dQbs = ((__Gf_ac * -0.70710678) * ( 1.0 - ((__xphi *  0.333333333333333) * ( 1.0 - (__xphi *  0.25)))));
            __d2Qis = ((__Gf_ac * -0.235702) * ( 1.0 - (__xphi *  0.5)));
          end
          else begin
            if ((abs((- __xphi)) <  230.258509299405)) begin
              temp = exp((- __xphi));
            end
            else begin
              if (((- __xphi) <  0.0)) begin
                temp = ( 100.0e-102 / (((-230.258509299405 - (- __xphi)) * ((((-230.258509299405 - (- __xphi)) * (((-230.258509299405 - (- __xphi)) *  0.333333333333333) +  1.0)) *  0.5) +  1.0)) +  1.0));
              end
              else begin
                temp = (((((- __xphi) -  230.258509299405) * (((((- __xphi) -  230.258509299405) * ((((- __xphi) -  230.258509299405) *  0.333333333333333) +  1.0)) *  0.5) +  1.0)) +  1.0) *  10.0e+99);
              end
            end
            __Qb_tmp = (__Gf_ac * sqrt(((temp + __xphi) -  1.0)));
            if ((__xphi > __margin_ac)) begin
              __Qb_tmp = (- __Qb_tmp);
            end
            __dQbs = ((((__Gf_ac *  0.5) * __Gf_ac) * ( 1.0 - temp)) / __Qb_tmp);
            __d2Qis = ((((__dQbs * __dQbs) - ((__Gf_ac *  0.5) * __Gf_ac)) / __Qb_tmp) + __dQbs);
          end
          __dQis = (__pd - __dQbs);
          __dQis_1 = ( 1.0 / __dQis);
          __fQi = ((__Qp4 * __dQis_1) -  1.0);
          __dfQi = (( 1.0 - (((__Qp4 * __d2Qis) * __dQis_1) * __dQis_1)) * __dQis_1);
          __fk0 = (((__dfQi * __dQy) * __dQy) + (__fQi * __d2Qy));
          __dpsy2 = (((__dQy * __dQy) * __dQis_1) * __dQis_1);
          __zsat_nqs = (__thesat2 * __dpsy2);
          if ((__CHNL_TYPE == -1)) begin
            __zsat_nqs = (__zsat_nqs / ((__thesat1_ac * __dps_ac) +  1.0));
          end
          temp = sqrt(((__zsat_nqs *  2.0) +  1.0));
          __Fvsat = ( 2.0 / (temp +  1.0));
          temp1 = (__d2Qy - (__dpsy2 * __d2Qis));
          __fk4 = (__Fvsat * (__fk0 - ((((__zsat_nqs * __fQi) * temp1) * __Fvsat) / temp)));
        end
        if ((__SWNQS_i >= 5)) begin
          if ((__SWNQS_i == 5)) begin
            __dQy = ((((((((__Qp4 * -336.0) + (__Qp5 *  84.0)) + (__Qp3 *  90.0)) + (__QpN *  181.0)) - __Qp0) + (__Qp1 *  6.0)) - (__Qp2 *  24.0)) /  65.0);
            __d2Qy = ((((((((__Qp0 *  18.0) + (__QpN *  3.762e+3)) + (__Qp4 *  6.048e+3)) + (__Qp2 *  432.0)) - (__Qp3 *  1.62e+3)) - (__Qp1 *  108.0)) - (__Qp5 *  8.532e+3)) /  65.0);
          end
          else begin
            if ((__SWNQS_i == 9)) begin
              __dQy = (((((((__Qp6 - __Qp4) *  1.68e+3) + ((__QpN - __Qp0) *  5.0)) + ((__Qp3 - __Qp7) *  450.0)) + ((__Qp8 - __Qp2) *  120.0)) - ((__Qp9 - __Qp1) *  30.0)) /  209.0);
              __d2Qy = ((((((((__Qp1 + __Qp9) * -900.0) - ((__Qp7 + __Qp3) *  13.5e+3)) - (__Qp5 *  79.5e+3)) + ((__Qp4 + __Qp6) *  50.4e+3)) + ((__Qp2 + __Qp8) *  3.6e+3)) + ((__Qp0 + __QpN) *  150.0)) /  181.0);
            end
            else begin
              __dQy =  0.0;
              __d2Qy =  0.0;
            end
          end
          temp = ((__Qp5 / __pd) + __xg_ac);
          if ((abs(temp) <= __marginp)) begin
            __xphi = (temp / __a_factrp);
          end
          else begin
            if ((temp < (- __marginp))) begin
              __NQS_yg = (- temp);
              __NQS_z = ((__NQS_yg *  1.25) / __a_factrp);
              __NQS_eta = (((__NQS_z +  10.0) - sqrt((((__NQS_z -  6.0) * (__NQS_z -  6.0)) +  64.0))) *  0.5);
              __NQS_a = (((__NQS_yg - __NQS_eta) * (__NQS_yg - __NQS_eta)) + (__Gp2 * (__NQS_eta +  1.0)));
              __NQS_c = (((__NQS_yg - __NQS_eta) *  2.0) - __Gp2);
              __NQS_tau = (ln((__NQS_a / __Gp2)) - __NQS_eta);
              __nu = (__NQS_a + __NQS_c);
              __mutau = ((__nu * __nu) + (__NQS_tau * (((__NQS_c * __NQS_c) *  0.5) - __NQS_a)));
              __NQS_y0 = (__NQS_eta + (((__NQS_a * __nu) * __NQS_tau) / (__mutau + (((((__nu / __mutau) * __NQS_tau) * __NQS_tau) * __NQS_c) * (((__NQS_c * __NQS_c) *  0.333333333333333) - __NQS_a)))));
              if ((abs(__NQS_y0) <  230.258509299405)) begin
                __NQS_D0 = exp(__NQS_y0);
              end
              else begin
                if ((__NQS_y0 <  0.0)) begin
                  __NQS_D0 = ( 100.0e-102 / (((-230.258509299405 - __NQS_y0) * ((((-230.258509299405 - __NQS_y0) * (((-230.258509299405 - __NQS_y0) *  0.333333333333333) +  1.0)) *  0.5) +  1.0)) +  1.0));
                end
                else begin
                  __NQS_D0 = ((((__NQS_y0 -  230.258509299405) * ((((__NQS_y0 -  230.258509299405) * (((__NQS_y0 -  230.258509299405) *  0.333333333333333) +  1.0)) *  0.5) +  1.0)) +  1.0) *  10.0e+99);
                end
              end
              __NQS_xi = ( 1.0 - ((__Gp2 * __NQS_D0) *  0.5));
              __NQS_p = (((__NQS_yg - __NQS_y0) *  2.0) + (__Gp2 * (__NQS_D0 -  1.0)));
              __NQS_q = (((__NQS_yg - __NQS_y0) * (__NQS_yg - __NQS_y0)) + (__Gp2 * ((__NQS_y0 +  1.0) - __NQS_D0)));
              __NQS_temp = ((__NQS_p * __NQS_p) - ((__NQS_xi *  4.0) * __NQS_q));
              __NQS_w = ((__NQS_q *  2.0) / (__NQS_p + sqrt(__NQS_temp)));
              __xphi = (- (__NQS_y0 + __NQS_w));
            end
            else begin
              __NQS_xg1 = ( 1.0 / ((__Gp *  0.732464877560822) +  1.25));
              __NQS_A_fac = ((((__a_factrp *  1.25) * __NQS_xg1) -  1.0) * __NQS_xg1);
              __NQS_xbar = ((temp / __a_factrp) * ((__NQS_A_fac * temp) +  1.0));
              if ((abs((- __NQS_xbar)) <  230.258509299405)) begin
                __NQS_temp = exp((- __NQS_xbar));
              end
              else begin
                if (((- __NQS_xbar) <  0.0)) begin
                  __NQS_temp = ( 100.0e-102 / (((-230.258509299405 - (- __NQS_xbar)) * ((((-230.258509299405 - (- __NQS_xbar)) * (((-230.258509299405 - (- __NQS_xbar)) *  0.333333333333333) +  1.0)) *  0.5) +  1.0)) +  1.0));
                end
                else begin
                  __NQS_temp = (((((- __NQS_xbar) -  230.258509299405) * (((((- __NQS_xbar) -  230.258509299405) * ((((- __NQS_xbar) -  230.258509299405) *  0.333333333333333) +  1.0)) *  0.5) +  1.0)) +  1.0) *  10.0e+99);
                end
              end
              __NQS_w = ( 1.0 - __NQS_temp);
              __NQS_x0 = ((temp + (__Gp2 *  0.5)) - (__Gp * sqrt(((temp + (__Gp2 *  0.25)) - __NQS_w))));
              if ((abs((- __NQS_x0)) <  230.258509299405)) begin
                __NQS_D0 = exp((- __NQS_x0));
              end
              else begin
                if (((- __NQS_x0) <  0.0)) begin
                  __NQS_D0 = ( 100.0e-102 / (((-230.258509299405 - (- __NQS_x0)) * ((((-230.258509299405 - (- __NQS_x0)) * (((-230.258509299405 - (- __NQS_x0)) *  0.333333333333333) +  1.0)) *  0.5) +  1.0)) +  1.0));
                end
                else begin
                  __NQS_D0 = (((((- __NQS_x0) -  230.258509299405) * (((((- __NQS_x0) -  230.258509299405) * ((((- __NQS_x0) -  230.258509299405) *  0.333333333333333) +  1.0)) *  0.5) +  1.0)) +  1.0) *  10.0e+99);
                end
              end
              __NQS_xi = ( 1.0 - ((__Gp2 *  0.5) * __NQS_D0));
              __NQS_p = (((temp - __NQS_x0) *  2.0) + (__Gp2 * ( 1.0 - __NQS_D0)));
              __NQS_q = (((temp - __NQS_x0) * (temp - __NQS_x0)) - (__Gp2 * ((__NQS_x0 -  1.0) + __NQS_D0)));
              __NQS_temp = ((__NQS_p * __NQS_p) - ((__NQS_xi *  4.0) * __NQS_q));
              __NQS_u = ((__NQS_q *  2.0) / (__NQS_p + sqrt(__NQS_temp)));
              __xphi = (__NQS_x0 + __NQS_u);
            end
          end
          if ((abs(__xphi) <= __margin_ac)) begin
            __Qb_tmp = (((__xphi * -0.70710678) * __Gf_ac) * ( 1.0 - ((__xphi *  0.166666666666667) * ( 1.0 - (__xphi *  0.166666666666667)))));
            __dQbs = ((__Gf_ac * -0.70710678) * ( 1.0 - ((__xphi *  0.333333333333333) * ( 1.0 - (__xphi *  0.25)))));
            __d2Qis = ((__Gf_ac * -0.235702) * ( 1.0 - (__xphi *  0.5)));
          end
          else begin
            if ((abs((- __xphi)) <  230.258509299405)) begin
              temp = exp((- __xphi));
            end
            else begin
              if (((- __xphi) <  0.0)) begin
                temp = ( 100.0e-102 / (((-230.258509299405 - (- __xphi)) * ((((-230.258509299405 - (- __xphi)) * (((-230.258509299405 - (- __xphi)) *  0.333333333333333) +  1.0)) *  0.5) +  1.0)) +  1.0));
              end
              else begin
                temp = (((((- __xphi) -  230.258509299405) * (((((- __xphi) -  230.258509299405) * ((((- __xphi) -  230.258509299405) *  0.333333333333333) +  1.0)) *  0.5) +  1.0)) +  1.0) *  10.0e+99);
              end
            end
            __Qb_tmp = (__Gf_ac * sqrt(((temp + __xphi) -  1.0)));
            if ((__xphi > __margin_ac)) begin
              __Qb_tmp = (- __Qb_tmp);
            end
            __dQbs = ((((__Gf_ac *  0.5) * __Gf_ac) * ( 1.0 - temp)) / __Qb_tmp);
            __d2Qis = ((((__dQbs * __dQbs) - ((__Gf_ac *  0.5) * __Gf_ac)) / __Qb_tmp) + __dQbs);
          end
          __dQis = (__pd - __dQbs);
          __dQis_1 = ( 1.0 / __dQis);
          __fQi = ((__Qp5 * __dQis_1) -  1.0);
          __dfQi = (( 1.0 - (((__Qp5 * __d2Qis) * __dQis_1) * __dQis_1)) * __dQis_1);
          __fk0 = (((__dfQi * __dQy) * __dQy) + (__fQi * __d2Qy));
          __dpsy2 = (((__dQy * __dQy) * __dQis_1) * __dQis_1);
          __zsat_nqs = (__thesat2 * __dpsy2);
          if ((__CHNL_TYPE == -1)) begin
            __zsat_nqs = (__zsat_nqs / ((__thesat1_ac * __dps_ac) +  1.0));
          end
          temp = sqrt(((__zsat_nqs *  2.0) +  1.0));
          __Fvsat = ( 2.0 / (temp +  1.0));
          temp1 = (__d2Qy - (__dpsy2 * __d2Qis));
          __fk5 = (__Fvsat * (__fk0 - ((((__zsat_nqs * __fQi) * temp1) * __Fvsat) / temp)));
        end
        if ((__SWNQS_i >= 6)) begin
          if ((__SWNQS_i == 9)) begin
            __dQy = (((((((((((__Qp6 *  30.0) + (__Qp4 *  81.48e+3)) - (__Qp3 *  21.825e+3)) - (__Qp8 *  81.06e+3)) + (__Qp9 *  20.265e+3)) - (__Qp1 *  1.455e+3)) + (__Qp7 *  303.975e+3)) + (__Qp2 *  5.82e+3)) /  37.829e+3) - (((__QpN *  6.755e+3) - (__Qp0 *  485.0)) /  75.658e+3)) - (__Qp5 *  8.03867403314917));
            __d2Qy = ((((((((((((__Qp1 *  50.4e+3) + (__Qp7 *  10.53e+6)) - (__Qp4 *  2.8224e+6)) + (__Qp3 *  756.0e+3)) - (__Qp2 *  201.6e+3)) - (__Qp0 *  8.4e+3)) - (__QpN *  117.0e+3)) - (__Qp8 *  2.808e+6)) + (__Qp9 *  702.0e+3)) - (__Qp6 *  16.6146e+6)) /  37.829e+3) + (__Qp5 *  278.453038674033));
          end
          else begin
            __dQy =  0.0;
            __d2Qy =  0.0;
          end
          temp = ((__Qp6 / __pd) + __xg_ac);
          if ((abs(temp) <= __marginp)) begin
            __xphi = (temp / __a_factrp);
          end
          else begin
            if ((temp < (- __marginp))) begin
              __NQS_yg = (- temp);
              __NQS_z = ((__NQS_yg *  1.25) / __a_factrp);
              __NQS_eta = (((__NQS_z +  10.0) - sqrt((((__NQS_z -  6.0) * (__NQS_z -  6.0)) +  64.0))) *  0.5);
              __NQS_a = (((__NQS_yg - __NQS_eta) * (__NQS_yg - __NQS_eta)) + (__Gp2 * (__NQS_eta +  1.0)));
              __NQS_c = (((__NQS_yg - __NQS_eta) *  2.0) - __Gp2);
              __NQS_tau = (ln((__NQS_a / __Gp2)) - __NQS_eta);
              __nu = (__NQS_a + __NQS_c);
              __mutau = ((__nu * __nu) + (__NQS_tau * (((__NQS_c * __NQS_c) *  0.5) - __NQS_a)));
              __NQS_y0 = (__NQS_eta + (((__NQS_a * __nu) * __NQS_tau) / (__mutau + (((((__nu / __mutau) * __NQS_tau) * __NQS_tau) * __NQS_c) * (((__NQS_c * __NQS_c) *  0.333333333333333) - __NQS_a)))));
              if ((abs(__NQS_y0) <  230.258509299405)) begin
                __NQS_D0 = exp(__NQS_y0);
              end
              else begin
                if ((__NQS_y0 <  0.0)) begin
                  __NQS_D0 = ( 100.0e-102 / (((-230.258509299405 - __NQS_y0) * ((((-230.258509299405 - __NQS_y0) * (((-230.258509299405 - __NQS_y0) *  0.333333333333333) +  1.0)) *  0.5) +  1.0)) +  1.0));
                end
                else begin
                  __NQS_D0 = ((((__NQS_y0 -  230.258509299405) * ((((__NQS_y0 -  230.258509299405) * (((__NQS_y0 -  230.258509299405) *  0.333333333333333) +  1.0)) *  0.5) +  1.0)) +  1.0) *  10.0e+99);
                end
              end
              __NQS_xi = ( 1.0 - ((__Gp2 * __NQS_D0) *  0.5));
              __NQS_p = (((__NQS_yg - __NQS_y0) *  2.0) + (__Gp2 * (__NQS_D0 -  1.0)));
              __NQS_q = (((__NQS_yg - __NQS_y0) * (__NQS_yg - __NQS_y0)) + (__Gp2 * ((__NQS_y0 +  1.0) - __NQS_D0)));
              __NQS_temp = ((__NQS_p * __NQS_p) - ((__NQS_xi *  4.0) * __NQS_q));
              __NQS_w = ((__NQS_q *  2.0) / (__NQS_p + sqrt(__NQS_temp)));
              __xphi = (- (__NQS_y0 + __NQS_w));
            end
            else begin
              __NQS_xg1 = ( 1.0 / ((__Gp *  0.732464877560822) +  1.25));
              __NQS_A_fac = ((((__a_factrp *  1.25) * __NQS_xg1) -  1.0) * __NQS_xg1);
              __NQS_xbar = ((temp / __a_factrp) * ((__NQS_A_fac * temp) +  1.0));
              if ((abs((- __NQS_xbar)) <  230.258509299405)) begin
                __NQS_temp = exp((- __NQS_xbar));
              end
              else begin
                if (((- __NQS_xbar) <  0.0)) begin
                  __NQS_temp = ( 100.0e-102 / (((-230.258509299405 - (- __NQS_xbar)) * ((((-230.258509299405 - (- __NQS_xbar)) * (((-230.258509299405 - (- __NQS_xbar)) *  0.333333333333333) +  1.0)) *  0.5) +  1.0)) +  1.0));
                end
                else begin
                  __NQS_temp = (((((- __NQS_xbar) -  230.258509299405) * (((((- __NQS_xbar) -  230.258509299405) * ((((- __NQS_xbar) -  230.258509299405) *  0.333333333333333) +  1.0)) *  0.5) +  1.0)) +  1.0) *  10.0e+99);
                end
              end
              __NQS_w = ( 1.0 - __NQS_temp);
              __NQS_x0 = ((temp + (__Gp2 *  0.5)) - (__Gp * sqrt(((temp + (__Gp2 *  0.25)) - __NQS_w))));
              if ((abs((- __NQS_x0)) <  230.258509299405)) begin
                __NQS_D0 = exp((- __NQS_x0));
              end
              else begin
                if (((- __NQS_x0) <  0.0)) begin
                  __NQS_D0 = ( 100.0e-102 / (((-230.258509299405 - (- __NQS_x0)) * ((((-230.258509299405 - (- __NQS_x0)) * (((-230.258509299405 - (- __NQS_x0)) *  0.333333333333333) +  1.0)) *  0.5) +  1.0)) +  1.0));
                end
                else begin
                  __NQS_D0 = (((((- __NQS_x0) -  230.258509299405) * (((((- __NQS_x0) -  230.258509299405) * ((((- __NQS_x0) -  230.258509299405) *  0.333333333333333) +  1.0)) *  0.5) +  1.0)) +  1.0) *  10.0e+99);
                end
              end
              __NQS_xi = ( 1.0 - ((__Gp2 *  0.5) * __NQS_D0));
              __NQS_p = (((temp - __NQS_x0) *  2.0) + (__Gp2 * ( 1.0 - __NQS_D0)));
              __NQS_q = (((temp - __NQS_x0) * (temp - __NQS_x0)) - (__Gp2 * ((__NQS_x0 -  1.0) + __NQS_D0)));
              __NQS_temp = ((__NQS_p * __NQS_p) - ((__NQS_xi *  4.0) * __NQS_q));
              __NQS_u = ((__NQS_q *  2.0) / (__NQS_p + sqrt(__NQS_temp)));
              __xphi = (__NQS_x0 + __NQS_u);
            end
          end
          if ((abs(__xphi) <= __margin_ac)) begin
            __Qb_tmp = (((__xphi * -0.70710678) * __Gf_ac) * ( 1.0 - ((__xphi *  0.166666666666667) * ( 1.0 - (__xphi *  0.166666666666667)))));
            __dQbs = ((__Gf_ac * -0.70710678) * ( 1.0 - ((__xphi *  0.333333333333333) * ( 1.0 - (__xphi *  0.25)))));
            __d2Qis = ((__Gf_ac * -0.235702) * ( 1.0 - (__xphi *  0.5)));
          end
          else begin
            if ((abs((- __xphi)) <  230.258509299405)) begin
              temp = exp((- __xphi));
            end
            else begin
              if (((- __xphi) <  0.0)) begin
                temp = ( 100.0e-102 / (((-230.258509299405 - (- __xphi)) * ((((-230.258509299405 - (- __xphi)) * (((-230.258509299405 - (- __xphi)) *  0.333333333333333) +  1.0)) *  0.5) +  1.0)) +  1.0));
              end
              else begin
                temp = (((((- __xphi) -  230.258509299405) * (((((- __xphi) -  230.258509299405) * ((((- __xphi) -  230.258509299405) *  0.333333333333333) +  1.0)) *  0.5) +  1.0)) +  1.0) *  10.0e+99);
              end
            end
            __Qb_tmp = (__Gf_ac * sqrt(((temp + __xphi) -  1.0)));
            if ((__xphi > __margin_ac)) begin
              __Qb_tmp = (- __Qb_tmp);
            end
            __dQbs = ((((__Gf_ac *  0.5) * __Gf_ac) * ( 1.0 - temp)) / __Qb_tmp);
            __d2Qis = ((((__dQbs * __dQbs) - ((__Gf_ac *  0.5) * __Gf_ac)) / __Qb_tmp) + __dQbs);
          end
          __dQis = (__pd - __dQbs);
          __dQis_1 = ( 1.0 / __dQis);
          __fQi = ((__Qp6 * __dQis_1) -  1.0);
          __dfQi = (( 1.0 - (((__Qp6 * __d2Qis) * __dQis_1) * __dQis_1)) * __dQis_1);
          __fk0 = (((__dfQi * __dQy) * __dQy) + (__fQi * __d2Qy));
          __dpsy2 = (((__dQy * __dQy) * __dQis_1) * __dQis_1);
          __zsat_nqs = (__thesat2 * __dpsy2);
          if ((__CHNL_TYPE == -1)) begin
            __zsat_nqs = (__zsat_nqs / ((__thesat1_ac * __dps_ac) +  1.0));
          end
          temp = sqrt(((__zsat_nqs *  2.0) +  1.0));
          __Fvsat = ( 2.0 / (temp +  1.0));
          temp1 = (__d2Qy - (__dpsy2 * __d2Qis));
          __fk6 = (__Fvsat * (__fk0 - ((((__zsat_nqs * __fQi) * temp1) * __Fvsat) / temp)));
        end
        if ((__SWNQS_i >= 7)) begin
          if ((__SWNQS_i == 9)) begin
            __dQy = ((((((((((((__Qp6 * -304.2e+3) - (__Qp4 *  21.84e+3)) + (__QpN *  12.605e+3)) + (__Qp3 *  5.85e+3)) + (__Qp8 *  302.52e+3)) - (__Qp0 *  65.0)) - (__Qp9 *  75.63e+3)) + (__Qp1 *  390.0)) + (__Qp7 *  420.0)) - (__Qp2 *  1.56e+3)) /  37.829e+3) + (__Qp5 *  2.15469613259669));
            __d2Qy = ((((((((((((__Qp1 * -13.5e+3) - (__Qp7 *  16.6011e+6)) + (__Qp4 *  756.0e+3)) - (__Qp3 *  202.5e+3)) + (__Qp2 *  54.0e+3)) + (__Qp0 *  2.25e+3)) + (__QpN *  436.65e+3)) + (__Qp8 *  10.4796e+6)) - (__Qp9 *  2.6199e+6)) + (__Qp6 *  10.53e+6)) /  37.829e+3) - (__Qp5 *  74.585635359116));
          end
          else begin
            __dQy =  0.0;
            __d2Qy =  0.0;
          end
          temp = ((__Qp7 / __pd) + __xg_ac);
          if ((abs(temp) <= __marginp)) begin
            __xphi = (temp / __a_factrp);
          end
          else begin
            if ((temp < (- __marginp))) begin
              __NQS_yg = (- temp);
              __NQS_z = ((__NQS_yg *  1.25) / __a_factrp);
              __NQS_eta = (((__NQS_z +  10.0) - sqrt((((__NQS_z -  6.0) * (__NQS_z -  6.0)) +  64.0))) *  0.5);
              __NQS_a = (((__NQS_yg - __NQS_eta) * (__NQS_yg - __NQS_eta)) + (__Gp2 * (__NQS_eta +  1.0)));
              __NQS_c = (((__NQS_yg - __NQS_eta) *  2.0) - __Gp2);
              __NQS_tau = (ln((__NQS_a / __Gp2)) - __NQS_eta);
              __nu = (__NQS_a + __NQS_c);
              __mutau = ((__nu * __nu) + (__NQS_tau * (((__NQS_c * __NQS_c) *  0.5) - __NQS_a)));
              __NQS_y0 = (__NQS_eta + (((__NQS_a * __nu) * __NQS_tau) / (__mutau + (((((__nu / __mutau) * __NQS_tau) * __NQS_tau) * __NQS_c) * (((__NQS_c * __NQS_c) *  0.333333333333333) - __NQS_a)))));
              if ((abs(__NQS_y0) <  230.258509299405)) begin
                __NQS_D0 = exp(__NQS_y0);
              end
              else begin
                if ((__NQS_y0 <  0.0)) begin
                  __NQS_D0 = ( 100.0e-102 / (((-230.258509299405 - __NQS_y0) * ((((-230.258509299405 - __NQS_y0) * (((-230.258509299405 - __NQS_y0) *  0.333333333333333) +  1.0)) *  0.5) +  1.0)) +  1.0));
                end
                else begin
                  __NQS_D0 = ((((__NQS_y0 -  230.258509299405) * ((((__NQS_y0 -  230.258509299405) * (((__NQS_y0 -  230.258509299405) *  0.333333333333333) +  1.0)) *  0.5) +  1.0)) +  1.0) *  10.0e+99);
                end
              end
              __NQS_xi = ( 1.0 - ((__Gp2 * __NQS_D0) *  0.5));
              __NQS_p = (((__NQS_yg - __NQS_y0) *  2.0) + (__Gp2 * (__NQS_D0 -  1.0)));
              __NQS_q = (((__NQS_yg - __NQS_y0) * (__NQS_yg - __NQS_y0)) + (__Gp2 * ((__NQS_y0 +  1.0) - __NQS_D0)));
              __NQS_temp = ((__NQS_p * __NQS_p) - ((__NQS_xi *  4.0) * __NQS_q));
              __NQS_w = ((__NQS_q *  2.0) / (__NQS_p + sqrt(__NQS_temp)));
              __xphi = (- (__NQS_y0 + __NQS_w));
            end
            else begin
              __NQS_xg1 = ( 1.0 / ((__Gp *  0.732464877560822) +  1.25));
              __NQS_A_fac = ((((__a_factrp *  1.25) * __NQS_xg1) -  1.0) * __NQS_xg1);
              __NQS_xbar = ((temp / __a_factrp) * ((__NQS_A_fac * temp) +  1.0));
              if ((abs((- __NQS_xbar)) <  230.258509299405)) begin
                __NQS_temp = exp((- __NQS_xbar));
              end
              else begin
                if (((- __NQS_xbar) <  0.0)) begin
                  __NQS_temp = ( 100.0e-102 / (((-230.258509299405 - (- __NQS_xbar)) * ((((-230.258509299405 - (- __NQS_xbar)) * (((-230.258509299405 - (- __NQS_xbar)) *  0.333333333333333) +  1.0)) *  0.5) +  1.0)) +  1.0));
                end
                else begin
                  __NQS_temp = (((((- __NQS_xbar) -  230.258509299405) * (((((- __NQS_xbar) -  230.258509299405) * ((((- __NQS_xbar) -  230.258509299405) *  0.333333333333333) +  1.0)) *  0.5) +  1.0)) +  1.0) *  10.0e+99);
                end
              end
              __NQS_w = ( 1.0 - __NQS_temp);
              __NQS_x0 = ((temp + (__Gp2 *  0.5)) - (__Gp * sqrt(((temp + (__Gp2 *  0.25)) - __NQS_w))));
              if ((abs((- __NQS_x0)) <  230.258509299405)) begin
                __NQS_D0 = exp((- __NQS_x0));
              end
              else begin
                if (((- __NQS_x0) <  0.0)) begin
                  __NQS_D0 = ( 100.0e-102 / (((-230.258509299405 - (- __NQS_x0)) * ((((-230.258509299405 - (- __NQS_x0)) * (((-230.258509299405 - (- __NQS_x0)) *  0.333333333333333) +  1.0)) *  0.5) +  1.0)) +  1.0));
                end
                else begin
                  __NQS_D0 = (((((- __NQS_x0) -  230.258509299405) * (((((- __NQS_x0) -  230.258509299405) * ((((- __NQS_x0) -  230.258509299405) *  0.333333333333333) +  1.0)) *  0.5) +  1.0)) +  1.0) *  10.0e+99);
                end
              end
              __NQS_xi = ( 1.0 - ((__Gp2 *  0.5) * __NQS_D0));
              __NQS_p = (((temp - __NQS_x0) *  2.0) + (__Gp2 * ( 1.0 - __NQS_D0)));
              __NQS_q = (((temp - __NQS_x0) * (temp - __NQS_x0)) - (__Gp2 * ((__NQS_x0 -  1.0) + __NQS_D0)));
              __NQS_temp = ((__NQS_p * __NQS_p) - ((__NQS_xi *  4.0) * __NQS_q));
              __NQS_u = ((__NQS_q *  2.0) / (__NQS_p + sqrt(__NQS_temp)));
              __xphi = (__NQS_x0 + __NQS_u);
            end
          end
          if ((abs(__xphi) <= __margin_ac)) begin
            __Qb_tmp = (((__xphi * -0.70710678) * __Gf_ac) * ( 1.0 - ((__xphi *  0.166666666666667) * ( 1.0 - (__xphi *  0.166666666666667)))));
            __dQbs = ((__Gf_ac * -0.70710678) * ( 1.0 - ((__xphi *  0.333333333333333) * ( 1.0 - (__xphi *  0.25)))));
            __d2Qis = ((__Gf_ac * -0.235702) * ( 1.0 - (__xphi *  0.5)));
          end
          else begin
            if ((abs((- __xphi)) <  230.258509299405)) begin
              temp = exp((- __xphi));
            end
            else begin
              if (((- __xphi) <  0.0)) begin
                temp = ( 100.0e-102 / (((-230.258509299405 - (- __xphi)) * ((((-230.258509299405 - (- __xphi)) * (((-230.258509299405 - (- __xphi)) *  0.333333333333333) +  1.0)) *  0.5) +  1.0)) +  1.0));
              end
              else begin
                temp = (((((- __xphi) -  230.258509299405) * (((((- __xphi) -  230.258509299405) * ((((- __xphi) -  230.258509299405) *  0.333333333333333) +  1.0)) *  0.5) +  1.0)) +  1.0) *  10.0e+99);
              end
            end
            __Qb_tmp = (__Gf_ac * sqrt(((temp + __xphi) -  1.0)));
            if ((__xphi > __margin_ac)) begin
              __Qb_tmp = (- __Qb_tmp);
            end
            __dQbs = ((((__Gf_ac *  0.5) * __Gf_ac) * ( 1.0 - temp)) / __Qb_tmp);
            __d2Qis = ((((__dQbs * __dQbs) - ((__Gf_ac *  0.5) * __Gf_ac)) / __Qb_tmp) + __dQbs);
          end
          __dQis = (__pd - __dQbs);
          __dQis_1 = ( 1.0 / __dQis);
          __fQi = ((__Qp7 * __dQis_1) -  1.0);
          __dfQi = (( 1.0 - (((__Qp7 * __d2Qis) * __dQis_1) * __dQis_1)) * __dQis_1);
          __fk0 = (((__dfQi * __dQy) * __dQy) + (__fQi * __d2Qy));
          __dpsy2 = (((__dQy * __dQy) * __dQis_1) * __dQis_1);
          __zsat_nqs = (__thesat2 * __dpsy2);
          if ((__CHNL_TYPE == -1)) begin
            __zsat_nqs = (__zsat_nqs / ((__thesat1_ac * __dps_ac) +  1.0));
          end
          temp = sqrt(((__zsat_nqs *  2.0) +  1.0));
          __Fvsat = ( 2.0 / (temp +  1.0));
          temp1 = (__d2Qy - (__dpsy2 * __d2Qis));
          __fk7 = (__Fvsat * (__fk0 - ((((__zsat_nqs * __fQi) * temp1) * __Fvsat) / temp)));
        end
        if ((__SWNQS_i >= 8)) begin
          if ((__SWNQS_i == 9)) begin
            __dQy = (((((((((((__Qp6 *  81.9e+3) + (__Qp4 *  5.88e+3)) - (__Qp3 *  1.575e+3)) + (__Qp8 *  5.85e+3)) + (__Qp9 *  282.255e+3)) - (__Qp1 *  105.0)) - (__Qp7 *  305.655e+3)) + (__Qp2 *  420.0)) /  37.829e+3) + (((__Qp0 *  35.0) - (__QpN *  94.085e+3)) /  75.658e+3)) - (__Qp5 *  0.580110497237569));
            __d2Qy = ((((((((((((__Qp1 *  3.6e+3) + (__Qp7 *  10.4796e+6)) - (__Qp4 *  201.6e+3)) + (__Qp3 *  54.0e+3)) - (__Qp2 *  14.4e+3)) - (__Qp0 *  600.0)) - (__QpN *  1.6296e+6)) - (__Qp8 *  16.413e+6)) + (__Qp9 *  9.7776e+6)) - (__Qp6 *  2.808e+6)) /  37.829e+3) + (__Qp5 *  19.8895027624309));
          end
          else begin
            __dQy =  0.0;
            __d2Qy =  0.0;
          end
          temp = ((__Qp8 / __pd) + __xg_ac);
          if ((abs(temp) <= __marginp)) begin
            __xphi = (temp / __a_factrp);
          end
          else begin
            if ((temp < (- __marginp))) begin
              __NQS_yg = (- temp);
              __NQS_z = ((__NQS_yg *  1.25) / __a_factrp);
              __NQS_eta = (((__NQS_z +  10.0) - sqrt((((__NQS_z -  6.0) * (__NQS_z -  6.0)) +  64.0))) *  0.5);
              __NQS_a = (((__NQS_yg - __NQS_eta) * (__NQS_yg - __NQS_eta)) + (__Gp2 * (__NQS_eta +  1.0)));
              __NQS_c = (((__NQS_yg - __NQS_eta) *  2.0) - __Gp2);
              __NQS_tau = (ln((__NQS_a / __Gp2)) - __NQS_eta);
              __nu = (__NQS_a + __NQS_c);
              __mutau = ((__nu * __nu) + (__NQS_tau * (((__NQS_c * __NQS_c) *  0.5) - __NQS_a)));
              __NQS_y0 = (__NQS_eta + (((__NQS_a * __nu) * __NQS_tau) / (__mutau + (((((__nu / __mutau) * __NQS_tau) * __NQS_tau) * __NQS_c) * (((__NQS_c * __NQS_c) *  0.333333333333333) - __NQS_a)))));
              if ((abs(__NQS_y0) <  230.258509299405)) begin
                __NQS_D0 = exp(__NQS_y0);
              end
              else begin
                if ((__NQS_y0 <  0.0)) begin
                  __NQS_D0 = ( 100.0e-102 / (((-230.258509299405 - __NQS_y0) * ((((-230.258509299405 - __NQS_y0) * (((-230.258509299405 - __NQS_y0) *  0.333333333333333) +  1.0)) *  0.5) +  1.0)) +  1.0));
                end
                else begin
                  __NQS_D0 = ((((__NQS_y0 -  230.258509299405) * ((((__NQS_y0 -  230.258509299405) * (((__NQS_y0 -  230.258509299405) *  0.333333333333333) +  1.0)) *  0.5) +  1.0)) +  1.0) *  10.0e+99);
                end
              end
              __NQS_xi = ( 1.0 - ((__Gp2 * __NQS_D0) *  0.5));
              __NQS_p = (((__NQS_yg - __NQS_y0) *  2.0) + (__Gp2 * (__NQS_D0 -  1.0)));
              __NQS_q = (((__NQS_yg - __NQS_y0) * (__NQS_yg - __NQS_y0)) + (__Gp2 * ((__NQS_y0 +  1.0) - __NQS_D0)));
              __NQS_temp = ((__NQS_p * __NQS_p) - ((__NQS_xi *  4.0) * __NQS_q));
              __NQS_w = ((__NQS_q *  2.0) / (__NQS_p + sqrt(__NQS_temp)));
              __xphi = (- (__NQS_y0 + __NQS_w));
            end
            else begin
              __NQS_xg1 = ( 1.0 / ((__Gp *  0.732464877560822) +  1.25));
              __NQS_A_fac = ((((__a_factrp *  1.25) * __NQS_xg1) -  1.0) * __NQS_xg1);
              __NQS_xbar = ((temp / __a_factrp) * ((__NQS_A_fac * temp) +  1.0));
              if ((abs((- __NQS_xbar)) <  230.258509299405)) begin
                __NQS_temp = exp((- __NQS_xbar));
              end
              else begin
                if (((- __NQS_xbar) <  0.0)) begin
                  __NQS_temp = ( 100.0e-102 / (((-230.258509299405 - (- __NQS_xbar)) * ((((-230.258509299405 - (- __NQS_xbar)) * (((-230.258509299405 - (- __NQS_xbar)) *  0.333333333333333) +  1.0)) *  0.5) +  1.0)) +  1.0));
                end
                else begin
                  __NQS_temp = (((((- __NQS_xbar) -  230.258509299405) * (((((- __NQS_xbar) -  230.258509299405) * ((((- __NQS_xbar) -  230.258509299405) *  0.333333333333333) +  1.0)) *  0.5) +  1.0)) +  1.0) *  10.0e+99);
                end
              end
              __NQS_w = ( 1.0 - __NQS_temp);
              __NQS_x0 = ((temp + (__Gp2 *  0.5)) - (__Gp * sqrt(((temp + (__Gp2 *  0.25)) - __NQS_w))));
              if ((abs((- __NQS_x0)) <  230.258509299405)) begin
                __NQS_D0 = exp((- __NQS_x0));
              end
              else begin
                if (((- __NQS_x0) <  0.0)) begin
                  __NQS_D0 = ( 100.0e-102 / (((-230.258509299405 - (- __NQS_x0)) * ((((-230.258509299405 - (- __NQS_x0)) * (((-230.258509299405 - (- __NQS_x0)) *  0.333333333333333) +  1.0)) *  0.5) +  1.0)) +  1.0));
                end
                else begin
                  __NQS_D0 = (((((- __NQS_x0) -  230.258509299405) * (((((- __NQS_x0) -  230.258509299405) * ((((- __NQS_x0) -  230.258509299405) *  0.333333333333333) +  1.0)) *  0.5) +  1.0)) +  1.0) *  10.0e+99);
                end
              end
              __NQS_xi = ( 1.0 - ((__Gp2 *  0.5) * __NQS_D0));
              __NQS_p = (((temp - __NQS_x0) *  2.0) + (__Gp2 * ( 1.0 - __NQS_D0)));
              __NQS_q = (((temp - __NQS_x0) * (temp - __NQS_x0)) - (__Gp2 * ((__NQS_x0 -  1.0) + __NQS_D0)));
              __NQS_temp = ((__NQS_p * __NQS_p) - ((__NQS_xi *  4.0) * __NQS_q));
              __NQS_u = ((__NQS_q *  2.0) / (__NQS_p + sqrt(__NQS_temp)));
              __xphi = (__NQS_x0 + __NQS_u);
            end
          end
          if ((abs(__xphi) <= __margin_ac)) begin
            __Qb_tmp = (((__xphi * -0.70710678) * __Gf_ac) * ( 1.0 - ((__xphi *  0.166666666666667) * ( 1.0 - (__xphi *  0.166666666666667)))));
            __dQbs = ((__Gf_ac * -0.70710678) * ( 1.0 - ((__xphi *  0.333333333333333) * ( 1.0 - (__xphi *  0.25)))));
            __d2Qis = ((__Gf_ac * -0.235702) * ( 1.0 - (__xphi *  0.5)));
          end
          else begin
            if ((abs((- __xphi)) <  230.258509299405)) begin
              temp = exp((- __xphi));
            end
            else begin
              if (((- __xphi) <  0.0)) begin
                temp = ( 100.0e-102 / (((-230.258509299405 - (- __xphi)) * ((((-230.258509299405 - (- __xphi)) * (((-230.258509299405 - (- __xphi)) *  0.333333333333333) +  1.0)) *  0.5) +  1.0)) +  1.0));
              end
              else begin
                temp = (((((- __xphi) -  230.258509299405) * (((((- __xphi) -  230.258509299405) * ((((- __xphi) -  230.258509299405) *  0.333333333333333) +  1.0)) *  0.5) +  1.0)) +  1.0) *  10.0e+99);
              end
            end
            __Qb_tmp = (__Gf_ac * sqrt(((temp + __xphi) -  1.0)));
            if ((__xphi > __margin_ac)) begin
              __Qb_tmp = (- __Qb_tmp);
            end
            __dQbs = ((((__Gf_ac *  0.5) * __Gf_ac) * ( 1.0 - temp)) / __Qb_tmp);
            __d2Qis = ((((__dQbs * __dQbs) - ((__Gf_ac *  0.5) * __Gf_ac)) / __Qb_tmp) + __dQbs);
          end
          __dQis = (__pd - __dQbs);
          __dQis_1 = ( 1.0 / __dQis);
          __fQi = ((__Qp8 * __dQis_1) -  1.0);
          __dfQi = (( 1.0 - (((__Qp8 * __d2Qis) * __dQis_1) * __dQis_1)) * __dQis_1);
          __fk0 = (((__dfQi * __dQy) * __dQy) + (__fQi * __d2Qy));
          __dpsy2 = (((__dQy * __dQy) * __dQis_1) * __dQis_1);
          __zsat_nqs = (__thesat2 * __dpsy2);
          if ((__CHNL_TYPE == -1)) begin
            __zsat_nqs = (__zsat_nqs / ((__thesat1_ac * __dps_ac) +  1.0));
          end
          temp = sqrt(((__zsat_nqs *  2.0) +  1.0));
          __Fvsat = ( 2.0 / (temp +  1.0));
          temp1 = (__d2Qy - (__dpsy2 * __d2Qis));
          __fk8 = (__Fvsat * (__fk0 - ((((__zsat_nqs * __fQi) * temp1) * __Fvsat) / temp)));
        end
        if ((__SWNQS_i >= 9)) begin
          if ((__SWNQS_i == 9)) begin
            __dQy = ((((((((((((__Qp6 * -23.4e+3) - (__Qp4 *  1.68e+3)) + (__QpN *  175.565e+3)) + (__Qp3 *  450.0)) - (__Qp8 *  325.92e+3)) - (__Qp0 *  5.0)) + (__Qp9 *  81.48e+3)) + (__Qp1 *  30.0)) + (__Qp7 *  87.33e+3)) - (__Qp2 *  120.0)) /  37.829e+3) + (__Qp5 *  0.165745856353591));
            __d2Qy = ((((((((((((__Qp1 * -900.0) - (__Qp7 *  2.6199e+6)) + (__Qp4 *  50.4e+3)) - (__Qp3 *  13.5e+3)) + (__Qp2 *  3.6e+3)) + (__Qp0 *  150.0)) + (__QpN *  6.08175e+6)) + (__Qp8 *  9.7776e+6)) - (__Qp9 *  13.7931e+6)) + (__Qp6 *  702.0e+3)) /  37.829e+3) - (__Qp5 *  4.97237569060773));
          end
          else begin
            __dQy =  0.0;
            __d2Qy =  0.0;
          end
          temp = ((__Qp9 / __pd) + __xg_ac);
          if ((abs(temp) <= __marginp)) begin
            __xphi = (temp / __a_factrp);
          end
          else begin
            if ((temp < (- __marginp))) begin
              __NQS_yg = (- temp);
              __NQS_z = ((__NQS_yg *  1.25) / __a_factrp);
              __NQS_eta = (((__NQS_z +  10.0) - sqrt((((__NQS_z -  6.0) * (__NQS_z -  6.0)) +  64.0))) *  0.5);
              __NQS_a = (((__NQS_yg - __NQS_eta) * (__NQS_yg - __NQS_eta)) + (__Gp2 * (__NQS_eta +  1.0)));
              __NQS_c = (((__NQS_yg - __NQS_eta) *  2.0) - __Gp2);
              __NQS_tau = (ln((__NQS_a / __Gp2)) - __NQS_eta);
              __nu = (__NQS_a + __NQS_c);
              __mutau = ((__nu * __nu) + (__NQS_tau * (((__NQS_c * __NQS_c) *  0.5) - __NQS_a)));
              __NQS_y0 = (__NQS_eta + (((__NQS_a * __nu) * __NQS_tau) / (__mutau + (((((__nu / __mutau) * __NQS_tau) * __NQS_tau) * __NQS_c) * (((__NQS_c * __NQS_c) *  0.333333333333333) - __NQS_a)))));
              if ((abs(__NQS_y0) <  230.258509299405)) begin
                __NQS_D0 = exp(__NQS_y0);
              end
              else begin
                if ((__NQS_y0 <  0.0)) begin
                  __NQS_D0 = ( 100.0e-102 / (((-230.258509299405 - __NQS_y0) * ((((-230.258509299405 - __NQS_y0) * (((-230.258509299405 - __NQS_y0) *  0.333333333333333) +  1.0)) *  0.5) +  1.0)) +  1.0));
                end
                else begin
                  __NQS_D0 = ((((__NQS_y0 -  230.258509299405) * ((((__NQS_y0 -  230.258509299405) * (((__NQS_y0 -  230.258509299405) *  0.333333333333333) +  1.0)) *  0.5) +  1.0)) +  1.0) *  10.0e+99);
                end
              end
              __NQS_xi = ( 1.0 - ((__Gp2 * __NQS_D0) *  0.5));
              __NQS_p = (((__NQS_yg - __NQS_y0) *  2.0) + (__Gp2 * (__NQS_D0 -  1.0)));
              __NQS_q = (((__NQS_yg - __NQS_y0) * (__NQS_yg - __NQS_y0)) + (__Gp2 * ((__NQS_y0 +  1.0) - __NQS_D0)));
              __NQS_temp = ((__NQS_p * __NQS_p) - ((__NQS_xi *  4.0) * __NQS_q));
              __NQS_w = ((__NQS_q *  2.0) / (__NQS_p + sqrt(__NQS_temp)));
              __xphi = (- (__NQS_y0 + __NQS_w));
            end
            else begin
              __NQS_xg1 = ( 1.0 / ((__Gp *  0.732464877560822) +  1.25));
              __NQS_A_fac = ((((__a_factrp *  1.25) * __NQS_xg1) -  1.0) * __NQS_xg1);
              __NQS_xbar = ((temp / __a_factrp) * ((__NQS_A_fac * temp) +  1.0));
              if ((abs((- __NQS_xbar)) <  230.258509299405)) begin
                __NQS_temp = exp((- __NQS_xbar));
              end
              else begin
                if (((- __NQS_xbar) <  0.0)) begin
                  __NQS_temp = ( 100.0e-102 / (((-230.258509299405 - (- __NQS_xbar)) * ((((-230.258509299405 - (- __NQS_xbar)) * (((-230.258509299405 - (- __NQS_xbar)) *  0.333333333333333) +  1.0)) *  0.5) +  1.0)) +  1.0));
                end
                else begin
                  __NQS_temp = (((((- __NQS_xbar) -  230.258509299405) * (((((- __NQS_xbar) -  230.258509299405) * ((((- __NQS_xbar) -  230.258509299405) *  0.333333333333333) +  1.0)) *  0.5) +  1.0)) +  1.0) *  10.0e+99);
                end
              end
              __NQS_w = ( 1.0 - __NQS_temp);
              __NQS_x0 = ((temp + (__Gp2 *  0.5)) - (__Gp * sqrt(((temp + (__Gp2 *  0.25)) - __NQS_w))));
              if ((abs((- __NQS_x0)) <  230.258509299405)) begin
                __NQS_D0 = exp((- __NQS_x0));
              end
              else begin
                if (((- __NQS_x0) <  0.0)) begin
                  __NQS_D0 = ( 100.0e-102 / (((-230.258509299405 - (- __NQS_x0)) * ((((-230.258509299405 - (- __NQS_x0)) * (((-230.258509299405 - (- __NQS_x0)) *  0.333333333333333) +  1.0)) *  0.5) +  1.0)) +  1.0));
                end
                else begin
                  __NQS_D0 = (((((- __NQS_x0) -  230.258509299405) * (((((- __NQS_x0) -  230.258509299405) * ((((- __NQS_x0) -  230.258509299405) *  0.333333333333333) +  1.0)) *  0.5) +  1.0)) +  1.0) *  10.0e+99);
                end
              end
              __NQS_xi = ( 1.0 - ((__Gp2 *  0.5) * __NQS_D0));
              __NQS_p = (((temp - __NQS_x0) *  2.0) + (__Gp2 * ( 1.0 - __NQS_D0)));
              __NQS_q = (((temp - __NQS_x0) * (temp - __NQS_x0)) - (__Gp2 * ((__NQS_x0 -  1.0) + __NQS_D0)));
              __NQS_temp = ((__NQS_p * __NQS_p) - ((__NQS_xi *  4.0) * __NQS_q));
              __NQS_u = ((__NQS_q *  2.0) / (__NQS_p + sqrt(__NQS_temp)));
              __xphi = (__NQS_x0 + __NQS_u);
            end
          end
          if ((abs(__xphi) <= __margin_ac)) begin
            __Qb_tmp = (((__xphi * -0.70710678) * __Gf_ac) * ( 1.0 - ((__xphi *  0.166666666666667) * ( 1.0 - (__xphi *  0.166666666666667)))));
            __dQbs = ((__Gf_ac * -0.70710678) * ( 1.0 - ((__xphi *  0.333333333333333) * ( 1.0 - (__xphi *  0.25)))));
            __d2Qis = ((__Gf_ac * -0.235702) * ( 1.0 - (__xphi *  0.5)));
          end
          else begin
            if ((abs((- __xphi)) <  230.258509299405)) begin
              temp = exp((- __xphi));
            end
            else begin
              if (((- __xphi) <  0.0)) begin
                temp = ( 100.0e-102 / (((-230.258509299405 - (- __xphi)) * ((((-230.258509299405 - (- __xphi)) * (((-230.258509299405 - (- __xphi)) *  0.333333333333333) +  1.0)) *  0.5) +  1.0)) +  1.0));
              end
              else begin
                temp = (((((- __xphi) -  230.258509299405) * (((((- __xphi) -  230.258509299405) * ((((- __xphi) -  230.258509299405) *  0.333333333333333) +  1.0)) *  0.5) +  1.0)) +  1.0) *  10.0e+99);
              end
            end
            __Qb_tmp = (__Gf_ac * sqrt(((temp + __xphi) -  1.0)));
            if ((__xphi > __margin_ac)) begin
              __Qb_tmp = (- __Qb_tmp);
            end
            __dQbs = ((((__Gf_ac *  0.5) * __Gf_ac) * ( 1.0 - temp)) / __Qb_tmp);
            __d2Qis = ((((__dQbs * __dQbs) - ((__Gf_ac *  0.5) * __Gf_ac)) / __Qb_tmp) + __dQbs);
          end
          __dQis = (__pd - __dQbs);
          __dQis_1 = ( 1.0 / __dQis);
          __fQi = ((__Qp9 * __dQis_1) -  1.0);
          __dfQi = (( 1.0 - (((__Qp9 * __d2Qis) * __dQis_1) * __dQis_1)) * __dQis_1);
          __fk0 = (((__dfQi * __dQy) * __dQy) + (__fQi * __d2Qy));
          __dpsy2 = (((__dQy * __dQy) * __dQis_1) * __dQis_1);
          __zsat_nqs = (__thesat2 * __dpsy2);
          if ((__CHNL_TYPE == -1)) begin
            __zsat_nqs = (__zsat_nqs / ((__thesat1_ac * __dps_ac) +  1.0));
          end
          temp = sqrt(((__zsat_nqs *  2.0) +  1.0));
          __Fvsat = ( 2.0 / (temp +  1.0));
          temp1 = (__d2Qy - (__dpsy2 * __d2Qis));
          __fk9 = (__Fvsat * (__fk0 - ((((__zsat_nqs * __fQi) * temp1) * __Fvsat) / temp)));
        end
        __QS_NQS =  0.0;
        __QD_NQS =  0.0;
        __QG_NQS =  0.0;
        if ((__SWNQS_i != 0)) begin
          if ((__SWNQS_i == 1)) begin
            __QS_NQS = ((((__Qp0 *  17.0) + (__Qp1 *  30.0)) + __QpN) /  96.0);
            __QD_NQS = (((__Qp0 + (__Qp1 *  30.0)) + (__QpN *  17.0)) /  96.0);
            temp = ((__Qp1 / __pd) + __xg_ac);
            if ((abs(temp) <= __marginp)) begin
              temp1 = (temp / __a_factrp);
            end
            else begin
              if ((temp < (- __marginp))) begin
                __NQS_yg = (- temp);
                __NQS_z = ((__NQS_yg *  1.25) / __a_factrp);
                __NQS_eta = (((__NQS_z +  10.0) - sqrt((((__NQS_z -  6.0) * (__NQS_z -  6.0)) +  64.0))) *  0.5);
                __NQS_a = (((__NQS_yg - __NQS_eta) * (__NQS_yg - __NQS_eta)) + (__Gp2 * (__NQS_eta +  1.0)));
                __NQS_c = (((__NQS_yg - __NQS_eta) *  2.0) - __Gp2);
                __NQS_tau = (ln((__NQS_a / __Gp2)) - __NQS_eta);
                __nu = (__NQS_a + __NQS_c);
                __mutau = ((__nu * __nu) + (__NQS_tau * (((__NQS_c * __NQS_c) *  0.5) - __NQS_a)));
                __NQS_y0 = (__NQS_eta + (((__NQS_a * __nu) * __NQS_tau) / (__mutau + (((((__nu / __mutau) * __NQS_tau) * __NQS_tau) * __NQS_c) * (((__NQS_c * __NQS_c) *  0.333333333333333) - __NQS_a)))));
                if ((abs(__NQS_y0) <  230.258509299405)) begin
                  __NQS_D0 = exp(__NQS_y0);
                end
                else begin
                  if ((__NQS_y0 <  0.0)) begin
                    __NQS_D0 = ( 100.0e-102 / (((-230.258509299405 - __NQS_y0) * ((((-230.258509299405 - __NQS_y0) * (((-230.258509299405 - __NQS_y0) *  0.333333333333333) +  1.0)) *  0.5) +  1.0)) +  1.0));
                  end
                  else begin
                    __NQS_D0 = ((((__NQS_y0 -  230.258509299405) * ((((__NQS_y0 -  230.258509299405) * (((__NQS_y0 -  230.258509299405) *  0.333333333333333) +  1.0)) *  0.5) +  1.0)) +  1.0) *  10.0e+99);
                  end
                end
                __NQS_xi = ( 1.0 - ((__Gp2 * __NQS_D0) *  0.5));
                __NQS_p = (((__NQS_yg - __NQS_y0) *  2.0) + (__Gp2 * (__NQS_D0 -  1.0)));
                __NQS_q = (((__NQS_yg - __NQS_y0) * (__NQS_yg - __NQS_y0)) + (__Gp2 * ((__NQS_y0 +  1.0) - __NQS_D0)));
                __NQS_temp = ((__NQS_p * __NQS_p) - ((__NQS_xi *  4.0) * __NQS_q));
                __NQS_w = ((__NQS_q *  2.0) / (__NQS_p + sqrt(__NQS_temp)));
                temp1 = (- (__NQS_y0 + __NQS_w));
              end
              else begin
                __NQS_xg1 = ( 1.0 / ((__Gp *  0.732464877560822) +  1.25));
                __NQS_A_fac = ((((__a_factrp *  1.25) * __NQS_xg1) -  1.0) * __NQS_xg1);
                __NQS_xbar = ((temp / __a_factrp) * ((__NQS_A_fac * temp) +  1.0));
                if ((abs((- __NQS_xbar)) <  230.258509299405)) begin
                  __NQS_temp = exp((- __NQS_xbar));
                end
                else begin
                  if (((- __NQS_xbar) <  0.0)) begin
                    __NQS_temp = ( 100.0e-102 / (((-230.258509299405 - (- __NQS_xbar)) * ((((-230.258509299405 - (- __NQS_xbar)) * (((-230.258509299405 - (- __NQS_xbar)) *  0.333333333333333) +  1.0)) *  0.5) +  1.0)) +  1.0));
                  end
                  else begin
                    __NQS_temp = (((((- __NQS_xbar) -  230.258509299405) * (((((- __NQS_xbar) -  230.258509299405) * ((((- __NQS_xbar) -  230.258509299405) *  0.333333333333333) +  1.0)) *  0.5) +  1.0)) +  1.0) *  10.0e+99);
                  end
                end
                __NQS_w = ( 1.0 - __NQS_temp);
                __NQS_x0 = ((temp + (__Gp2 *  0.5)) - (__Gp * sqrt(((temp + (__Gp2 *  0.25)) - __NQS_w))));
                if ((abs((- __NQS_x0)) <  230.258509299405)) begin
                  __NQS_D0 = exp((- __NQS_x0));
                end
                else begin
                  if (((- __NQS_x0) <  0.0)) begin
                    __NQS_D0 = ( 100.0e-102 / (((-230.258509299405 - (- __NQS_x0)) * ((((-230.258509299405 - (- __NQS_x0)) * (((-230.258509299405 - (- __NQS_x0)) *  0.333333333333333) +  1.0)) *  0.5) +  1.0)) +  1.0));
                  end
                  else begin
                    __NQS_D0 = (((((- __NQS_x0) -  230.258509299405) * (((((- __NQS_x0) -  230.258509299405) * ((((- __NQS_x0) -  230.258509299405) *  0.333333333333333) +  1.0)) *  0.5) +  1.0)) +  1.0) *  10.0e+99);
                  end
                end
                __NQS_xi = ( 1.0 - ((__Gp2 *  0.5) * __NQS_D0));
                __NQS_p = (((temp - __NQS_x0) *  2.0) + (__Gp2 * ( 1.0 - __NQS_D0)));
                __NQS_q = (((temp - __NQS_x0) * (temp - __NQS_x0)) - (__Gp2 * ((__NQS_x0 -  1.0) + __NQS_D0)));
                __NQS_temp = ((__NQS_p * __NQS_p) - ((__NQS_xi *  4.0) * __NQS_q));
                __NQS_u = ((__NQS_q *  2.0) / (__NQS_p + sqrt(__NQS_temp)));
                temp1 = (__NQS_x0 + __NQS_u);
              end
            end
            __QG_NQS = (__xg_ac - (((__x_sp + (temp1 *  4.0)) + __x_dp) *  0.166666666666667));
          end
          else begin
            if ((__SWNQS_i == 2)) begin
              __QS_NQS = (((((__Qp0 *  11.0) + (__Qp1 *  24.0)) + (__Qp2 *  9.0)) + __QpN) /  90.0);
              __QD_NQS = (((((__QpN *  11.0) + (__Qp2 *  24.0)) + (__Qp1 *  9.0)) + __Qp0) /  90.0);
              temp = ((__Qp1 / __pd) + __xg_ac);
              if ((abs(temp) <= __marginp)) begin
                temp1 = (temp / __a_factrp);
              end
              else begin
                if ((temp < (- __marginp))) begin
                  __NQS_yg = (- temp);
                  __NQS_z = ((__NQS_yg *  1.25) / __a_factrp);
                  __NQS_eta = (((__NQS_z +  10.0) - sqrt((((__NQS_z -  6.0) * (__NQS_z -  6.0)) +  64.0))) *  0.5);
                  __NQS_a = (((__NQS_yg - __NQS_eta) * (__NQS_yg - __NQS_eta)) + (__Gp2 * (__NQS_eta +  1.0)));
                  __NQS_c = (((__NQS_yg - __NQS_eta) *  2.0) - __Gp2);
                  __NQS_tau = (ln((__NQS_a / __Gp2)) - __NQS_eta);
                  __nu = (__NQS_a + __NQS_c);
                  __mutau = ((__nu * __nu) + (__NQS_tau * (((__NQS_c * __NQS_c) *  0.5) - __NQS_a)));
                  __NQS_y0 = (__NQS_eta + (((__NQS_a * __nu) * __NQS_tau) / (__mutau + (((((__nu / __mutau) * __NQS_tau) * __NQS_tau) * __NQS_c) * (((__NQS_c * __NQS_c) *  0.333333333333333) - __NQS_a)))));
                  if ((abs(__NQS_y0) <  230.258509299405)) begin
                    __NQS_D0 = exp(__NQS_y0);
                  end
                  else begin
                    if ((__NQS_y0 <  0.0)) begin
                      __NQS_D0 = ( 100.0e-102 / (((-230.258509299405 - __NQS_y0) * ((((-230.258509299405 - __NQS_y0) * (((-230.258509299405 - __NQS_y0) *  0.333333333333333) +  1.0)) *  0.5) +  1.0)) +  1.0));
                    end
                    else begin
                      __NQS_D0 = ((((__NQS_y0 -  230.258509299405) * ((((__NQS_y0 -  230.258509299405) * (((__NQS_y0 -  230.258509299405) *  0.333333333333333) +  1.0)) *  0.5) +  1.0)) +  1.0) *  10.0e+99);
                    end
                  end
                  __NQS_xi = ( 1.0 - ((__Gp2 * __NQS_D0) *  0.5));
                  __NQS_p = (((__NQS_yg - __NQS_y0) *  2.0) + (__Gp2 * (__NQS_D0 -  1.0)));
                  __NQS_q = (((__NQS_yg - __NQS_y0) * (__NQS_yg - __NQS_y0)) + (__Gp2 * ((__NQS_y0 +  1.0) - __NQS_D0)));
                  __NQS_temp = ((__NQS_p * __NQS_p) - ((__NQS_xi *  4.0) * __NQS_q));
                  __NQS_w = ((__NQS_q *  2.0) / (__NQS_p + sqrt(__NQS_temp)));
                  temp1 = (- (__NQS_y0 + __NQS_w));
                end
                else begin
                  __NQS_xg1 = ( 1.0 / ((__Gp *  0.732464877560822) +  1.25));
                  __NQS_A_fac = ((((__a_factrp *  1.25) * __NQS_xg1) -  1.0) * __NQS_xg1);
                  __NQS_xbar = ((temp / __a_factrp) * ((__NQS_A_fac * temp) +  1.0));
                  if ((abs((- __NQS_xbar)) <  230.258509299405)) begin
                    __NQS_temp = exp((- __NQS_xbar));
                  end
                  else begin
                    if (((- __NQS_xbar) <  0.0)) begin
                      __NQS_temp = ( 100.0e-102 / (((-230.258509299405 - (- __NQS_xbar)) * ((((-230.258509299405 - (- __NQS_xbar)) * (((-230.258509299405 - (- __NQS_xbar)) *  0.333333333333333) +  1.0)) *  0.5) +  1.0)) +  1.0));
                    end
                    else begin
                      __NQS_temp = (((((- __NQS_xbar) -  230.258509299405) * (((((- __NQS_xbar) -  230.258509299405) * ((((- __NQS_xbar) -  230.258509299405) *  0.333333333333333) +  1.0)) *  0.5) +  1.0)) +  1.0) *  10.0e+99);
                    end
                  end
                  __NQS_w = ( 1.0 - __NQS_temp);
                  __NQS_x0 = ((temp + (__Gp2 *  0.5)) - (__Gp * sqrt(((temp + (__Gp2 *  0.25)) - __NQS_w))));
                  if ((abs((- __NQS_x0)) <  230.258509299405)) begin
                    __NQS_D0 = exp((- __NQS_x0));
                  end
                  else begin
                    if (((- __NQS_x0) <  0.0)) begin
                      __NQS_D0 = ( 100.0e-102 / (((-230.258509299405 - (- __NQS_x0)) * ((((-230.258509299405 - (- __NQS_x0)) * (((-230.258509299405 - (- __NQS_x0)) *  0.333333333333333) +  1.0)) *  0.5) +  1.0)) +  1.0));
                    end
                    else begin
                      __NQS_D0 = (((((- __NQS_x0) -  230.258509299405) * (((((- __NQS_x0) -  230.258509299405) * ((((- __NQS_x0) -  230.258509299405) *  0.333333333333333) +  1.0)) *  0.5) +  1.0)) +  1.0) *  10.0e+99);
                    end
                  end
                  __NQS_xi = ( 1.0 - ((__Gp2 *  0.5) * __NQS_D0));
                  __NQS_p = (((temp - __NQS_x0) *  2.0) + (__Gp2 * ( 1.0 - __NQS_D0)));
                  __NQS_q = (((temp - __NQS_x0) * (temp - __NQS_x0)) - (__Gp2 * ((__NQS_x0 -  1.0) + __NQS_D0)));
                  __NQS_temp = ((__NQS_p * __NQS_p) - ((__NQS_xi *  4.0) * __NQS_q));
                  __NQS_u = ((__NQS_q *  2.0) / (__NQS_p + sqrt(__NQS_temp)));
                  temp1 = (__NQS_x0 + __NQS_u);
                end
              end
              temp = ((__Qp2 / __pd) + __xg_ac);
              if ((abs(temp) <= __marginp)) begin
                temp2 = (temp / __a_factrp);
              end
              else begin
                if ((temp < (- __marginp))) begin
                  __NQS_yg = (- temp);
                  __NQS_z = ((__NQS_yg *  1.25) / __a_factrp);
                  __NQS_eta = (((__NQS_z +  10.0) - sqrt((((__NQS_z -  6.0) * (__NQS_z -  6.0)) +  64.0))) *  0.5);
                  __NQS_a = (((__NQS_yg - __NQS_eta) * (__NQS_yg - __NQS_eta)) + (__Gp2 * (__NQS_eta +  1.0)));
                  __NQS_c = (((__NQS_yg - __NQS_eta) *  2.0) - __Gp2);
                  __NQS_tau = (ln((__NQS_a / __Gp2)) - __NQS_eta);
                  __nu = (__NQS_a + __NQS_c);
                  __mutau = ((__nu * __nu) + (__NQS_tau * (((__NQS_c * __NQS_c) *  0.5) - __NQS_a)));
                  __NQS_y0 = (__NQS_eta + (((__NQS_a * __nu) * __NQS_tau) / (__mutau + (((((__nu / __mutau) * __NQS_tau) * __NQS_tau) * __NQS_c) * (((__NQS_c * __NQS_c) *  0.333333333333333) - __NQS_a)))));
                  if ((abs(__NQS_y0) <  230.258509299405)) begin
                    __NQS_D0 = exp(__NQS_y0);
                  end
                  else begin
                    if ((__NQS_y0 <  0.0)) begin
                      __NQS_D0 = ( 100.0e-102 / (((-230.258509299405 - __NQS_y0) * ((((-230.258509299405 - __NQS_y0) * (((-230.258509299405 - __NQS_y0) *  0.333333333333333) +  1.0)) *  0.5) +  1.0)) +  1.0));
                    end
                    else begin
                      __NQS_D0 = ((((__NQS_y0 -  230.258509299405) * ((((__NQS_y0 -  230.258509299405) * (((__NQS_y0 -  230.258509299405) *  0.333333333333333) +  1.0)) *  0.5) +  1.0)) +  1.0) *  10.0e+99);
                    end
                  end
                  __NQS_xi = ( 1.0 - ((__Gp2 * __NQS_D0) *  0.5));
                  __NQS_p = (((__NQS_yg - __NQS_y0) *  2.0) + (__Gp2 * (__NQS_D0 -  1.0)));
                  __NQS_q = (((__NQS_yg - __NQS_y0) * (__NQS_yg - __NQS_y0)) + (__Gp2 * ((__NQS_y0 +  1.0) - __NQS_D0)));
                  __NQS_temp = ((__NQS_p * __NQS_p) - ((__NQS_xi *  4.0) * __NQS_q));
                  __NQS_w = ((__NQS_q *  2.0) / (__NQS_p + sqrt(__NQS_temp)));
                  temp2 = (- (__NQS_y0 + __NQS_w));
                end
                else begin
                  __NQS_xg1 = ( 1.0 / ((__Gp *  0.732464877560822) +  1.25));
                  __NQS_A_fac = ((((__a_factrp *  1.25) * __NQS_xg1) -  1.0) * __NQS_xg1);
                  __NQS_xbar = ((temp / __a_factrp) * ((__NQS_A_fac * temp) +  1.0));
                  if ((abs((- __NQS_xbar)) <  230.258509299405)) begin
                    __NQS_temp = exp((- __NQS_xbar));
                  end
                  else begin
                    if (((- __NQS_xbar) <  0.0)) begin
                      __NQS_temp = ( 100.0e-102 / (((-230.258509299405 - (- __NQS_xbar)) * ((((-230.258509299405 - (- __NQS_xbar)) * (((-230.258509299405 - (- __NQS_xbar)) *  0.333333333333333) +  1.0)) *  0.5) +  1.0)) +  1.0));
                    end
                    else begin
                      __NQS_temp = (((((- __NQS_xbar) -  230.258509299405) * (((((- __NQS_xbar) -  230.258509299405) * ((((- __NQS_xbar) -  230.258509299405) *  0.333333333333333) +  1.0)) *  0.5) +  1.0)) +  1.0) *  10.0e+99);
                    end
                  end
                  __NQS_w = ( 1.0 - __NQS_temp);
                  __NQS_x0 = ((temp + (__Gp2 *  0.5)) - (__Gp * sqrt(((temp + (__Gp2 *  0.25)) - __NQS_w))));
                  if ((abs((- __NQS_x0)) <  230.258509299405)) begin
                    __NQS_D0 = exp((- __NQS_x0));
                  end
                  else begin
                    if (((- __NQS_x0) <  0.0)) begin
                      __NQS_D0 = ( 100.0e-102 / (((-230.258509299405 - (- __NQS_x0)) * ((((-230.258509299405 - (- __NQS_x0)) * (((-230.258509299405 - (- __NQS_x0)) *  0.333333333333333) +  1.0)) *  0.5) +  1.0)) +  1.0));
                    end
                    else begin
                      __NQS_D0 = (((((- __NQS_x0) -  230.258509299405) * (((((- __NQS_x0) -  230.258509299405) * ((((- __NQS_x0) -  230.258509299405) *  0.333333333333333) +  1.0)) *  0.5) +  1.0)) +  1.0) *  10.0e+99);
                    end
                  end
                  __NQS_xi = ( 1.0 - ((__Gp2 *  0.5) * __NQS_D0));
                  __NQS_p = (((temp - __NQS_x0) *  2.0) + (__Gp2 * ( 1.0 - __NQS_D0)));
                  __NQS_q = (((temp - __NQS_x0) * (temp - __NQS_x0)) - (__Gp2 * ((__NQS_x0 -  1.0) + __NQS_D0)));
                  __NQS_temp = ((__NQS_p * __NQS_p) - ((__NQS_xi *  4.0) * __NQS_q));
                  __NQS_u = ((__NQS_q *  2.0) / (__NQS_p + sqrt(__NQS_temp)));
                  temp2 = (__NQS_x0 + __NQS_u);
                end
              end
              __QG_NQS = (__xg_ac - (((__x_sp + ((temp1 + temp2) *  3.0)) + __x_dp) *  0.125));
            end
            else begin
              if ((__SWNQS_i == 3)) begin
                __QS_NQS = ((((((__Qp0 *  251.0) + (__Qp1 *  594.0)) + (__Qp2 *  312.0)) + (__Qp3 *  174.0)) + (__QpN *  13.0)) /  2.688e+3);
                __QD_NQS = ((((((__QpN *  251.0) + (__Qp3 *  594.0)) + (__Qp2 *  312.0)) + (__Qp1 *  174.0)) + (__Qp0 *  13.0)) /  2.688e+3);
                temp = ((__Qp1 / __pd) + __xg_ac);
                if ((abs(temp) <= __marginp)) begin
                  temp1 = (temp / __a_factrp);
                end
                else begin
                  if ((temp < (- __marginp))) begin
                    __NQS_yg = (- temp);
                    __NQS_z = ((__NQS_yg *  1.25) / __a_factrp);
                    __NQS_eta = (((__NQS_z +  10.0) - sqrt((((__NQS_z -  6.0) * (__NQS_z -  6.0)) +  64.0))) *  0.5);
                    __NQS_a = (((__NQS_yg - __NQS_eta) * (__NQS_yg - __NQS_eta)) + (__Gp2 * (__NQS_eta +  1.0)));
                    __NQS_c = (((__NQS_yg - __NQS_eta) *  2.0) - __Gp2);
                    __NQS_tau = (ln((__NQS_a / __Gp2)) - __NQS_eta);
                    __nu = (__NQS_a + __NQS_c);
                    __mutau = ((__nu * __nu) + (__NQS_tau * (((__NQS_c * __NQS_c) *  0.5) - __NQS_a)));
                    __NQS_y0 = (__NQS_eta + (((__NQS_a * __nu) * __NQS_tau) / (__mutau + (((((__nu / __mutau) * __NQS_tau) * __NQS_tau) * __NQS_c) * (((__NQS_c * __NQS_c) *  0.333333333333333) - __NQS_a)))));
                    if ((abs(__NQS_y0) <  230.258509299405)) begin
                      __NQS_D0 = exp(__NQS_y0);
                    end
                    else begin
                      if ((__NQS_y0 <  0.0)) begin
                        __NQS_D0 = ( 100.0e-102 / (((-230.258509299405 - __NQS_y0) * ((((-230.258509299405 - __NQS_y0) * (((-230.258509299405 - __NQS_y0) *  0.333333333333333) +  1.0)) *  0.5) +  1.0)) +  1.0));
                      end
                      else begin
                        __NQS_D0 = ((((__NQS_y0 -  230.258509299405) * ((((__NQS_y0 -  230.258509299405) * (((__NQS_y0 -  230.258509299405) *  0.333333333333333) +  1.0)) *  0.5) +  1.0)) +  1.0) *  10.0e+99);
                      end
                    end
                    __NQS_xi = ( 1.0 - ((__Gp2 * __NQS_D0) *  0.5));
                    __NQS_p = (((__NQS_yg - __NQS_y0) *  2.0) + (__Gp2 * (__NQS_D0 -  1.0)));
                    __NQS_q = (((__NQS_yg - __NQS_y0) * (__NQS_yg - __NQS_y0)) + (__Gp2 * ((__NQS_y0 +  1.0) - __NQS_D0)));
                    __NQS_temp = ((__NQS_p * __NQS_p) - ((__NQS_xi *  4.0) * __NQS_q));
                    __NQS_w = ((__NQS_q *  2.0) / (__NQS_p + sqrt(__NQS_temp)));
                    temp1 = (- (__NQS_y0 + __NQS_w));
                  end
                  else begin
                    __NQS_xg1 = ( 1.0 / ((__Gp *  0.732464877560822) +  1.25));
                    __NQS_A_fac = ((((__a_factrp *  1.25) * __NQS_xg1) -  1.0) * __NQS_xg1);
                    __NQS_xbar = ((temp / __a_factrp) * ((__NQS_A_fac * temp) +  1.0));
                    if ((abs((- __NQS_xbar)) <  230.258509299405)) begin
                      __NQS_temp = exp((- __NQS_xbar));
                    end
                    else begin
                      if (((- __NQS_xbar) <  0.0)) begin
                        __NQS_temp = ( 100.0e-102 / (((-230.258509299405 - (- __NQS_xbar)) * ((((-230.258509299405 - (- __NQS_xbar)) * (((-230.258509299405 - (- __NQS_xbar)) *  0.333333333333333) +  1.0)) *  0.5) +  1.0)) +  1.0));
                      end
                      else begin
                        __NQS_temp = (((((- __NQS_xbar) -  230.258509299405) * (((((- __NQS_xbar) -  230.258509299405) * ((((- __NQS_xbar) -  230.258509299405) *  0.333333333333333) +  1.0)) *  0.5) +  1.0)) +  1.0) *  10.0e+99);
                      end
                    end
                    __NQS_w = ( 1.0 - __NQS_temp);
                    __NQS_x0 = ((temp + (__Gp2 *  0.5)) - (__Gp * sqrt(((temp + (__Gp2 *  0.25)) - __NQS_w))));
                    if ((abs((- __NQS_x0)) <  230.258509299405)) begin
                      __NQS_D0 = exp((- __NQS_x0));
                    end
                    else begin
                      if (((- __NQS_x0) <  0.0)) begin
                        __NQS_D0 = ( 100.0e-102 / (((-230.258509299405 - (- __NQS_x0)) * ((((-230.258509299405 - (- __NQS_x0)) * (((-230.258509299405 - (- __NQS_x0)) *  0.333333333333333) +  1.0)) *  0.5) +  1.0)) +  1.0));
                      end
                      else begin
                        __NQS_D0 = (((((- __NQS_x0) -  230.258509299405) * (((((- __NQS_x0) -  230.258509299405) * ((((- __NQS_x0) -  230.258509299405) *  0.333333333333333) +  1.0)) *  0.5) +  1.0)) +  1.0) *  10.0e+99);
                      end
                    end
                    __NQS_xi = ( 1.0 - ((__Gp2 *  0.5) * __NQS_D0));
                    __NQS_p = (((temp - __NQS_x0) *  2.0) + (__Gp2 * ( 1.0 - __NQS_D0)));
                    __NQS_q = (((temp - __NQS_x0) * (temp - __NQS_x0)) - (__Gp2 * ((__NQS_x0 -  1.0) + __NQS_D0)));
                    __NQS_temp = ((__NQS_p * __NQS_p) - ((__NQS_xi *  4.0) * __NQS_q));
                    __NQS_u = ((__NQS_q *  2.0) / (__NQS_p + sqrt(__NQS_temp)));
                    temp1 = (__NQS_x0 + __NQS_u);
                  end
                end
                temp = ((__Qp2 / __pd) + __xg_ac);
                if ((abs(temp) <= __marginp)) begin
                  temp2 = (temp / __a_factrp);
                end
                else begin
                  if ((temp < (- __marginp))) begin
                    __NQS_yg = (- temp);
                    __NQS_z = ((__NQS_yg *  1.25) / __a_factrp);
                    __NQS_eta = (((__NQS_z +  10.0) - sqrt((((__NQS_z -  6.0) * (__NQS_z -  6.0)) +  64.0))) *  0.5);
                    __NQS_a = (((__NQS_yg - __NQS_eta) * (__NQS_yg - __NQS_eta)) + (__Gp2 * (__NQS_eta +  1.0)));
                    __NQS_c = (((__NQS_yg - __NQS_eta) *  2.0) - __Gp2);
                    __NQS_tau = (ln((__NQS_a / __Gp2)) - __NQS_eta);
                    __nu = (__NQS_a + __NQS_c);
                    __mutau = ((__nu * __nu) + (__NQS_tau * (((__NQS_c * __NQS_c) *  0.5) - __NQS_a)));
                    __NQS_y0 = (__NQS_eta + (((__NQS_a * __nu) * __NQS_tau) / (__mutau + (((((__nu / __mutau) * __NQS_tau) * __NQS_tau) * __NQS_c) * (((__NQS_c * __NQS_c) *  0.333333333333333) - __NQS_a)))));
                    if ((abs(__NQS_y0) <  230.258509299405)) begin
                      __NQS_D0 = exp(__NQS_y0);
                    end
                    else begin
                      if ((__NQS_y0 <  0.0)) begin
                        __NQS_D0 = ( 100.0e-102 / (((-230.258509299405 - __NQS_y0) * ((((-230.258509299405 - __NQS_y0) * (((-230.258509299405 - __NQS_y0) *  0.333333333333333) +  1.0)) *  0.5) +  1.0)) +  1.0));
                      end
                      else begin
                        __NQS_D0 = ((((__NQS_y0 -  230.258509299405) * ((((__NQS_y0 -  230.258509299405) * (((__NQS_y0 -  230.258509299405) *  0.333333333333333) +  1.0)) *  0.5) +  1.0)) +  1.0) *  10.0e+99);
                      end
                    end
                    __NQS_xi = ( 1.0 - ((__Gp2 * __NQS_D0) *  0.5));
                    __NQS_p = (((__NQS_yg - __NQS_y0) *  2.0) + (__Gp2 * (__NQS_D0 -  1.0)));
                    __NQS_q = (((__NQS_yg - __NQS_y0) * (__NQS_yg - __NQS_y0)) + (__Gp2 * ((__NQS_y0 +  1.0) - __NQS_D0)));
                    __NQS_temp = ((__NQS_p * __NQS_p) - ((__NQS_xi *  4.0) * __NQS_q));
                    __NQS_w = ((__NQS_q *  2.0) / (__NQS_p + sqrt(__NQS_temp)));
                    temp2 = (- (__NQS_y0 + __NQS_w));
                  end
                  else begin
                    __NQS_xg1 = ( 1.0 / ((__Gp *  0.732464877560822) +  1.25));
                    __NQS_A_fac = ((((__a_factrp *  1.25) * __NQS_xg1) -  1.0) * __NQS_xg1);
                    __NQS_xbar = ((temp / __a_factrp) * ((__NQS_A_fac * temp) +  1.0));
                    if ((abs((- __NQS_xbar)) <  230.258509299405)) begin
                      __NQS_temp = exp((- __NQS_xbar));
                    end
                    else begin
                      if (((- __NQS_xbar) <  0.0)) begin
                        __NQS_temp = ( 100.0e-102 / (((-230.258509299405 - (- __NQS_xbar)) * ((((-230.258509299405 - (- __NQS_xbar)) * (((-230.258509299405 - (- __NQS_xbar)) *  0.333333333333333) +  1.0)) *  0.5) +  1.0)) +  1.0));
                      end
                      else begin
                        __NQS_temp = (((((- __NQS_xbar) -  230.258509299405) * (((((- __NQS_xbar) -  230.258509299405) * ((((- __NQS_xbar) -  230.258509299405) *  0.333333333333333) +  1.0)) *  0.5) +  1.0)) +  1.0) *  10.0e+99);
                      end
                    end
                    __NQS_w = ( 1.0 - __NQS_temp);
                    __NQS_x0 = ((temp + (__Gp2 *  0.5)) - (__Gp * sqrt(((temp + (__Gp2 *  0.25)) - __NQS_w))));
                    if ((abs((- __NQS_x0)) <  230.258509299405)) begin
                      __NQS_D0 = exp((- __NQS_x0));
                    end
                    else begin
                      if (((- __NQS_x0) <  0.0)) begin
                        __NQS_D0 = ( 100.0e-102 / (((-230.258509299405 - (- __NQS_x0)) * ((((-230.258509299405 - (- __NQS_x0)) * (((-230.258509299405 - (- __NQS_x0)) *  0.333333333333333) +  1.0)) *  0.5) +  1.0)) +  1.0));
                      end
                      else begin
                        __NQS_D0 = (((((- __NQS_x0) -  230.258509299405) * (((((- __NQS_x0) -  230.258509299405) * ((((- __NQS_x0) -  230.258509299405) *  0.333333333333333) +  1.0)) *  0.5) +  1.0)) +  1.0) *  10.0e+99);
                      end
                    end
                    __NQS_xi = ( 1.0 - ((__Gp2 *  0.5) * __NQS_D0));
                    __NQS_p = (((temp - __NQS_x0) *  2.0) + (__Gp2 * ( 1.0 - __NQS_D0)));
                    __NQS_q = (((temp - __NQS_x0) * (temp - __NQS_x0)) - (__Gp2 * ((__NQS_x0 -  1.0) + __NQS_D0)));
                    __NQS_temp = ((__NQS_p * __NQS_p) - ((__NQS_xi *  4.0) * __NQS_q));
                    __NQS_u = ((__NQS_q *  2.0) / (__NQS_p + sqrt(__NQS_temp)));
                    temp2 = (__NQS_x0 + __NQS_u);
                  end
                end
                temp = ((__Qp3 / __pd) + __xg_ac);
                if ((abs(temp) <= __marginp)) begin
                  __temp3 = (temp / __a_factrp);
                end
                else begin
                  if ((temp < (- __marginp))) begin
                    __NQS_yg = (- temp);
                    __NQS_z = ((__NQS_yg *  1.25) / __a_factrp);
                    __NQS_eta = (((__NQS_z +  10.0) - sqrt((((__NQS_z -  6.0) * (__NQS_z -  6.0)) +  64.0))) *  0.5);
                    __NQS_a = (((__NQS_yg - __NQS_eta) * (__NQS_yg - __NQS_eta)) + (__Gp2 * (__NQS_eta +  1.0)));
                    __NQS_c = (((__NQS_yg - __NQS_eta) *  2.0) - __Gp2);
                    __NQS_tau = (ln((__NQS_a / __Gp2)) - __NQS_eta);
                    __nu = (__NQS_a + __NQS_c);
                    __mutau = ((__nu * __nu) + (__NQS_tau * (((__NQS_c * __NQS_c) *  0.5) - __NQS_a)));
                    __NQS_y0 = (__NQS_eta + (((__NQS_a * __nu) * __NQS_tau) / (__mutau + (((((__nu / __mutau) * __NQS_tau) * __NQS_tau) * __NQS_c) * (((__NQS_c * __NQS_c) *  0.333333333333333) - __NQS_a)))));
                    if ((abs(__NQS_y0) <  230.258509299405)) begin
                      __NQS_D0 = exp(__NQS_y0);
                    end
                    else begin
                      if ((__NQS_y0 <  0.0)) begin
                        __NQS_D0 = ( 100.0e-102 / (((-230.258509299405 - __NQS_y0) * ((((-230.258509299405 - __NQS_y0) * (((-230.258509299405 - __NQS_y0) *  0.333333333333333) +  1.0)) *  0.5) +  1.0)) +  1.0));
                      end
                      else begin
                        __NQS_D0 = ((((__NQS_y0 -  230.258509299405) * ((((__NQS_y0 -  230.258509299405) * (((__NQS_y0 -  230.258509299405) *  0.333333333333333) +  1.0)) *  0.5) +  1.0)) +  1.0) *  10.0e+99);
                      end
                    end
                    __NQS_xi = ( 1.0 - ((__Gp2 * __NQS_D0) *  0.5));
                    __NQS_p = (((__NQS_yg - __NQS_y0) *  2.0) + (__Gp2 * (__NQS_D0 -  1.0)));
                    __NQS_q = (((__NQS_yg - __NQS_y0) * (__NQS_yg - __NQS_y0)) + (__Gp2 * ((__NQS_y0 +  1.0) - __NQS_D0)));
                    __NQS_temp = ((__NQS_p * __NQS_p) - ((__NQS_xi *  4.0) * __NQS_q));
                    __NQS_w = ((__NQS_q *  2.0) / (__NQS_p + sqrt(__NQS_temp)));
                    __temp3 = (- (__NQS_y0 + __NQS_w));
                  end
                  else begin
                    __NQS_xg1 = ( 1.0 / ((__Gp *  0.732464877560822) +  1.25));
                    __NQS_A_fac = ((((__a_factrp *  1.25) * __NQS_xg1) -  1.0) * __NQS_xg1);
                    __NQS_xbar = ((temp / __a_factrp) * ((__NQS_A_fac * temp) +  1.0));
                    if ((abs((- __NQS_xbar)) <  230.258509299405)) begin
                      __NQS_temp = exp((- __NQS_xbar));
                    end
                    else begin
                      if (((- __NQS_xbar) <  0.0)) begin
                        __NQS_temp = ( 100.0e-102 / (((-230.258509299405 - (- __NQS_xbar)) * ((((-230.258509299405 - (- __NQS_xbar)) * (((-230.258509299405 - (- __NQS_xbar)) *  0.333333333333333) +  1.0)) *  0.5) +  1.0)) +  1.0));
                      end
                      else begin
                        __NQS_temp = (((((- __NQS_xbar) -  230.258509299405) * (((((- __NQS_xbar) -  230.258509299405) * ((((- __NQS_xbar) -  230.258509299405) *  0.333333333333333) +  1.0)) *  0.5) +  1.0)) +  1.0) *  10.0e+99);
                      end
                    end
                    __NQS_w = ( 1.0 - __NQS_temp);
                    __NQS_x0 = ((temp + (__Gp2 *  0.5)) - (__Gp * sqrt(((temp + (__Gp2 *  0.25)) - __NQS_w))));
                    if ((abs((- __NQS_x0)) <  230.258509299405)) begin
                      __NQS_D0 = exp((- __NQS_x0));
                    end
                    else begin
                      if (((- __NQS_x0) <  0.0)) begin
                        __NQS_D0 = ( 100.0e-102 / (((-230.258509299405 - (- __NQS_x0)) * ((((-230.258509299405 - (- __NQS_x0)) * (((-230.258509299405 - (- __NQS_x0)) *  0.333333333333333) +  1.0)) *  0.5) +  1.0)) +  1.0));
                      end
                      else begin
                        __NQS_D0 = (((((- __NQS_x0) -  230.258509299405) * (((((- __NQS_x0) -  230.258509299405) * ((((- __NQS_x0) -  230.258509299405) *  0.333333333333333) +  1.0)) *  0.5) +  1.0)) +  1.0) *  10.0e+99);
                      end
                    end
                    __NQS_xi = ( 1.0 - ((__Gp2 *  0.5) * __NQS_D0));
                    __NQS_p = (((temp - __NQS_x0) *  2.0) + (__Gp2 * ( 1.0 - __NQS_D0)));
                    __NQS_q = (((temp - __NQS_x0) * (temp - __NQS_x0)) - (__Gp2 * ((__NQS_x0 -  1.0) + __NQS_D0)));
                    __NQS_temp = ((__NQS_p * __NQS_p) - ((__NQS_xi *  4.0) * __NQS_q));
                    __NQS_u = ((__NQS_q *  2.0) / (__NQS_p + sqrt(__NQS_temp)));
                    __temp3 = (__NQS_x0 + __NQS_u);
                  end
                end
                __QG_NQS = (__xg_ac - (((((__x_sp + (temp1 *  4.0)) + (temp2 *  2.0)) + (__temp3 *  4.0)) + __x_dp) /  12.0));
              end
              else begin
                if ((__SWNQS_i == 5)) begin
                  __QS_NQS = ((((__Qp0 *  1.187e+3) + (__QpN *  43.0)) /  18.72e+3) + ((((((__Qp1 *  503.0) + (__Qp4 *  172.0)) + (__Qp5 *  87.0)) + (__Qp3 *  265.0)) + (__Qp2 *  328.0)) /  3.12e+3));
                  __QD_NQS = ((((__QpN *  1.187e+3) + (__Qp0 *  43.0)) /  18.72e+3) + ((((((__Qp5 *  503.0) + (__Qp2 *  172.0)) + (__Qp1 *  87.0)) + (__Qp3 *  265.0)) + (__Qp4 *  328.0)) /  3.12e+3));
                  temp = ((__Qp1 / __pd) + __xg_ac);
                  if ((abs(temp) <= __marginp)) begin
                    temp1 = (temp / __a_factrp);
                  end
                  else begin
                    if ((temp < (- __marginp))) begin
                      __NQS_yg = (- temp);
                      __NQS_z = ((__NQS_yg *  1.25) / __a_factrp);
                      __NQS_eta = (((__NQS_z +  10.0) - sqrt((((__NQS_z -  6.0) * (__NQS_z -  6.0)) +  64.0))) *  0.5);
                      __NQS_a = (((__NQS_yg - __NQS_eta) * (__NQS_yg - __NQS_eta)) + (__Gp2 * (__NQS_eta +  1.0)));
                      __NQS_c = (((__NQS_yg - __NQS_eta) *  2.0) - __Gp2);
                      __NQS_tau = (ln((__NQS_a / __Gp2)) - __NQS_eta);
                      __nu = (__NQS_a + __NQS_c);
                      __mutau = ((__nu * __nu) + (__NQS_tau * (((__NQS_c * __NQS_c) *  0.5) - __NQS_a)));
                      __NQS_y0 = (__NQS_eta + (((__NQS_a * __nu) * __NQS_tau) / (__mutau + (((((__nu / __mutau) * __NQS_tau) * __NQS_tau) * __NQS_c) * (((__NQS_c * __NQS_c) *  0.333333333333333) - __NQS_a)))));
                      if ((abs(__NQS_y0) <  230.258509299405)) begin
                        __NQS_D0 = exp(__NQS_y0);
                      end
                      else begin
                        if ((__NQS_y0 <  0.0)) begin
                          __NQS_D0 = ( 100.0e-102 / (((-230.258509299405 - __NQS_y0) * ((((-230.258509299405 - __NQS_y0) * (((-230.258509299405 - __NQS_y0) *  0.333333333333333) +  1.0)) *  0.5) +  1.0)) +  1.0));
                        end
                        else begin
                          __NQS_D0 = ((((__NQS_y0 -  230.258509299405) * ((((__NQS_y0 -  230.258509299405) * (((__NQS_y0 -  230.258509299405) *  0.333333333333333) +  1.0)) *  0.5) +  1.0)) +  1.0) *  10.0e+99);
                        end
                      end
                      __NQS_xi = ( 1.0 - ((__Gp2 * __NQS_D0) *  0.5));
                      __NQS_p = (((__NQS_yg - __NQS_y0) *  2.0) + (__Gp2 * (__NQS_D0 -  1.0)));
                      __NQS_q = (((__NQS_yg - __NQS_y0) * (__NQS_yg - __NQS_y0)) + (__Gp2 * ((__NQS_y0 +  1.0) - __NQS_D0)));
                      __NQS_temp = ((__NQS_p * __NQS_p) - ((__NQS_xi *  4.0) * __NQS_q));
                      __NQS_w = ((__NQS_q *  2.0) / (__NQS_p + sqrt(__NQS_temp)));
                      temp1 = (- (__NQS_y0 + __NQS_w));
                    end
                    else begin
                      __NQS_xg1 = ( 1.0 / ((__Gp *  0.732464877560822) +  1.25));
                      __NQS_A_fac = ((((__a_factrp *  1.25) * __NQS_xg1) -  1.0) * __NQS_xg1);
                      __NQS_xbar = ((temp / __a_factrp) * ((__NQS_A_fac * temp) +  1.0));
                      if ((abs((- __NQS_xbar)) <  230.258509299405)) begin
                        __NQS_temp = exp((- __NQS_xbar));
                      end
                      else begin
                        if (((- __NQS_xbar) <  0.0)) begin
                          __NQS_temp = ( 100.0e-102 / (((-230.258509299405 - (- __NQS_xbar)) * ((((-230.258509299405 - (- __NQS_xbar)) * (((-230.258509299405 - (- __NQS_xbar)) *  0.333333333333333) +  1.0)) *  0.5) +  1.0)) +  1.0));
                        end
                        else begin
                          __NQS_temp = (((((- __NQS_xbar) -  230.258509299405) * (((((- __NQS_xbar) -  230.258509299405) * ((((- __NQS_xbar) -  230.258509299405) *  0.333333333333333) +  1.0)) *  0.5) +  1.0)) +  1.0) *  10.0e+99);
                        end
                      end
                      __NQS_w = ( 1.0 - __NQS_temp);
                      __NQS_x0 = ((temp + (__Gp2 *  0.5)) - (__Gp * sqrt(((temp + (__Gp2 *  0.25)) - __NQS_w))));
                      if ((abs((- __NQS_x0)) <  230.258509299405)) begin
                        __NQS_D0 = exp((- __NQS_x0));
                      end
                      else begin
                        if (((- __NQS_x0) <  0.0)) begin
                          __NQS_D0 = ( 100.0e-102 / (((-230.258509299405 - (- __NQS_x0)) * ((((-230.258509299405 - (- __NQS_x0)) * (((-230.258509299405 - (- __NQS_x0)) *  0.333333333333333) +  1.0)) *  0.5) +  1.0)) +  1.0));
                        end
                        else begin
                          __NQS_D0 = (((((- __NQS_x0) -  230.258509299405) * (((((- __NQS_x0) -  230.258509299405) * ((((- __NQS_x0) -  230.258509299405) *  0.333333333333333) +  1.0)) *  0.5) +  1.0)) +  1.0) *  10.0e+99);
                        end
                      end
                      __NQS_xi = ( 1.0 - ((__Gp2 *  0.5) * __NQS_D0));
                      __NQS_p = (((temp - __NQS_x0) *  2.0) + (__Gp2 * ( 1.0 - __NQS_D0)));
                      __NQS_q = (((temp - __NQS_x0) * (temp - __NQS_x0)) - (__Gp2 * ((__NQS_x0 -  1.0) + __NQS_D0)));
                      __NQS_temp = ((__NQS_p * __NQS_p) - ((__NQS_xi *  4.0) * __NQS_q));
                      __NQS_u = ((__NQS_q *  2.0) / (__NQS_p + sqrt(__NQS_temp)));
                      temp1 = (__NQS_x0 + __NQS_u);
                    end
                  end
                  temp = ((__Qp2 / __pd) + __xg_ac);
                  if ((abs(temp) <= __marginp)) begin
                    temp2 = (temp / __a_factrp);
                  end
                  else begin
                    if ((temp < (- __marginp))) begin
                      __NQS_yg = (- temp);
                      __NQS_z = ((__NQS_yg *  1.25) / __a_factrp);
                      __NQS_eta = (((__NQS_z +  10.0) - sqrt((((__NQS_z -  6.0) * (__NQS_z -  6.0)) +  64.0))) *  0.5);
                      __NQS_a = (((__NQS_yg - __NQS_eta) * (__NQS_yg - __NQS_eta)) + (__Gp2 * (__NQS_eta +  1.0)));
                      __NQS_c = (((__NQS_yg - __NQS_eta) *  2.0) - __Gp2);
                      __NQS_tau = (ln((__NQS_a / __Gp2)) - __NQS_eta);
                      __nu = (__NQS_a + __NQS_c);
                      __mutau = ((__nu * __nu) + (__NQS_tau * (((__NQS_c * __NQS_c) *  0.5) - __NQS_a)));
                      __NQS_y0 = (__NQS_eta + (((__NQS_a * __nu) * __NQS_tau) / (__mutau + (((((__nu / __mutau) * __NQS_tau) * __NQS_tau) * __NQS_c) * (((__NQS_c * __NQS_c) *  0.333333333333333) - __NQS_a)))));
                      if ((abs(__NQS_y0) <  230.258509299405)) begin
                        __NQS_D0 = exp(__NQS_y0);
                      end
                      else begin
                        if ((__NQS_y0 <  0.0)) begin
                          __NQS_D0 = ( 100.0e-102 / (((-230.258509299405 - __NQS_y0) * ((((-230.258509299405 - __NQS_y0) * (((-230.258509299405 - __NQS_y0) *  0.333333333333333) +  1.0)) *  0.5) +  1.0)) +  1.0));
                        end
                        else begin
                          __NQS_D0 = ((((__NQS_y0 -  230.258509299405) * ((((__NQS_y0 -  230.258509299405) * (((__NQS_y0 -  230.258509299405) *  0.333333333333333) +  1.0)) *  0.5) +  1.0)) +  1.0) *  10.0e+99);
                        end
                      end
                      __NQS_xi = ( 1.0 - ((__Gp2 * __NQS_D0) *  0.5));
                      __NQS_p = (((__NQS_yg - __NQS_y0) *  2.0) + (__Gp2 * (__NQS_D0 -  1.0)));
                      __NQS_q = (((__NQS_yg - __NQS_y0) * (__NQS_yg - __NQS_y0)) + (__Gp2 * ((__NQS_y0 +  1.0) - __NQS_D0)));
                      __NQS_temp = ((__NQS_p * __NQS_p) - ((__NQS_xi *  4.0) * __NQS_q));
                      __NQS_w = ((__NQS_q *  2.0) / (__NQS_p + sqrt(__NQS_temp)));
                      temp2 = (- (__NQS_y0 + __NQS_w));
                    end
                    else begin
                      __NQS_xg1 = ( 1.0 / ((__Gp *  0.732464877560822) +  1.25));
                      __NQS_A_fac = ((((__a_factrp *  1.25) * __NQS_xg1) -  1.0) * __NQS_xg1);
                      __NQS_xbar = ((temp / __a_factrp) * ((__NQS_A_fac * temp) +  1.0));
                      if ((abs((- __NQS_xbar)) <  230.258509299405)) begin
                        __NQS_temp = exp((- __NQS_xbar));
                      end
                      else begin
                        if (((- __NQS_xbar) <  0.0)) begin
                          __NQS_temp = ( 100.0e-102 / (((-230.258509299405 - (- __NQS_xbar)) * ((((-230.258509299405 - (- __NQS_xbar)) * (((-230.258509299405 - (- __NQS_xbar)) *  0.333333333333333) +  1.0)) *  0.5) +  1.0)) +  1.0));
                        end
                        else begin
                          __NQS_temp = (((((- __NQS_xbar) -  230.258509299405) * (((((- __NQS_xbar) -  230.258509299405) * ((((- __NQS_xbar) -  230.258509299405) *  0.333333333333333) +  1.0)) *  0.5) +  1.0)) +  1.0) *  10.0e+99);
                        end
                      end
                      __NQS_w = ( 1.0 - __NQS_temp);
                      __NQS_x0 = ((temp + (__Gp2 *  0.5)) - (__Gp * sqrt(((temp + (__Gp2 *  0.25)) - __NQS_w))));
                      if ((abs((- __NQS_x0)) <  230.258509299405)) begin
                        __NQS_D0 = exp((- __NQS_x0));
                      end
                      else begin
                        if (((- __NQS_x0) <  0.0)) begin
                          __NQS_D0 = ( 100.0e-102 / (((-230.258509299405 - (- __NQS_x0)) * ((((-230.258509299405 - (- __NQS_x0)) * (((-230.258509299405 - (- __NQS_x0)) *  0.333333333333333) +  1.0)) *  0.5) +  1.0)) +  1.0));
                        end
                        else begin
                          __NQS_D0 = (((((- __NQS_x0) -  230.258509299405) * (((((- __NQS_x0) -  230.258509299405) * ((((- __NQS_x0) -  230.258509299405) *  0.333333333333333) +  1.0)) *  0.5) +  1.0)) +  1.0) *  10.0e+99);
                        end
                      end
                      __NQS_xi = ( 1.0 - ((__Gp2 *  0.5) * __NQS_D0));
                      __NQS_p = (((temp - __NQS_x0) *  2.0) + (__Gp2 * ( 1.0 - __NQS_D0)));
                      __NQS_q = (((temp - __NQS_x0) * (temp - __NQS_x0)) - (__Gp2 * ((__NQS_x0 -  1.0) + __NQS_D0)));
                      __NQS_temp = ((__NQS_p * __NQS_p) - ((__NQS_xi *  4.0) * __NQS_q));
                      __NQS_u = ((__NQS_q *  2.0) / (__NQS_p + sqrt(__NQS_temp)));
                      temp2 = (__NQS_x0 + __NQS_u);
                    end
                  end
                  temp = ((__Qp3 / __pd) + __xg_ac);
                  if ((abs(temp) <= __marginp)) begin
                    __temp3 = (temp / __a_factrp);
                  end
                  else begin
                    if ((temp < (- __marginp))) begin
                      __NQS_yg = (- temp);
                      __NQS_z = ((__NQS_yg *  1.25) / __a_factrp);
                      __NQS_eta = (((__NQS_z +  10.0) - sqrt((((__NQS_z -  6.0) * (__NQS_z -  6.0)) +  64.0))) *  0.5);
                      __NQS_a = (((__NQS_yg - __NQS_eta) * (__NQS_yg - __NQS_eta)) + (__Gp2 * (__NQS_eta +  1.0)));
                      __NQS_c = (((__NQS_yg - __NQS_eta) *  2.0) - __Gp2);
                      __NQS_tau = (ln((__NQS_a / __Gp2)) - __NQS_eta);
                      __nu = (__NQS_a + __NQS_c);
                      __mutau = ((__nu * __nu) + (__NQS_tau * (((__NQS_c * __NQS_c) *  0.5) - __NQS_a)));
                      __NQS_y0 = (__NQS_eta + (((__NQS_a * __nu) * __NQS_tau) / (__mutau + (((((__nu / __mutau) * __NQS_tau) * __NQS_tau) * __NQS_c) * (((__NQS_c * __NQS_c) *  0.333333333333333) - __NQS_a)))));
                      if ((abs(__NQS_y0) <  230.258509299405)) begin
                        __NQS_D0 = exp(__NQS_y0);
                      end
                      else begin
                        if ((__NQS_y0 <  0.0)) begin
                          __NQS_D0 = ( 100.0e-102 / (((-230.258509299405 - __NQS_y0) * ((((-230.258509299405 - __NQS_y0) * (((-230.258509299405 - __NQS_y0) *  0.333333333333333) +  1.0)) *  0.5) +  1.0)) +  1.0));
                        end
                        else begin
                          __NQS_D0 = ((((__NQS_y0 -  230.258509299405) * ((((__NQS_y0 -  230.258509299405) * (((__NQS_y0 -  230.258509299405) *  0.333333333333333) +  1.0)) *  0.5) +  1.0)) +  1.0) *  10.0e+99);
                        end
                      end
                      __NQS_xi = ( 1.0 - ((__Gp2 * __NQS_D0) *  0.5));
                      __NQS_p = (((__NQS_yg - __NQS_y0) *  2.0) + (__Gp2 * (__NQS_D0 -  1.0)));
                      __NQS_q = (((__NQS_yg - __NQS_y0) * (__NQS_yg - __NQS_y0)) + (__Gp2 * ((__NQS_y0 +  1.0) - __NQS_D0)));
                      __NQS_temp = ((__NQS_p * __NQS_p) - ((__NQS_xi *  4.0) * __NQS_q));
                      __NQS_w = ((__NQS_q *  2.0) / (__NQS_p + sqrt(__NQS_temp)));
                      __temp3 = (- (__NQS_y0 + __NQS_w));
                    end
                    else begin
                      __NQS_xg1 = ( 1.0 / ((__Gp *  0.732464877560822) +  1.25));
                      __NQS_A_fac = ((((__a_factrp *  1.25) * __NQS_xg1) -  1.0) * __NQS_xg1);
                      __NQS_xbar = ((temp / __a_factrp) * ((__NQS_A_fac * temp) +  1.0));
                      if ((abs((- __NQS_xbar)) <  230.258509299405)) begin
                        __NQS_temp = exp((- __NQS_xbar));
                      end
                      else begin
                        if (((- __NQS_xbar) <  0.0)) begin
                          __NQS_temp = ( 100.0e-102 / (((-230.258509299405 - (- __NQS_xbar)) * ((((-230.258509299405 - (- __NQS_xbar)) * (((-230.258509299405 - (- __NQS_xbar)) *  0.333333333333333) +  1.0)) *  0.5) +  1.0)) +  1.0));
                        end
                        else begin
                          __NQS_temp = (((((- __NQS_xbar) -  230.258509299405) * (((((- __NQS_xbar) -  230.258509299405) * ((((- __NQS_xbar) -  230.258509299405) *  0.333333333333333) +  1.0)) *  0.5) +  1.0)) +  1.0) *  10.0e+99);
                        end
                      end
                      __NQS_w = ( 1.0 - __NQS_temp);
                      __NQS_x0 = ((temp + (__Gp2 *  0.5)) - (__Gp * sqrt(((temp + (__Gp2 *  0.25)) - __NQS_w))));
                      if ((abs((- __NQS_x0)) <  230.258509299405)) begin
                        __NQS_D0 = exp((- __NQS_x0));
                      end
                      else begin
                        if (((- __NQS_x0) <  0.0)) begin
                          __NQS_D0 = ( 100.0e-102 / (((-230.258509299405 - (- __NQS_x0)) * ((((-230.258509299405 - (- __NQS_x0)) * (((-230.258509299405 - (- __NQS_x0)) *  0.333333333333333) +  1.0)) *  0.5) +  1.0)) +  1.0));
                        end
                        else begin
                          __NQS_D0 = (((((- __NQS_x0) -  230.258509299405) * (((((- __NQS_x0) -  230.258509299405) * ((((- __NQS_x0) -  230.258509299405) *  0.333333333333333) +  1.0)) *  0.5) +  1.0)) +  1.0) *  10.0e+99);
                        end
                      end
                      __NQS_xi = ( 1.0 - ((__Gp2 *  0.5) * __NQS_D0));
                      __NQS_p = (((temp - __NQS_x0) *  2.0) + (__Gp2 * ( 1.0 - __NQS_D0)));
                      __NQS_q = (((temp - __NQS_x0) * (temp - __NQS_x0)) - (__Gp2 * ((__NQS_x0 -  1.0) + __NQS_D0)));
                      __NQS_temp = ((__NQS_p * __NQS_p) - ((__NQS_xi *  4.0) * __NQS_q));
                      __NQS_u = ((__NQS_q *  2.0) / (__NQS_p + sqrt(__NQS_temp)));
                      __temp3 = (__NQS_x0 + __NQS_u);
                    end
                  end
                  temp = ((__Qp4 / __pd) + __xg_ac);
                  if ((abs(temp) <= __marginp)) begin
                    __temp4 = (temp / __a_factrp);
                  end
                  else begin
                    if ((temp < (- __marginp))) begin
                      __NQS_yg = (- temp);
                      __NQS_z = ((__NQS_yg *  1.25) / __a_factrp);
                      __NQS_eta = (((__NQS_z +  10.0) - sqrt((((__NQS_z -  6.0) * (__NQS_z -  6.0)) +  64.0))) *  0.5);
                      __NQS_a = (((__NQS_yg - __NQS_eta) * (__NQS_yg - __NQS_eta)) + (__Gp2 * (__NQS_eta +  1.0)));
                      __NQS_c = (((__NQS_yg - __NQS_eta) *  2.0) - __Gp2);
                      __NQS_tau = (ln((__NQS_a / __Gp2)) - __NQS_eta);
                      __nu = (__NQS_a + __NQS_c);
                      __mutau = ((__nu * __nu) + (__NQS_tau * (((__NQS_c * __NQS_c) *  0.5) - __NQS_a)));
                      __NQS_y0 = (__NQS_eta + (((__NQS_a * __nu) * __NQS_tau) / (__mutau + (((((__nu / __mutau) * __NQS_tau) * __NQS_tau) * __NQS_c) * (((__NQS_c * __NQS_c) *  0.333333333333333) - __NQS_a)))));
                      if ((abs(__NQS_y0) <  230.258509299405)) begin
                        __NQS_D0 = exp(__NQS_y0);
                      end
                      else begin
                        if ((__NQS_y0 <  0.0)) begin
                          __NQS_D0 = ( 100.0e-102 / (((-230.258509299405 - __NQS_y0) * ((((-230.258509299405 - __NQS_y0) * (((-230.258509299405 - __NQS_y0) *  0.333333333333333) +  1.0)) *  0.5) +  1.0)) +  1.0));
                        end
                        else begin
                          __NQS_D0 = ((((__NQS_y0 -  230.258509299405) * ((((__NQS_y0 -  230.258509299405) * (((__NQS_y0 -  230.258509299405) *  0.333333333333333) +  1.0)) *  0.5) +  1.0)) +  1.0) *  10.0e+99);
                        end
                      end
                      __NQS_xi = ( 1.0 - ((__Gp2 * __NQS_D0) *  0.5));
                      __NQS_p = (((__NQS_yg - __NQS_y0) *  2.0) + (__Gp2 * (__NQS_D0 -  1.0)));
                      __NQS_q = (((__NQS_yg - __NQS_y0) * (__NQS_yg - __NQS_y0)) + (__Gp2 * ((__NQS_y0 +  1.0) - __NQS_D0)));
                      __NQS_temp = ((__NQS_p * __NQS_p) - ((__NQS_xi *  4.0) * __NQS_q));
                      __NQS_w = ((__NQS_q *  2.0) / (__NQS_p + sqrt(__NQS_temp)));
                      __temp4 = (- (__NQS_y0 + __NQS_w));
                    end
                    else begin
                      __NQS_xg1 = ( 1.0 / ((__Gp *  0.732464877560822) +  1.25));
                      __NQS_A_fac = ((((__a_factrp *  1.25) * __NQS_xg1) -  1.0) * __NQS_xg1);
                      __NQS_xbar = ((temp / __a_factrp) * ((__NQS_A_fac * temp) +  1.0));
                      if ((abs((- __NQS_xbar)) <  230.258509299405)) begin
                        __NQS_temp = exp((- __NQS_xbar));
                      end
                      else begin
                        if (((- __NQS_xbar) <  0.0)) begin
                          __NQS_temp = ( 100.0e-102 / (((-230.258509299405 - (- __NQS_xbar)) * ((((-230.258509299405 - (- __NQS_xbar)) * (((-230.258509299405 - (- __NQS_xbar)) *  0.333333333333333) +  1.0)) *  0.5) +  1.0)) +  1.0));
                        end
                        else begin
                          __NQS_temp = (((((- __NQS_xbar) -  230.258509299405) * (((((- __NQS_xbar) -  230.258509299405) * ((((- __NQS_xbar) -  230.258509299405) *  0.333333333333333) +  1.0)) *  0.5) +  1.0)) +  1.0) *  10.0e+99);
                        end
                      end
                      __NQS_w = ( 1.0 - __NQS_temp);
                      __NQS_x0 = ((temp + (__Gp2 *  0.5)) - (__Gp * sqrt(((temp + (__Gp2 *  0.25)) - __NQS_w))));
                      if ((abs((- __NQS_x0)) <  230.258509299405)) begin
                        __NQS_D0 = exp((- __NQS_x0));
                      end
                      else begin
                        if (((- __NQS_x0) <  0.0)) begin
                          __NQS_D0 = ( 100.0e-102 / (((-230.258509299405 - (- __NQS_x0)) * ((((-230.258509299405 - (- __NQS_x0)) * (((-230.258509299405 - (- __NQS_x0)) *  0.333333333333333) +  1.0)) *  0.5) +  1.0)) +  1.0));
                        end
                        else begin
                          __NQS_D0 = (((((- __NQS_x0) -  230.258509299405) * (((((- __NQS_x0) -  230.258509299405) * ((((- __NQS_x0) -  230.258509299405) *  0.333333333333333) +  1.0)) *  0.5) +  1.0)) +  1.0) *  10.0e+99);
                        end
                      end
                      __NQS_xi = ( 1.0 - ((__Gp2 *  0.5) * __NQS_D0));
                      __NQS_p = (((temp - __NQS_x0) *  2.0) + (__Gp2 * ( 1.0 - __NQS_D0)));
                      __NQS_q = (((temp - __NQS_x0) * (temp - __NQS_x0)) - (__Gp2 * ((__NQS_x0 -  1.0) + __NQS_D0)));
                      __NQS_temp = ((__NQS_p * __NQS_p) - ((__NQS_xi *  4.0) * __NQS_q));
                      __NQS_u = ((__NQS_q *  2.0) / (__NQS_p + sqrt(__NQS_temp)));
                      __temp4 = (__NQS_x0 + __NQS_u);
                    end
                  end
                  temp = ((__Qp5 / __pd) + __xg_ac);
                  if ((abs(temp) <= __marginp)) begin
                    __temp5 = (temp / __a_factrp);
                  end
                  else begin
                    if ((temp < (- __marginp))) begin
                      __NQS_yg = (- temp);
                      __NQS_z = ((__NQS_yg *  1.25) / __a_factrp);
                      __NQS_eta = (((__NQS_z +  10.0) - sqrt((((__NQS_z -  6.0) * (__NQS_z -  6.0)) +  64.0))) *  0.5);
                      __NQS_a = (((__NQS_yg - __NQS_eta) * (__NQS_yg - __NQS_eta)) + (__Gp2 * (__NQS_eta +  1.0)));
                      __NQS_c = (((__NQS_yg - __NQS_eta) *  2.0) - __Gp2);
                      __NQS_tau = (ln((__NQS_a / __Gp2)) - __NQS_eta);
                      __nu = (__NQS_a + __NQS_c);
                      __mutau = ((__nu * __nu) + (__NQS_tau * (((__NQS_c * __NQS_c) *  0.5) - __NQS_a)));
                      __NQS_y0 = (__NQS_eta + (((__NQS_a * __nu) * __NQS_tau) / (__mutau + (((((__nu / __mutau) * __NQS_tau) * __NQS_tau) * __NQS_c) * (((__NQS_c * __NQS_c) *  0.333333333333333) - __NQS_a)))));
                      if ((abs(__NQS_y0) <  230.258509299405)) begin
                        __NQS_D0 = exp(__NQS_y0);
                      end
                      else begin
                        if ((__NQS_y0 <  0.0)) begin
                          __NQS_D0 = ( 100.0e-102 / (((-230.258509299405 - __NQS_y0) * ((((-230.258509299405 - __NQS_y0) * (((-230.258509299405 - __NQS_y0) *  0.333333333333333) +  1.0)) *  0.5) +  1.0)) +  1.0));
                        end
                        else begin
                          __NQS_D0 = ((((__NQS_y0 -  230.258509299405) * ((((__NQS_y0 -  230.258509299405) * (((__NQS_y0 -  230.258509299405) *  0.333333333333333) +  1.0)) *  0.5) +  1.0)) +  1.0) *  10.0e+99);
                        end
                      end
                      __NQS_xi = ( 1.0 - ((__Gp2 * __NQS_D0) *  0.5));
                      __NQS_p = (((__NQS_yg - __NQS_y0) *  2.0) + (__Gp2 * (__NQS_D0 -  1.0)));
                      __NQS_q = (((__NQS_yg - __NQS_y0) * (__NQS_yg - __NQS_y0)) + (__Gp2 * ((__NQS_y0 +  1.0) - __NQS_D0)));
                      __NQS_temp = ((__NQS_p * __NQS_p) - ((__NQS_xi *  4.0) * __NQS_q));
                      __NQS_w = ((__NQS_q *  2.0) / (__NQS_p + sqrt(__NQS_temp)));
                      __temp5 = (- (__NQS_y0 + __NQS_w));
                    end
                    else begin
                      __NQS_xg1 = ( 1.0 / ((__Gp *  0.732464877560822) +  1.25));
                      __NQS_A_fac = ((((__a_factrp *  1.25) * __NQS_xg1) -  1.0) * __NQS_xg1);
                      __NQS_xbar = ((temp / __a_factrp) * ((__NQS_A_fac * temp) +  1.0));
                      if ((abs((- __NQS_xbar)) <  230.258509299405)) begin
                        __NQS_temp = exp((- __NQS_xbar));
                      end
                      else begin
                        if (((- __NQS_xbar) <  0.0)) begin
                          __NQS_temp = ( 100.0e-102 / (((-230.258509299405 - (- __NQS_xbar)) * ((((-230.258509299405 - (- __NQS_xbar)) * (((-230.258509299405 - (- __NQS_xbar)) *  0.333333333333333) +  1.0)) *  0.5) +  1.0)) +  1.0));
                        end
                        else begin
                          __NQS_temp = (((((- __NQS_xbar) -  230.258509299405) * (((((- __NQS_xbar) -  230.258509299405) * ((((- __NQS_xbar) -  230.258509299405) *  0.333333333333333) +  1.0)) *  0.5) +  1.0)) +  1.0) *  10.0e+99);
                        end
                      end
                      __NQS_w = ( 1.0 - __NQS_temp);
                      __NQS_x0 = ((temp + (__Gp2 *  0.5)) - (__Gp * sqrt(((temp + (__Gp2 *  0.25)) - __NQS_w))));
                      if ((abs((- __NQS_x0)) <  230.258509299405)) begin
                        __NQS_D0 = exp((- __NQS_x0));
                      end
                      else begin
                        if (((- __NQS_x0) <  0.0)) begin
                          __NQS_D0 = ( 100.0e-102 / (((-230.258509299405 - (- __NQS_x0)) * ((((-230.258509299405 - (- __NQS_x0)) * (((-230.258509299405 - (- __NQS_x0)) *  0.333333333333333) +  1.0)) *  0.5) +  1.0)) +  1.0));
                        end
                        else begin
                          __NQS_D0 = (((((- __NQS_x0) -  230.258509299405) * (((((- __NQS_x0) -  230.258509299405) * ((((- __NQS_x0) -  230.258509299405) *  0.333333333333333) +  1.0)) *  0.5) +  1.0)) +  1.0) *  10.0e+99);
                        end
                      end
                      __NQS_xi = ( 1.0 - ((__Gp2 *  0.5) * __NQS_D0));
                      __NQS_p = (((temp - __NQS_x0) *  2.0) + (__Gp2 * ( 1.0 - __NQS_D0)));
                      __NQS_q = (((temp - __NQS_x0) * (temp - __NQS_x0)) - (__Gp2 * ((__NQS_x0 -  1.0) + __NQS_D0)));
                      __NQS_temp = ((__NQS_p * __NQS_p) - ((__NQS_xi *  4.0) * __NQS_q));
                      __NQS_u = ((__NQS_q *  2.0) / (__NQS_p + sqrt(__NQS_temp)));
                      __temp5 = (__NQS_x0 + __NQS_u);
                    end
                  end
                  __QG_NQS = (__xg_ac - ((((__x_sp + (((temp1 + __temp3) + __temp5) *  4.0)) + ((temp2 + __temp4) *  2.0)) + __x_dp) /  18.0));
                end
                else begin
                  if ((__SWNQS_i == 9)) begin
                    __QS_NQS = ((((((((__Qp8 *  75.653e+3) + (__Qp4 *  225.999e+3)) /  3.7829e+6) + (((((__Qp9 *  151.321e+3) + (__Qp7 *  454.023e+3)) + (__Qp3 *  1.073767e+6)) + (__Qp1 *  1.564569e+6)) /  15.1316e+6)) + (__Qp6 *  0.0399814956779191)) + (__Qp5 *  0.0500690607734807)) + (__Qp2 *  0.076410161516297)) + (((__Qp0 *  3.504517e+6) + (__QpN *  75.653e+3)) /  90.7896e+6));
                    __QD_NQS = ((((((((__Qp2 *  75.653e+3) + (__Qp6 *  225.999e+3)) /  3.7829e+6) + (((((__Qp1 *  151.321e+3) + (__Qp3 *  454.023e+3)) + (__Qp7 *  1.073767e+6)) + (__Qp9 *  1.564569e+6)) /  15.1316e+6)) + (__Qp4 *  0.0399814956779191)) + (__Qp5 *  0.0500690607734807)) + (__Qp8 *  0.076410161516297)) + (((__QpN *  3.504517e+6) + (__Qp0 *  75.653e+3)) /  90.7896e+6));
                    temp = ((__Qp1 / __pd) + __xg_ac);
                    if ((abs(temp) <= __marginp)) begin
                      temp1 = (temp / __a_factrp);
                    end
                    else begin
                      if ((temp < (- __marginp))) begin
                        __NQS_yg = (- temp);
                        __NQS_z = ((__NQS_yg *  1.25) / __a_factrp);
                        __NQS_eta = (((__NQS_z +  10.0) - sqrt((((__NQS_z -  6.0) * (__NQS_z -  6.0)) +  64.0))) *  0.5);
                        __NQS_a = (((__NQS_yg - __NQS_eta) * (__NQS_yg - __NQS_eta)) + (__Gp2 * (__NQS_eta +  1.0)));
                        __NQS_c = (((__NQS_yg - __NQS_eta) *  2.0) - __Gp2);
                        __NQS_tau = (ln((__NQS_a / __Gp2)) - __NQS_eta);
                        __nu = (__NQS_a + __NQS_c);
                        __mutau = ((__nu * __nu) + (__NQS_tau * (((__NQS_c * __NQS_c) *  0.5) - __NQS_a)));
                        __NQS_y0 = (__NQS_eta + (((__NQS_a * __nu) * __NQS_tau) / (__mutau + (((((__nu / __mutau) * __NQS_tau) * __NQS_tau) * __NQS_c) * (((__NQS_c * __NQS_c) *  0.333333333333333) - __NQS_a)))));
                        if ((abs(__NQS_y0) <  230.258509299405)) begin
                          __NQS_D0 = exp(__NQS_y0);
                        end
                        else begin
                          if ((__NQS_y0 <  0.0)) begin
                            __NQS_D0 = ( 100.0e-102 / (((-230.258509299405 - __NQS_y0) * ((((-230.258509299405 - __NQS_y0) * (((-230.258509299405 - __NQS_y0) *  0.333333333333333) +  1.0)) *  0.5) +  1.0)) +  1.0));
                          end
                          else begin
                            __NQS_D0 = ((((__NQS_y0 -  230.258509299405) * ((((__NQS_y0 -  230.258509299405) * (((__NQS_y0 -  230.258509299405) *  0.333333333333333) +  1.0)) *  0.5) +  1.0)) +  1.0) *  10.0e+99);
                          end
                        end
                        __NQS_xi = ( 1.0 - ((__Gp2 * __NQS_D0) *  0.5));
                        __NQS_p = (((__NQS_yg - __NQS_y0) *  2.0) + (__Gp2 * (__NQS_D0 -  1.0)));
                        __NQS_q = (((__NQS_yg - __NQS_y0) * (__NQS_yg - __NQS_y0)) + (__Gp2 * ((__NQS_y0 +  1.0) - __NQS_D0)));
                        __NQS_temp = ((__NQS_p * __NQS_p) - ((__NQS_xi *  4.0) * __NQS_q));
                        __NQS_w = ((__NQS_q *  2.0) / (__NQS_p + sqrt(__NQS_temp)));
                        temp1 = (- (__NQS_y0 + __NQS_w));
                      end
                      else begin
                        __NQS_xg1 = ( 1.0 / ((__Gp *  0.732464877560822) +  1.25));
                        __NQS_A_fac = ((((__a_factrp *  1.25) * __NQS_xg1) -  1.0) * __NQS_xg1);
                        __NQS_xbar = ((temp / __a_factrp) * ((__NQS_A_fac * temp) +  1.0));
                        if ((abs((- __NQS_xbar)) <  230.258509299405)) begin
                          __NQS_temp = exp((- __NQS_xbar));
                        end
                        else begin
                          if (((- __NQS_xbar) <  0.0)) begin
                            __NQS_temp = ( 100.0e-102 / (((-230.258509299405 - (- __NQS_xbar)) * ((((-230.258509299405 - (- __NQS_xbar)) * (((-230.258509299405 - (- __NQS_xbar)) *  0.333333333333333) +  1.0)) *  0.5) +  1.0)) +  1.0));
                          end
                          else begin
                            __NQS_temp = (((((- __NQS_xbar) -  230.258509299405) * (((((- __NQS_xbar) -  230.258509299405) * ((((- __NQS_xbar) -  230.258509299405) *  0.333333333333333) +  1.0)) *  0.5) +  1.0)) +  1.0) *  10.0e+99);
                          end
                        end
                        __NQS_w = ( 1.0 - __NQS_temp);
                        __NQS_x0 = ((temp + (__Gp2 *  0.5)) - (__Gp * sqrt(((temp + (__Gp2 *  0.25)) - __NQS_w))));
                        if ((abs((- __NQS_x0)) <  230.258509299405)) begin
                          __NQS_D0 = exp((- __NQS_x0));
                        end
                        else begin
                          if (((- __NQS_x0) <  0.0)) begin
                            __NQS_D0 = ( 100.0e-102 / (((-230.258509299405 - (- __NQS_x0)) * ((((-230.258509299405 - (- __NQS_x0)) * (((-230.258509299405 - (- __NQS_x0)) *  0.333333333333333) +  1.0)) *  0.5) +  1.0)) +  1.0));
                          end
                          else begin
                            __NQS_D0 = (((((- __NQS_x0) -  230.258509299405) * (((((- __NQS_x0) -  230.258509299405) * ((((- __NQS_x0) -  230.258509299405) *  0.333333333333333) +  1.0)) *  0.5) +  1.0)) +  1.0) *  10.0e+99);
                          end
                        end
                        __NQS_xi = ( 1.0 - ((__Gp2 *  0.5) * __NQS_D0));
                        __NQS_p = (((temp - __NQS_x0) *  2.0) + (__Gp2 * ( 1.0 - __NQS_D0)));
                        __NQS_q = (((temp - __NQS_x0) * (temp - __NQS_x0)) - (__Gp2 * ((__NQS_x0 -  1.0) + __NQS_D0)));
                        __NQS_temp = ((__NQS_p * __NQS_p) - ((__NQS_xi *  4.0) * __NQS_q));
                        __NQS_u = ((__NQS_q *  2.0) / (__NQS_p + sqrt(__NQS_temp)));
                        temp1 = (__NQS_x0 + __NQS_u);
                      end
                    end
                    temp = ((__Qp2 / __pd) + __xg_ac);
                    if ((abs(temp) <= __marginp)) begin
                      temp2 = (temp / __a_factrp);
                    end
                    else begin
                      if ((temp < (- __marginp))) begin
                        __NQS_yg = (- temp);
                        __NQS_z = ((__NQS_yg *  1.25) / __a_factrp);
                        __NQS_eta = (((__NQS_z +  10.0) - sqrt((((__NQS_z -  6.0) * (__NQS_z -  6.0)) +  64.0))) *  0.5);
                        __NQS_a = (((__NQS_yg - __NQS_eta) * (__NQS_yg - __NQS_eta)) + (__Gp2 * (__NQS_eta +  1.0)));
                        __NQS_c = (((__NQS_yg - __NQS_eta) *  2.0) - __Gp2);
                        __NQS_tau = (ln((__NQS_a / __Gp2)) - __NQS_eta);
                        __nu = (__NQS_a + __NQS_c);
                        __mutau = ((__nu * __nu) + (__NQS_tau * (((__NQS_c * __NQS_c) *  0.5) - __NQS_a)));
                        __NQS_y0 = (__NQS_eta + (((__NQS_a * __nu) * __NQS_tau) / (__mutau + (((((__nu / __mutau) * __NQS_tau) * __NQS_tau) * __NQS_c) * (((__NQS_c * __NQS_c) *  0.333333333333333) - __NQS_a)))));
                        if ((abs(__NQS_y0) <  230.258509299405)) begin
                          __NQS_D0 = exp(__NQS_y0);
                        end
                        else begin
                          if ((__NQS_y0 <  0.0)) begin
                            __NQS_D0 = ( 100.0e-102 / (((-230.258509299405 - __NQS_y0) * ((((-230.258509299405 - __NQS_y0) * (((-230.258509299405 - __NQS_y0) *  0.333333333333333) +  1.0)) *  0.5) +  1.0)) +  1.0));
                          end
                          else begin
                            __NQS_D0 = ((((__NQS_y0 -  230.258509299405) * ((((__NQS_y0 -  230.258509299405) * (((__NQS_y0 -  230.258509299405) *  0.333333333333333) +  1.0)) *  0.5) +  1.0)) +  1.0) *  10.0e+99);
                          end
                        end
                        __NQS_xi = ( 1.0 - ((__Gp2 * __NQS_D0) *  0.5));
                        __NQS_p = (((__NQS_yg - __NQS_y0) *  2.0) + (__Gp2 * (__NQS_D0 -  1.0)));
                        __NQS_q = (((__NQS_yg - __NQS_y0) * (__NQS_yg - __NQS_y0)) + (__Gp2 * ((__NQS_y0 +  1.0) - __NQS_D0)));
                        __NQS_temp = ((__NQS_p * __NQS_p) - ((__NQS_xi *  4.0) * __NQS_q));
                        __NQS_w = ((__NQS_q *  2.0) / (__NQS_p + sqrt(__NQS_temp)));
                        temp2 = (- (__NQS_y0 + __NQS_w));
                      end
                      else begin
                        __NQS_xg1 = ( 1.0 / ((__Gp *  0.732464877560822) +  1.25));
                        __NQS_A_fac = ((((__a_factrp *  1.25) * __NQS_xg1) -  1.0) * __NQS_xg1);
                        __NQS_xbar = ((temp / __a_factrp) * ((__NQS_A_fac * temp) +  1.0));
                        if ((abs((- __NQS_xbar)) <  230.258509299405)) begin
                          __NQS_temp = exp((- __NQS_xbar));
                        end
                        else begin
                          if (((- __NQS_xbar) <  0.0)) begin
                            __NQS_temp = ( 100.0e-102 / (((-230.258509299405 - (- __NQS_xbar)) * ((((-230.258509299405 - (- __NQS_xbar)) * (((-230.258509299405 - (- __NQS_xbar)) *  0.333333333333333) +  1.0)) *  0.5) +  1.0)) +  1.0));
                          end
                          else begin
                            __NQS_temp = (((((- __NQS_xbar) -  230.258509299405) * (((((- __NQS_xbar) -  230.258509299405) * ((((- __NQS_xbar) -  230.258509299405) *  0.333333333333333) +  1.0)) *  0.5) +  1.0)) +  1.0) *  10.0e+99);
                          end
                        end
                        __NQS_w = ( 1.0 - __NQS_temp);
                        __NQS_x0 = ((temp + (__Gp2 *  0.5)) - (__Gp * sqrt(((temp + (__Gp2 *  0.25)) - __NQS_w))));
                        if ((abs((- __NQS_x0)) <  230.258509299405)) begin
                          __NQS_D0 = exp((- __NQS_x0));
                        end
                        else begin
                          if (((- __NQS_x0) <  0.0)) begin
                            __NQS_D0 = ( 100.0e-102 / (((-230.258509299405 - (- __NQS_x0)) * ((((-230.258509299405 - (- __NQS_x0)) * (((-230.258509299405 - (- __NQS_x0)) *  0.333333333333333) +  1.0)) *  0.5) +  1.0)) +  1.0));
                          end
                          else begin
                            __NQS_D0 = (((((- __NQS_x0) -  230.258509299405) * (((((- __NQS_x0) -  230.258509299405) * ((((- __NQS_x0) -  230.258509299405) *  0.333333333333333) +  1.0)) *  0.5) +  1.0)) +  1.0) *  10.0e+99);
                          end
                        end
                        __NQS_xi = ( 1.0 - ((__Gp2 *  0.5) * __NQS_D0));
                        __NQS_p = (((temp - __NQS_x0) *  2.0) + (__Gp2 * ( 1.0 - __NQS_D0)));
                        __NQS_q = (((temp - __NQS_x0) * (temp - __NQS_x0)) - (__Gp2 * ((__NQS_x0 -  1.0) + __NQS_D0)));
                        __NQS_temp = ((__NQS_p * __NQS_p) - ((__NQS_xi *  4.0) * __NQS_q));
                        __NQS_u = ((__NQS_q *  2.0) / (__NQS_p + sqrt(__NQS_temp)));
                        temp2 = (__NQS_x0 + __NQS_u);
                      end
                    end
                    temp = ((__Qp3 / __pd) + __xg_ac);
                    if ((abs(temp) <= __marginp)) begin
                      __temp3 = (temp / __a_factrp);
                    end
                    else begin
                      if ((temp < (- __marginp))) begin
                        __NQS_yg = (- temp);
                        __NQS_z = ((__NQS_yg *  1.25) / __a_factrp);
                        __NQS_eta = (((__NQS_z +  10.0) - sqrt((((__NQS_z -  6.0) * (__NQS_z -  6.0)) +  64.0))) *  0.5);
                        __NQS_a = (((__NQS_yg - __NQS_eta) * (__NQS_yg - __NQS_eta)) + (__Gp2 * (__NQS_eta +  1.0)));
                        __NQS_c = (((__NQS_yg - __NQS_eta) *  2.0) - __Gp2);
                        __NQS_tau = (ln((__NQS_a / __Gp2)) - __NQS_eta);
                        __nu = (__NQS_a + __NQS_c);
                        __mutau = ((__nu * __nu) + (__NQS_tau * (((__NQS_c * __NQS_c) *  0.5) - __NQS_a)));
                        __NQS_y0 = (__NQS_eta + (((__NQS_a * __nu) * __NQS_tau) / (__mutau + (((((__nu / __mutau) * __NQS_tau) * __NQS_tau) * __NQS_c) * (((__NQS_c * __NQS_c) *  0.333333333333333) - __NQS_a)))));
                        if ((abs(__NQS_y0) <  230.258509299405)) begin
                          __NQS_D0 = exp(__NQS_y0);
                        end
                        else begin
                          if ((__NQS_y0 <  0.0)) begin
                            __NQS_D0 = ( 100.0e-102 / (((-230.258509299405 - __NQS_y0) * ((((-230.258509299405 - __NQS_y0) * (((-230.258509299405 - __NQS_y0) *  0.333333333333333) +  1.0)) *  0.5) +  1.0)) +  1.0));
                          end
                          else begin
                            __NQS_D0 = ((((__NQS_y0 -  230.258509299405) * ((((__NQS_y0 -  230.258509299405) * (((__NQS_y0 -  230.258509299405) *  0.333333333333333) +  1.0)) *  0.5) +  1.0)) +  1.0) *  10.0e+99);
                          end
                        end
                        __NQS_xi = ( 1.0 - ((__Gp2 * __NQS_D0) *  0.5));
                        __NQS_p = (((__NQS_yg - __NQS_y0) *  2.0) + (__Gp2 * (__NQS_D0 -  1.0)));
                        __NQS_q = (((__NQS_yg - __NQS_y0) * (__NQS_yg - __NQS_y0)) + (__Gp2 * ((__NQS_y0 +  1.0) - __NQS_D0)));
                        __NQS_temp = ((__NQS_p * __NQS_p) - ((__NQS_xi *  4.0) * __NQS_q));
                        __NQS_w = ((__NQS_q *  2.0) / (__NQS_p + sqrt(__NQS_temp)));
                        __temp3 = (- (__NQS_y0 + __NQS_w));
                      end
                      else begin
                        __NQS_xg1 = ( 1.0 / ((__Gp *  0.732464877560822) +  1.25));
                        __NQS_A_fac = ((((__a_factrp *  1.25) * __NQS_xg1) -  1.0) * __NQS_xg1);
                        __NQS_xbar = ((temp / __a_factrp) * ((__NQS_A_fac * temp) +  1.0));
                        if ((abs((- __NQS_xbar)) <  230.258509299405)) begin
                          __NQS_temp = exp((- __NQS_xbar));
                        end
                        else begin
                          if (((- __NQS_xbar) <  0.0)) begin
                            __NQS_temp = ( 100.0e-102 / (((-230.258509299405 - (- __NQS_xbar)) * ((((-230.258509299405 - (- __NQS_xbar)) * (((-230.258509299405 - (- __NQS_xbar)) *  0.333333333333333) +  1.0)) *  0.5) +  1.0)) +  1.0));
                          end
                          else begin
                            __NQS_temp = (((((- __NQS_xbar) -  230.258509299405) * (((((- __NQS_xbar) -  230.258509299405) * ((((- __NQS_xbar) -  230.258509299405) *  0.333333333333333) +  1.0)) *  0.5) +  1.0)) +  1.0) *  10.0e+99);
                          end
                        end
                        __NQS_w = ( 1.0 - __NQS_temp);
                        __NQS_x0 = ((temp + (__Gp2 *  0.5)) - (__Gp * sqrt(((temp + (__Gp2 *  0.25)) - __NQS_w))));
                        if ((abs((- __NQS_x0)) <  230.258509299405)) begin
                          __NQS_D0 = exp((- __NQS_x0));
                        end
                        else begin
                          if (((- __NQS_x0) <  0.0)) begin
                            __NQS_D0 = ( 100.0e-102 / (((-230.258509299405 - (- __NQS_x0)) * ((((-230.258509299405 - (- __NQS_x0)) * (((-230.258509299405 - (- __NQS_x0)) *  0.333333333333333) +  1.0)) *  0.5) +  1.0)) +  1.0));
                          end
                          else begin
                            __NQS_D0 = (((((- __NQS_x0) -  230.258509299405) * (((((- __NQS_x0) -  230.258509299405) * ((((- __NQS_x0) -  230.258509299405) *  0.333333333333333) +  1.0)) *  0.5) +  1.0)) +  1.0) *  10.0e+99);
                          end
                        end
                        __NQS_xi = ( 1.0 - ((__Gp2 *  0.5) * __NQS_D0));
                        __NQS_p = (((temp - __NQS_x0) *  2.0) + (__Gp2 * ( 1.0 - __NQS_D0)));
                        __NQS_q = (((temp - __NQS_x0) * (temp - __NQS_x0)) - (__Gp2 * ((__NQS_x0 -  1.0) + __NQS_D0)));
                        __NQS_temp = ((__NQS_p * __NQS_p) - ((__NQS_xi *  4.0) * __NQS_q));
                        __NQS_u = ((__NQS_q *  2.0) / (__NQS_p + sqrt(__NQS_temp)));
                        __temp3 = (__NQS_x0 + __NQS_u);
                      end
                    end
                    temp = ((__Qp4 / __pd) + __xg_ac);
                    if ((abs(temp) <= __marginp)) begin
                      __temp4 = (temp / __a_factrp);
                    end
                    else begin
                      if ((temp < (- __marginp))) begin
                        __NQS_yg = (- temp);
                        __NQS_z = ((__NQS_yg *  1.25) / __a_factrp);
                        __NQS_eta = (((__NQS_z +  10.0) - sqrt((((__NQS_z -  6.0) * (__NQS_z -  6.0)) +  64.0))) *  0.5);
                        __NQS_a = (((__NQS_yg - __NQS_eta) * (__NQS_yg - __NQS_eta)) + (__Gp2 * (__NQS_eta +  1.0)));
                        __NQS_c = (((__NQS_yg - __NQS_eta) *  2.0) - __Gp2);
                        __NQS_tau = (ln((__NQS_a / __Gp2)) - __NQS_eta);
                        __nu = (__NQS_a + __NQS_c);
                        __mutau = ((__nu * __nu) + (__NQS_tau * (((__NQS_c * __NQS_c) *  0.5) - __NQS_a)));
                        __NQS_y0 = (__NQS_eta + (((__NQS_a * __nu) * __NQS_tau) / (__mutau + (((((__nu / __mutau) * __NQS_tau) * __NQS_tau) * __NQS_c) * (((__NQS_c * __NQS_c) *  0.333333333333333) - __NQS_a)))));
                        if ((abs(__NQS_y0) <  230.258509299405)) begin
                          __NQS_D0 = exp(__NQS_y0);
                        end
                        else begin
                          if ((__NQS_y0 <  0.0)) begin
                            __NQS_D0 = ( 100.0e-102 / (((-230.258509299405 - __NQS_y0) * ((((-230.258509299405 - __NQS_y0) * (((-230.258509299405 - __NQS_y0) *  0.333333333333333) +  1.0)) *  0.5) +  1.0)) +  1.0));
                          end
                          else begin
                            __NQS_D0 = ((((__NQS_y0 -  230.258509299405) * ((((__NQS_y0 -  230.258509299405) * (((__NQS_y0 -  230.258509299405) *  0.333333333333333) +  1.0)) *  0.5) +  1.0)) +  1.0) *  10.0e+99);
                          end
                        end
                        __NQS_xi = ( 1.0 - ((__Gp2 * __NQS_D0) *  0.5));
                        __NQS_p = (((__NQS_yg - __NQS_y0) *  2.0) + (__Gp2 * (__NQS_D0 -  1.0)));
                        __NQS_q = (((__NQS_yg - __NQS_y0) * (__NQS_yg - __NQS_y0)) + (__Gp2 * ((__NQS_y0 +  1.0) - __NQS_D0)));
                        __NQS_temp = ((__NQS_p * __NQS_p) - ((__NQS_xi *  4.0) * __NQS_q));
                        __NQS_w = ((__NQS_q *  2.0) / (__NQS_p + sqrt(__NQS_temp)));
                        __temp4 = (- (__NQS_y0 + __NQS_w));
                      end
                      else begin
                        __NQS_xg1 = ( 1.0 / ((__Gp *  0.732464877560822) +  1.25));
                        __NQS_A_fac = ((((__a_factrp *  1.25) * __NQS_xg1) -  1.0) * __NQS_xg1);
                        __NQS_xbar = ((temp / __a_factrp) * ((__NQS_A_fac * temp) +  1.0));
                        if ((abs((- __NQS_xbar)) <  230.258509299405)) begin
                          __NQS_temp = exp((- __NQS_xbar));
                        end
                        else begin
                          if (((- __NQS_xbar) <  0.0)) begin
                            __NQS_temp = ( 100.0e-102 / (((-230.258509299405 - (- __NQS_xbar)) * ((((-230.258509299405 - (- __NQS_xbar)) * (((-230.258509299405 - (- __NQS_xbar)) *  0.333333333333333) +  1.0)) *  0.5) +  1.0)) +  1.0));
                          end
                          else begin
                            __NQS_temp = (((((- __NQS_xbar) -  230.258509299405) * (((((- __NQS_xbar) -  230.258509299405) * ((((- __NQS_xbar) -  230.258509299405) *  0.333333333333333) +  1.0)) *  0.5) +  1.0)) +  1.0) *  10.0e+99);
                          end
                        end
                        __NQS_w = ( 1.0 - __NQS_temp);
                        __NQS_x0 = ((temp + (__Gp2 *  0.5)) - (__Gp * sqrt(((temp + (__Gp2 *  0.25)) - __NQS_w))));
                        if ((abs((- __NQS_x0)) <  230.258509299405)) begin
                          __NQS_D0 = exp((- __NQS_x0));
                        end
                        else begin
                          if (((- __NQS_x0) <  0.0)) begin
                            __NQS_D0 = ( 100.0e-102 / (((-230.258509299405 - (- __NQS_x0)) * ((((-230.258509299405 - (- __NQS_x0)) * (((-230.258509299405 - (- __NQS_x0)) *  0.333333333333333) +  1.0)) *  0.5) +  1.0)) +  1.0));
                          end
                          else begin
                            __NQS_D0 = (((((- __NQS_x0) -  230.258509299405) * (((((- __NQS_x0) -  230.258509299405) * ((((- __NQS_x0) -  230.258509299405) *  0.333333333333333) +  1.0)) *  0.5) +  1.0)) +  1.0) *  10.0e+99);
                          end
                        end
                        __NQS_xi = ( 1.0 - ((__Gp2 *  0.5) * __NQS_D0));
                        __NQS_p = (((temp - __NQS_x0) *  2.0) + (__Gp2 * ( 1.0 - __NQS_D0)));
                        __NQS_q = (((temp - __NQS_x0) * (temp - __NQS_x0)) - (__Gp2 * ((__NQS_x0 -  1.0) + __NQS_D0)));
                        __NQS_temp = ((__NQS_p * __NQS_p) - ((__NQS_xi *  4.0) * __NQS_q));
                        __NQS_u = ((__NQS_q *  2.0) / (__NQS_p + sqrt(__NQS_temp)));
                        __temp4 = (__NQS_x0 + __NQS_u);
                      end
                    end
                    temp = ((__Qp5 / __pd) + __xg_ac);
                    if ((abs(temp) <= __marginp)) begin
                      __temp5 = (temp / __a_factrp);
                    end
                    else begin
                      if ((temp < (- __marginp))) begin
                        __NQS_yg = (- temp);
                        __NQS_z = ((__NQS_yg *  1.25) / __a_factrp);
                        __NQS_eta = (((__NQS_z +  10.0) - sqrt((((__NQS_z -  6.0) * (__NQS_z -  6.0)) +  64.0))) *  0.5);
                        __NQS_a = (((__NQS_yg - __NQS_eta) * (__NQS_yg - __NQS_eta)) + (__Gp2 * (__NQS_eta +  1.0)));
                        __NQS_c = (((__NQS_yg - __NQS_eta) *  2.0) - __Gp2);
                        __NQS_tau = (ln((__NQS_a / __Gp2)) - __NQS_eta);
                        __nu = (__NQS_a + __NQS_c);
                        __mutau = ((__nu * __nu) + (__NQS_tau * (((__NQS_c * __NQS_c) *  0.5) - __NQS_a)));
                        __NQS_y0 = (__NQS_eta + (((__NQS_a * __nu) * __NQS_tau) / (__mutau + (((((__nu / __mutau) * __NQS_tau) * __NQS_tau) * __NQS_c) * (((__NQS_c * __NQS_c) *  0.333333333333333) - __NQS_a)))));
                        if ((abs(__NQS_y0) <  230.258509299405)) begin
                          __NQS_D0 = exp(__NQS_y0);
                        end
                        else begin
                          if ((__NQS_y0 <  0.0)) begin
                            __NQS_D0 = ( 100.0e-102 / (((-230.258509299405 - __NQS_y0) * ((((-230.258509299405 - __NQS_y0) * (((-230.258509299405 - __NQS_y0) *  0.333333333333333) +  1.0)) *  0.5) +  1.0)) +  1.0));
                          end
                          else begin
                            __NQS_D0 = ((((__NQS_y0 -  230.258509299405) * ((((__NQS_y0 -  230.258509299405) * (((__NQS_y0 -  230.258509299405) *  0.333333333333333) +  1.0)) *  0.5) +  1.0)) +  1.0) *  10.0e+99);
                          end
                        end
                        __NQS_xi = ( 1.0 - ((__Gp2 * __NQS_D0) *  0.5));
                        __NQS_p = (((__NQS_yg - __NQS_y0) *  2.0) + (__Gp2 * (__NQS_D0 -  1.0)));
                        __NQS_q = (((__NQS_yg - __NQS_y0) * (__NQS_yg - __NQS_y0)) + (__Gp2 * ((__NQS_y0 +  1.0) - __NQS_D0)));
                        __NQS_temp = ((__NQS_p * __NQS_p) - ((__NQS_xi *  4.0) * __NQS_q));
                        __NQS_w = ((__NQS_q *  2.0) / (__NQS_p + sqrt(__NQS_temp)));
                        __temp5 = (- (__NQS_y0 + __NQS_w));
                      end
                      else begin
                        __NQS_xg1 = ( 1.0 / ((__Gp *  0.732464877560822) +  1.25));
                        __NQS_A_fac = ((((__a_factrp *  1.25) * __NQS_xg1) -  1.0) * __NQS_xg1);
                        __NQS_xbar = ((temp / __a_factrp) * ((__NQS_A_fac * temp) +  1.0));
                        if ((abs((- __NQS_xbar)) <  230.258509299405)) begin
                          __NQS_temp = exp((- __NQS_xbar));
                        end
                        else begin
                          if (((- __NQS_xbar) <  0.0)) begin
                            __NQS_temp = ( 100.0e-102 / (((-230.258509299405 - (- __NQS_xbar)) * ((((-230.258509299405 - (- __NQS_xbar)) * (((-230.258509299405 - (- __NQS_xbar)) *  0.333333333333333) +  1.0)) *  0.5) +  1.0)) +  1.0));
                          end
                          else begin
                            __NQS_temp = (((((- __NQS_xbar) -  230.258509299405) * (((((- __NQS_xbar) -  230.258509299405) * ((((- __NQS_xbar) -  230.258509299405) *  0.333333333333333) +  1.0)) *  0.5) +  1.0)) +  1.0) *  10.0e+99);
                          end
                        end
                        __NQS_w = ( 1.0 - __NQS_temp);
                        __NQS_x0 = ((temp + (__Gp2 *  0.5)) - (__Gp * sqrt(((temp + (__Gp2 *  0.25)) - __NQS_w))));
                        if ((abs((- __NQS_x0)) <  230.258509299405)) begin
                          __NQS_D0 = exp((- __NQS_x0));
                        end
                        else begin
                          if (((- __NQS_x0) <  0.0)) begin
                            __NQS_D0 = ( 100.0e-102 / (((-230.258509299405 - (- __NQS_x0)) * ((((-230.258509299405 - (- __NQS_x0)) * (((-230.258509299405 - (- __NQS_x0)) *  0.333333333333333) +  1.0)) *  0.5) +  1.0)) +  1.0));
                          end
                          else begin
                            __NQS_D0 = (((((- __NQS_x0) -  230.258509299405) * (((((- __NQS_x0) -  230.258509299405) * ((((- __NQS_x0) -  230.258509299405) *  0.333333333333333) +  1.0)) *  0.5) +  1.0)) +  1.0) *  10.0e+99);
                          end
                        end
                        __NQS_xi = ( 1.0 - ((__Gp2 *  0.5) * __NQS_D0));
                        __NQS_p = (((temp - __NQS_x0) *  2.0) + (__Gp2 * ( 1.0 - __NQS_D0)));
                        __NQS_q = (((temp - __NQS_x0) * (temp - __NQS_x0)) - (__Gp2 * ((__NQS_x0 -  1.0) + __NQS_D0)));
                        __NQS_temp = ((__NQS_p * __NQS_p) - ((__NQS_xi *  4.0) * __NQS_q));
                        __NQS_u = ((__NQS_q *  2.0) / (__NQS_p + sqrt(__NQS_temp)));
                        __temp5 = (__NQS_x0 + __NQS_u);
                      end
                    end
                    temp = ((__Qp6 / __pd) + __xg_ac);
                    if ((abs(temp) <= __marginp)) begin
                      __temp6 = (temp / __a_factrp);
                    end
                    else begin
                      if ((temp < (- __marginp))) begin
                        __NQS_yg = (- temp);
                        __NQS_z = ((__NQS_yg *  1.25) / __a_factrp);
                        __NQS_eta = (((__NQS_z +  10.0) - sqrt((((__NQS_z -  6.0) * (__NQS_z -  6.0)) +  64.0))) *  0.5);
                        __NQS_a = (((__NQS_yg - __NQS_eta) * (__NQS_yg - __NQS_eta)) + (__Gp2 * (__NQS_eta +  1.0)));
                        __NQS_c = (((__NQS_yg - __NQS_eta) *  2.0) - __Gp2);
                        __NQS_tau = (ln((__NQS_a / __Gp2)) - __NQS_eta);
                        __nu = (__NQS_a + __NQS_c);
                        __mutau = ((__nu * __nu) + (__NQS_tau * (((__NQS_c * __NQS_c) *  0.5) - __NQS_a)));
                        __NQS_y0 = (__NQS_eta + (((__NQS_a * __nu) * __NQS_tau) / (__mutau + (((((__nu / __mutau) * __NQS_tau) * __NQS_tau) * __NQS_c) * (((__NQS_c * __NQS_c) *  0.333333333333333) - __NQS_a)))));
                        if ((abs(__NQS_y0) <  230.258509299405)) begin
                          __NQS_D0 = exp(__NQS_y0);
                        end
                        else begin
                          if ((__NQS_y0 <  0.0)) begin
                            __NQS_D0 = ( 100.0e-102 / (((-230.258509299405 - __NQS_y0) * ((((-230.258509299405 - __NQS_y0) * (((-230.258509299405 - __NQS_y0) *  0.333333333333333) +  1.0)) *  0.5) +  1.0)) +  1.0));
                          end
                          else begin
                            __NQS_D0 = ((((__NQS_y0 -  230.258509299405) * ((((__NQS_y0 -  230.258509299405) * (((__NQS_y0 -  230.258509299405) *  0.333333333333333) +  1.0)) *  0.5) +  1.0)) +  1.0) *  10.0e+99);
                          end
                        end
                        __NQS_xi = ( 1.0 - ((__Gp2 * __NQS_D0) *  0.5));
                        __NQS_p = (((__NQS_yg - __NQS_y0) *  2.0) + (__Gp2 * (__NQS_D0 -  1.0)));
                        __NQS_q = (((__NQS_yg - __NQS_y0) * (__NQS_yg - __NQS_y0)) + (__Gp2 * ((__NQS_y0 +  1.0) - __NQS_D0)));
                        __NQS_temp = ((__NQS_p * __NQS_p) - ((__NQS_xi *  4.0) * __NQS_q));
                        __NQS_w = ((__NQS_q *  2.0) / (__NQS_p + sqrt(__NQS_temp)));
                        __temp6 = (- (__NQS_y0 + __NQS_w));
                      end
                      else begin
                        __NQS_xg1 = ( 1.0 / ((__Gp *  0.732464877560822) +  1.25));
                        __NQS_A_fac = ((((__a_factrp *  1.25) * __NQS_xg1) -  1.0) * __NQS_xg1);
                        __NQS_xbar = ((temp / __a_factrp) * ((__NQS_A_fac * temp) +  1.0));
                        if ((abs((- __NQS_xbar)) <  230.258509299405)) begin
                          __NQS_temp = exp((- __NQS_xbar));
                        end
                        else begin
                          if (((- __NQS_xbar) <  0.0)) begin
                            __NQS_temp = ( 100.0e-102 / (((-230.258509299405 - (- __NQS_xbar)) * ((((-230.258509299405 - (- __NQS_xbar)) * (((-230.258509299405 - (- __NQS_xbar)) *  0.333333333333333) +  1.0)) *  0.5) +  1.0)) +  1.0));
                          end
                          else begin
                            __NQS_temp = (((((- __NQS_xbar) -  230.258509299405) * (((((- __NQS_xbar) -  230.258509299405) * ((((- __NQS_xbar) -  230.258509299405) *  0.333333333333333) +  1.0)) *  0.5) +  1.0)) +  1.0) *  10.0e+99);
                          end
                        end
                        __NQS_w = ( 1.0 - __NQS_temp);
                        __NQS_x0 = ((temp + (__Gp2 *  0.5)) - (__Gp * sqrt(((temp + (__Gp2 *  0.25)) - __NQS_w))));
                        if ((abs((- __NQS_x0)) <  230.258509299405)) begin
                          __NQS_D0 = exp((- __NQS_x0));
                        end
                        else begin
                          if (((- __NQS_x0) <  0.0)) begin
                            __NQS_D0 = ( 100.0e-102 / (((-230.258509299405 - (- __NQS_x0)) * ((((-230.258509299405 - (- __NQS_x0)) * (((-230.258509299405 - (- __NQS_x0)) *  0.333333333333333) +  1.0)) *  0.5) +  1.0)) +  1.0));
                          end
                          else begin
                            __NQS_D0 = (((((- __NQS_x0) -  230.258509299405) * (((((- __NQS_x0) -  230.258509299405) * ((((- __NQS_x0) -  230.258509299405) *  0.333333333333333) +  1.0)) *  0.5) +  1.0)) +  1.0) *  10.0e+99);
                          end
                        end
                        __NQS_xi = ( 1.0 - ((__Gp2 *  0.5) * __NQS_D0));
                        __NQS_p = (((temp - __NQS_x0) *  2.0) + (__Gp2 * ( 1.0 - __NQS_D0)));
                        __NQS_q = (((temp - __NQS_x0) * (temp - __NQS_x0)) - (__Gp2 * ((__NQS_x0 -  1.0) + __NQS_D0)));
                        __NQS_temp = ((__NQS_p * __NQS_p) - ((__NQS_xi *  4.0) * __NQS_q));
                        __NQS_u = ((__NQS_q *  2.0) / (__NQS_p + sqrt(__NQS_temp)));
                        __temp6 = (__NQS_x0 + __NQS_u);
                      end
                    end
                    temp = ((__Qp7 / __pd) + __xg_ac);
                    if ((abs(temp) <= __marginp)) begin
                      __temp7 = (temp / __a_factrp);
                    end
                    else begin
                      if ((temp < (- __marginp))) begin
                        __NQS_yg = (- temp);
                        __NQS_z = ((__NQS_yg *  1.25) / __a_factrp);
                        __NQS_eta = (((__NQS_z +  10.0) - sqrt((((__NQS_z -  6.0) * (__NQS_z -  6.0)) +  64.0))) *  0.5);
                        __NQS_a = (((__NQS_yg - __NQS_eta) * (__NQS_yg - __NQS_eta)) + (__Gp2 * (__NQS_eta +  1.0)));
                        __NQS_c = (((__NQS_yg - __NQS_eta) *  2.0) - __Gp2);
                        __NQS_tau = (ln((__NQS_a / __Gp2)) - __NQS_eta);
                        __nu = (__NQS_a + __NQS_c);
                        __mutau = ((__nu * __nu) + (__NQS_tau * (((__NQS_c * __NQS_c) *  0.5) - __NQS_a)));
                        __NQS_y0 = (__NQS_eta + (((__NQS_a * __nu) * __NQS_tau) / (__mutau + (((((__nu / __mutau) * __NQS_tau) * __NQS_tau) * __NQS_c) * (((__NQS_c * __NQS_c) *  0.333333333333333) - __NQS_a)))));
                        if ((abs(__NQS_y0) <  230.258509299405)) begin
                          __NQS_D0 = exp(__NQS_y0);
                        end
                        else begin
                          if ((__NQS_y0 <  0.0)) begin
                            __NQS_D0 = ( 100.0e-102 / (((-230.258509299405 - __NQS_y0) * ((((-230.258509299405 - __NQS_y0) * (((-230.258509299405 - __NQS_y0) *  0.333333333333333) +  1.0)) *  0.5) +  1.0)) +  1.0));
                          end
                          else begin
                            __NQS_D0 = ((((__NQS_y0 -  230.258509299405) * ((((__NQS_y0 -  230.258509299405) * (((__NQS_y0 -  230.258509299405) *  0.333333333333333) +  1.0)) *  0.5) +  1.0)) +  1.0) *  10.0e+99);
                          end
                        end
                        __NQS_xi = ( 1.0 - ((__Gp2 * __NQS_D0) *  0.5));
                        __NQS_p = (((__NQS_yg - __NQS_y0) *  2.0) + (__Gp2 * (__NQS_D0 -  1.0)));
                        __NQS_q = (((__NQS_yg - __NQS_y0) * (__NQS_yg - __NQS_y0)) + (__Gp2 * ((__NQS_y0 +  1.0) - __NQS_D0)));
                        __NQS_temp = ((__NQS_p * __NQS_p) - ((__NQS_xi *  4.0) * __NQS_q));
                        __NQS_w = ((__NQS_q *  2.0) / (__NQS_p + sqrt(__NQS_temp)));
                        __temp7 = (- (__NQS_y0 + __NQS_w));
                      end
                      else begin
                        __NQS_xg1 = ( 1.0 / ((__Gp *  0.732464877560822) +  1.25));
                        __NQS_A_fac = ((((__a_factrp *  1.25) * __NQS_xg1) -  1.0) * __NQS_xg1);
                        __NQS_xbar = ((temp / __a_factrp) * ((__NQS_A_fac * temp) +  1.0));
                        if ((abs((- __NQS_xbar)) <  230.258509299405)) begin
                          __NQS_temp = exp((- __NQS_xbar));
                        end
                        else begin
                          if (((- __NQS_xbar) <  0.0)) begin
                            __NQS_temp = ( 100.0e-102 / (((-230.258509299405 - (- __NQS_xbar)) * ((((-230.258509299405 - (- __NQS_xbar)) * (((-230.258509299405 - (- __NQS_xbar)) *  0.333333333333333) +  1.0)) *  0.5) +  1.0)) +  1.0));
                          end
                          else begin
                            __NQS_temp = (((((- __NQS_xbar) -  230.258509299405) * (((((- __NQS_xbar) -  230.258509299405) * ((((- __NQS_xbar) -  230.258509299405) *  0.333333333333333) +  1.0)) *  0.5) +  1.0)) +  1.0) *  10.0e+99);
                          end
                        end
                        __NQS_w = ( 1.0 - __NQS_temp);
                        __NQS_x0 = ((temp + (__Gp2 *  0.5)) - (__Gp * sqrt(((temp + (__Gp2 *  0.25)) - __NQS_w))));
                        if ((abs((- __NQS_x0)) <  230.258509299405)) begin
                          __NQS_D0 = exp((- __NQS_x0));
                        end
                        else begin
                          if (((- __NQS_x0) <  0.0)) begin
                            __NQS_D0 = ( 100.0e-102 / (((-230.258509299405 - (- __NQS_x0)) * ((((-230.258509299405 - (- __NQS_x0)) * (((-230.258509299405 - (- __NQS_x0)) *  0.333333333333333) +  1.0)) *  0.5) +  1.0)) +  1.0));
                          end
                          else begin
                            __NQS_D0 = (((((- __NQS_x0) -  230.258509299405) * (((((- __NQS_x0) -  230.258509299405) * ((((- __NQS_x0) -  230.258509299405) *  0.333333333333333) +  1.0)) *  0.5) +  1.0)) +  1.0) *  10.0e+99);
                          end
                        end
                        __NQS_xi = ( 1.0 - ((__Gp2 *  0.5) * __NQS_D0));
                        __NQS_p = (((temp - __NQS_x0) *  2.0) + (__Gp2 * ( 1.0 - __NQS_D0)));
                        __NQS_q = (((temp - __NQS_x0) * (temp - __NQS_x0)) - (__Gp2 * ((__NQS_x0 -  1.0) + __NQS_D0)));
                        __NQS_temp = ((__NQS_p * __NQS_p) - ((__NQS_xi *  4.0) * __NQS_q));
                        __NQS_u = ((__NQS_q *  2.0) / (__NQS_p + sqrt(__NQS_temp)));
                        __temp7 = (__NQS_x0 + __NQS_u);
                      end
                    end
                    temp = ((__Qp8 / __pd) + __xg_ac);
                    if ((abs(temp) <= __marginp)) begin
                      __temp8 = (temp / __a_factrp);
                    end
                    else begin
                      if ((temp < (- __marginp))) begin
                        __NQS_yg = (- temp);
                        __NQS_z = ((__NQS_yg *  1.25) / __a_factrp);
                        __NQS_eta = (((__NQS_z +  10.0) - sqrt((((__NQS_z -  6.0) * (__NQS_z -  6.0)) +  64.0))) *  0.5);
                        __NQS_a = (((__NQS_yg - __NQS_eta) * (__NQS_yg - __NQS_eta)) + (__Gp2 * (__NQS_eta +  1.0)));
                        __NQS_c = (((__NQS_yg - __NQS_eta) *  2.0) - __Gp2);
                        __NQS_tau = (ln((__NQS_a / __Gp2)) - __NQS_eta);
                        __nu = (__NQS_a + __NQS_c);
                        __mutau = ((__nu * __nu) + (__NQS_tau * (((__NQS_c * __NQS_c) *  0.5) - __NQS_a)));
                        __NQS_y0 = (__NQS_eta + (((__NQS_a * __nu) * __NQS_tau) / (__mutau + (((((__nu / __mutau) * __NQS_tau) * __NQS_tau) * __NQS_c) * (((__NQS_c * __NQS_c) *  0.333333333333333) - __NQS_a)))));
                        if ((abs(__NQS_y0) <  230.258509299405)) begin
                          __NQS_D0 = exp(__NQS_y0);
                        end
                        else begin
                          if ((__NQS_y0 <  0.0)) begin
                            __NQS_D0 = ( 100.0e-102 / (((-230.258509299405 - __NQS_y0) * ((((-230.258509299405 - __NQS_y0) * (((-230.258509299405 - __NQS_y0) *  0.333333333333333) +  1.0)) *  0.5) +  1.0)) +  1.0));
                          end
                          else begin
                            __NQS_D0 = ((((__NQS_y0 -  230.258509299405) * ((((__NQS_y0 -  230.258509299405) * (((__NQS_y0 -  230.258509299405) *  0.333333333333333) +  1.0)) *  0.5) +  1.0)) +  1.0) *  10.0e+99);
                          end
                        end
                        __NQS_xi = ( 1.0 - ((__Gp2 * __NQS_D0) *  0.5));
                        __NQS_p = (((__NQS_yg - __NQS_y0) *  2.0) + (__Gp2 * (__NQS_D0 -  1.0)));
                        __NQS_q = (((__NQS_yg - __NQS_y0) * (__NQS_yg - __NQS_y0)) + (__Gp2 * ((__NQS_y0 +  1.0) - __NQS_D0)));
                        __NQS_temp = ((__NQS_p * __NQS_p) - ((__NQS_xi *  4.0) * __NQS_q));
                        __NQS_w = ((__NQS_q *  2.0) / (__NQS_p + sqrt(__NQS_temp)));
                        __temp8 = (- (__NQS_y0 + __NQS_w));
                      end
                      else begin
                        __NQS_xg1 = ( 1.0 / ((__Gp *  0.732464877560822) +  1.25));
                        __NQS_A_fac = ((((__a_factrp *  1.25) * __NQS_xg1) -  1.0) * __NQS_xg1);
                        __NQS_xbar = ((temp / __a_factrp) * ((__NQS_A_fac * temp) +  1.0));
                        if ((abs((- __NQS_xbar)) <  230.258509299405)) begin
                          __NQS_temp = exp((- __NQS_xbar));
                        end
                        else begin
                          if (((- __NQS_xbar) <  0.0)) begin
                            __NQS_temp = ( 100.0e-102 / (((-230.258509299405 - (- __NQS_xbar)) * ((((-230.258509299405 - (- __NQS_xbar)) * (((-230.258509299405 - (- __NQS_xbar)) *  0.333333333333333) +  1.0)) *  0.5) +  1.0)) +  1.0));
                          end
                          else begin
                            __NQS_temp = (((((- __NQS_xbar) -  230.258509299405) * (((((- __NQS_xbar) -  230.258509299405) * ((((- __NQS_xbar) -  230.258509299405) *  0.333333333333333) +  1.0)) *  0.5) +  1.0)) +  1.0) *  10.0e+99);
                          end
                        end
                        __NQS_w = ( 1.0 - __NQS_temp);
                        __NQS_x0 = ((temp + (__Gp2 *  0.5)) - (__Gp * sqrt(((temp + (__Gp2 *  0.25)) - __NQS_w))));
                        if ((abs((- __NQS_x0)) <  230.258509299405)) begin
                          __NQS_D0 = exp((- __NQS_x0));
                        end
                        else begin
                          if (((- __NQS_x0) <  0.0)) begin
                            __NQS_D0 = ( 100.0e-102 / (((-230.258509299405 - (- __NQS_x0)) * ((((-230.258509299405 - (- __NQS_x0)) * (((-230.258509299405 - (- __NQS_x0)) *  0.333333333333333) +  1.0)) *  0.5) +  1.0)) +  1.0));
                          end
                          else begin
                            __NQS_D0 = (((((- __NQS_x0) -  230.258509299405) * (((((- __NQS_x0) -  230.258509299405) * ((((- __NQS_x0) -  230.258509299405) *  0.333333333333333) +  1.0)) *  0.5) +  1.0)) +  1.0) *  10.0e+99);
                          end
                        end
                        __NQS_xi = ( 1.0 - ((__Gp2 *  0.5) * __NQS_D0));
                        __NQS_p = (((temp - __NQS_x0) *  2.0) + (__Gp2 * ( 1.0 - __NQS_D0)));
                        __NQS_q = (((temp - __NQS_x0) * (temp - __NQS_x0)) - (__Gp2 * ((__NQS_x0 -  1.0) + __NQS_D0)));
                        __NQS_temp = ((__NQS_p * __NQS_p) - ((__NQS_xi *  4.0) * __NQS_q));
                        __NQS_u = ((__NQS_q *  2.0) / (__NQS_p + sqrt(__NQS_temp)));
                        __temp8 = (__NQS_x0 + __NQS_u);
                      end
                    end
                    temp = ((__Qp9 / __pd) + __xg_ac);
                    if ((abs(temp) <= __marginp)) begin
                      __temp9 = (temp / __a_factrp);
                    end
                    else begin
                      if ((temp < (- __marginp))) begin
                        __NQS_yg = (- temp);
                        __NQS_z = ((__NQS_yg *  1.25) / __a_factrp);
                        __NQS_eta = (((__NQS_z +  10.0) - sqrt((((__NQS_z -  6.0) * (__NQS_z -  6.0)) +  64.0))) *  0.5);
                        __NQS_a = (((__NQS_yg - __NQS_eta) * (__NQS_yg - __NQS_eta)) + (__Gp2 * (__NQS_eta +  1.0)));
                        __NQS_c = (((__NQS_yg - __NQS_eta) *  2.0) - __Gp2);
                        __NQS_tau = (ln((__NQS_a / __Gp2)) - __NQS_eta);
                        __nu = (__NQS_a + __NQS_c);
                        __mutau = ((__nu * __nu) + (__NQS_tau * (((__NQS_c * __NQS_c) *  0.5) - __NQS_a)));
                        __NQS_y0 = (__NQS_eta + (((__NQS_a * __nu) * __NQS_tau) / (__mutau + (((((__nu / __mutau) * __NQS_tau) * __NQS_tau) * __NQS_c) * (((__NQS_c * __NQS_c) *  0.333333333333333) - __NQS_a)))));
                        if ((abs(__NQS_y0) <  230.258509299405)) begin
                          __NQS_D0 = exp(__NQS_y0);
                        end
                        else begin
                          if ((__NQS_y0 <  0.0)) begin
                            __NQS_D0 = ( 100.0e-102 / (((-230.258509299405 - __NQS_y0) * ((((-230.258509299405 - __NQS_y0) * (((-230.258509299405 - __NQS_y0) *  0.333333333333333) +  1.0)) *  0.5) +  1.0)) +  1.0));
                          end
                          else begin
                            __NQS_D0 = ((((__NQS_y0 -  230.258509299405) * ((((__NQS_y0 -  230.258509299405) * (((__NQS_y0 -  230.258509299405) *  0.333333333333333) +  1.0)) *  0.5) +  1.0)) +  1.0) *  10.0e+99);
                          end
                        end
                        __NQS_xi = ( 1.0 - ((__Gp2 * __NQS_D0) *  0.5));
                        __NQS_p = (((__NQS_yg - __NQS_y0) *  2.0) + (__Gp2 * (__NQS_D0 -  1.0)));
                        __NQS_q = (((__NQS_yg - __NQS_y0) * (__NQS_yg - __NQS_y0)) + (__Gp2 * ((__NQS_y0 +  1.0) - __NQS_D0)));
                        __NQS_temp = ((__NQS_p * __NQS_p) - ((__NQS_xi *  4.0) * __NQS_q));
                        __NQS_w = ((__NQS_q *  2.0) / (__NQS_p + sqrt(__NQS_temp)));
                        __temp9 = (- (__NQS_y0 + __NQS_w));
                      end
                      else begin
                        __NQS_xg1 = ( 1.0 / ((__Gp *  0.732464877560822) +  1.25));
                        __NQS_A_fac = ((((__a_factrp *  1.25) * __NQS_xg1) -  1.0) * __NQS_xg1);
                        __NQS_xbar = ((temp / __a_factrp) * ((__NQS_A_fac * temp) +  1.0));
                        if ((abs((- __NQS_xbar)) <  230.258509299405)) begin
                          __NQS_temp = exp((- __NQS_xbar));
                        end
                        else begin
                          if (((- __NQS_xbar) <  0.0)) begin
                            __NQS_temp = ( 100.0e-102 / (((-230.258509299405 - (- __NQS_xbar)) * ((((-230.258509299405 - (- __NQS_xbar)) * (((-230.258509299405 - (- __NQS_xbar)) *  0.333333333333333) +  1.0)) *  0.5) +  1.0)) +  1.0));
                          end
                          else begin
                            __NQS_temp = (((((- __NQS_xbar) -  230.258509299405) * (((((- __NQS_xbar) -  230.258509299405) * ((((- __NQS_xbar) -  230.258509299405) *  0.333333333333333) +  1.0)) *  0.5) +  1.0)) +  1.0) *  10.0e+99);
                          end
                        end
                        __NQS_w = ( 1.0 - __NQS_temp);
                        __NQS_x0 = ((temp + (__Gp2 *  0.5)) - (__Gp * sqrt(((temp + (__Gp2 *  0.25)) - __NQS_w))));
                        if ((abs((- __NQS_x0)) <  230.258509299405)) begin
                          __NQS_D0 = exp((- __NQS_x0));
                        end
                        else begin
                          if (((- __NQS_x0) <  0.0)) begin
                            __NQS_D0 = ( 100.0e-102 / (((-230.258509299405 - (- __NQS_x0)) * ((((-230.258509299405 - (- __NQS_x0)) * (((-230.258509299405 - (- __NQS_x0)) *  0.333333333333333) +  1.0)) *  0.5) +  1.0)) +  1.0));
                          end
                          else begin
                            __NQS_D0 = (((((- __NQS_x0) -  230.258509299405) * (((((- __NQS_x0) -  230.258509299405) * ((((- __NQS_x0) -  230.258509299405) *  0.333333333333333) +  1.0)) *  0.5) +  1.0)) +  1.0) *  10.0e+99);
                          end
                        end
                        __NQS_xi = ( 1.0 - ((__Gp2 *  0.5) * __NQS_D0));
                        __NQS_p = (((temp - __NQS_x0) *  2.0) + (__Gp2 * ( 1.0 - __NQS_D0)));
                        __NQS_q = (((temp - __NQS_x0) * (temp - __NQS_x0)) - (__Gp2 * ((__NQS_x0 -  1.0) + __NQS_D0)));
                        __NQS_temp = ((__NQS_p * __NQS_p) - ((__NQS_xi *  4.0) * __NQS_q));
                        __NQS_u = ((__NQS_q *  2.0) / (__NQS_p + sqrt(__NQS_temp)));
                        __temp9 = (__NQS_x0 + __NQS_u);
                      end
                    end
                    __QG_NQS = (__xg_ac - ((((__x_sp + (((((temp1 + __temp3) + __temp5) + __temp7) + __temp9) *  4.0)) + ((((temp2 + __temp4) + __temp6) + __temp8) *  2.0)) + __x_dp) /  30.0));
                  end
                end
              end
            end
          end
          __QG_NQS = (__pd * __QG_NQS);
          if ((sigVds > 0)) begin
            __Qs = ((COX_qm * phit1) * __QS_NQS);
            __Qd = ((COX_qm * phit1) * __QD_NQS);
          end
          else begin
            __Qs = ((COX_qm * phit1) * __QD_NQS);
            __Qd = ((COX_qm * phit1) * __QS_NQS);
          end
          __Qg = ((COX_qm * phit1) * __QG_NQS);
          __Qb = (((- __Qg) - __Qs) - __Qd);
        end
        V(RES1) <+ ((__vnorm_inv * I(RES1)) * __r_nqs);
        V(SPLINE1) <+ (__vnorm_inv * idt(((- __Tnorm) * __fk1), __Qp1_0));
        V(RES2) <+ ((__vnorm_inv * I(RES2)) * __r_nqs);
        V(SPLINE2) <+ (__vnorm_inv * idt(((- __Tnorm) * __fk2), __Qp2_0));
        V(RES3) <+ ((__vnorm_inv * I(RES3)) * __r_nqs);
        V(SPLINE3) <+ (__vnorm_inv * idt(((- __Tnorm) * __fk3), __Qp3_0));
        V(RES4) <+ ((__vnorm_inv * I(RES4)) * __r_nqs);
        V(SPLINE4) <+ (__vnorm_inv * idt(((- __Tnorm) * __fk4), __Qp4_0));
        V(RES5) <+ ((__vnorm_inv * I(RES5)) * __r_nqs);
        V(SPLINE5) <+ (__vnorm_inv * idt(((- __Tnorm) * __fk5), __Qp5_0));
        V(RES6) <+ ((__vnorm_inv * I(RES6)) * __r_nqs);
        V(SPLINE6) <+ (__vnorm_inv * idt(((- __Tnorm) * __fk6), __Qp6_0));
        V(RES7) <+ ((__vnorm_inv * I(RES7)) * __r_nqs);
        V(SPLINE7) <+ (__vnorm_inv * idt(((- __Tnorm) * __fk7), __Qp7_0));
        V(RES8) <+ ((__vnorm_inv * I(RES8)) * __r_nqs);
        V(SPLINE8) <+ (__vnorm_inv * idt(((- __Tnorm) * __fk8), __Qp8_0));
        V(RES9) <+ ((__vnorm_inv * I(RES9)) * __r_nqs);
        V(SPLINE9) <+ (__vnorm_inv * idt(((- __Tnorm) * __fk9), __Qp9_0));
      end
      begin : loadDynamic
        real temp;
        __Qs = (- ((__Qg + __Qb) + __Qd));
        __Qfgs = (__Qfgs + __Qgs_ov);
        __Qfgd = (__Qfgd + __Qgd_ov);
        qjun_s = (((__ABSOURCE_i * qjunbot_s) + (__LSSOURCE_i * qjunsti_s)) + (__LGSOURCE_i * qjungat_s));
        qjun_d = (((__ABDRAIN_i * qjunbot_d) + (__LSDRAIN_i * qjunsti_d)) + (__LGDRAIN_i * qjungat_d));
        if ((sigVds <  0.0)) begin
          temp = __Qd;
          __Qd = __Qs;
          __Qs = temp;
        end
        I(GP, SI) <+ ddt(((__CHNL_TYPE * __MULT_i) * __Qg));
        I(BP, SI) <+ ddt(((__CHNL_TYPE * __MULT_i) * __Qb));
        I(DI, SI) <+ ddt(((__CHNL_TYPE * __MULT_i) * __Qd));
        I(GP, SI) <+ ddt(((__CHNL_TYPE * __MULT_i) * __Qfgs));
        I(GP, DI) <+ ddt(((__CHNL_TYPE * __MULT_i) * __Qfgd));
        I(GP, BP) <+ ddt(((__CHNL_TYPE * __MULT_i) * __Qgb_ov));
        I(BS, SI) <+ ddt(((__CHNL_TYPE * __MULT_i) * qjun_s));
        I(BD, DI) <+ ddt(((__CHNL_TYPE * __MULT_i) * qjun_d));
      end
      begin : noise
        __Sfl =  0.0;
        __Sidexc =  0.0;
        __mid =  0.0;
        __mig =  100.0e-42;
        __migid =  0.0;
        __c_igid =  0.0;
        __CGeff = (COX_qm * eta_p_ac);
        __sqid =  0.0;
        __sqig =  0.0;
        Sfledge =  0.0;
        midedge =  0.0;
        sqidedge =  0.0;
        if ((((xg_dc >  0.0) && (__MULT_i >  0.0)) && (__BET_i >  0.0))) begin
          __N1 = ((__Cox_over_q * alpha_dc) * __phit);
          __Nm1 = (__Cox_over_q * qim1_dc);
          __Delta_N1 = ((__Cox_over_q * alpha_dc) * dps_dc);
          __Sfl = (((__NFA_i - (__NFB_i * __N1)) + (__NFC_i * (__N1 * __N1))) * ln(((__Nm1 + (__Delta_N1 *  0.5)) / (__Nm1 - (__Delta_N1 *  0.5)))));
          __Sfl = (__Sfl + ((__NFB_i + (__NFC_i * (__Nm1 - (__N1 *  2.0)))) * __Delta_N1));
          __Sfl = ((((__Sfl_prefac * Ids) * Gvsatinv_dc) * __Sfl) / __N1);
          __Sfl = (((__Sfl >  0.0))? (__Sfl):( 0.0));
          H0 = (qim1_dc / alpha_dc);
          __t1 = (qim_dc / qim1_dc);
          __sqt2 = ((dps_dc / H0) *  0.0833333333333333);
          __t2 = (__sqt2 * __sqt2);
          __r = ((H0 / H_dc) -  1.0);
          __lc = (((( 1.0 - ((__r * __t2) *  12.0)) >  10.0e-21))? (( 1.0 - ((__r * __t2) *  12.0))):( 10.0e-21));
          __lcinv2 = ( 1.0 / (__lc * __lc));
          __g_ideal = (__BET_i * ((FdL_dc * qim1_dc) * Gvsatinv_dc));
          __mid = ((__t1 + (__t2 *  12.0)) - ((((__t1 +  1.0) * __t2) * __r) *  24.0));
          __mid = (((__mid >  100.0e-42))? (__mid):( 100.0e-42));
          __mid = ((__g_ideal * __lcinv2) * __mid);
          if ((__FNTEXC_i >  0.0)) begin
            __temp2_exc = (qim_dc * xitsb_dc);
            __wsat_exc = ((__temp2_exc / (__temp2_exc +  100.0)) *  100.0);
            if ((__THESATG_i < 0)) begin
              __temp_exc = ( 1.0 / ( 1.0 - (__THESATG_i * __wsat_exc)));
            end
            else begin
              __temp_exc = ((__THESATG_i * __wsat_exc) +  1.0);
            end
            __thesat1_exc = (__THESAT_T * (__temp_exc / Gmob_dc));
            __zsat_exc = (((__thesat1_exc * __thesat1_exc) * dps_dc) * dps_dc);
            if ((__CHNL_TYPE == -1)) begin
              __zsat_exc = (__zsat_exc / ((__thesat1_exc * dps_dc) +  1.0));
            end
            __Gvsat_exc = ((Gmob_dc * (sqrt(((__zsat_exc *  2.0) +  1.0)) +  1.0)) *  0.5);
            __gfac = (Gmob_dc / (__Gvsat_exc * __lc));
            __Sidexc = ((((__fac_exc * Ids) * Vdse_dc) * __gfac) * __gfac);
            __mid = (__mid + (__Sidexc / __nt0));
          end
          __sqid = sqrt((__nt * __mid));
          if ((1 && (__nt >  0.0))) begin
            __mig = (((__t1 /  12.0) - (__t2 * ((__t1 +  0.2) - (__t2 *  12.0)))) - (((__t2 * ((__t1 +  1.0) - (__t2 *  12.0))) * __r) *  1.6));
            __mig = (((__mig >  100.0e-42))? (__mig):( 100.0e-42));
            __mig = ((__lcinv2 / __g_ideal) * __mig);
            __migid0 = ((__lcinv2 * __sqt2) * (( 1.0 - (__t2 *  12.0)) - (((__t1 + (__t2 *  19.2)) - ((__t1 * __t2) *  12.0)) * __r)));
            __CGeff = ((((Gvsat_ac * Gvsat_ac) * COX_qm) * eta_p_ac) / (Gmob_dL_ac * Gmob_dL_ac));
            if ((__FNTEXC_i >  0.0)) begin
              __mig = (__mig + ((__Sidexc * ((__t2 *  12.0) +  1.0)) / (((__g_ideal *  12.0) * __g_ideal) * __nt0)));
              __migid0 = (__migid0 - (((__Sidexc * __sqt2) * (__r +  1.0)) / (__g_ideal * __nt0)));
            end
            __sqig = sqrt((__nt / __mig));
            if ((__sqid <= 0)) begin
              __c_igid =  0.0;
            end
            else begin
              __c_igid = ((__migid0 * __sqig) / __sqid);
            end
            __c_igid = (((__c_igid >  0.0))? ((((__c_igid <  1.0))? (__c_igid):( 1.0))):( 0.0));
            __migid = ((__c_igid * __sqid) / __sqig);
          end
        end
        __shot_igcsx = (abs(Igcs) *  320.43836e-21);
        __shot_igcdx = (abs(Igcd) *  320.43836e-21);
        __shot_igsov = (abs(Igsov) *  320.43836e-21);
        __shot_igdov = (abs(Igdov) *  320.43836e-21);
        __shot_iavl = (((mavl + 1) * abs(Iimpact)) *  320.43836e-21);
        __jnoisex_s = (abs(ijun_s) *  320.43836e-21);
        __jnoisex_d = (abs(ijun_d) *  320.43836e-21);
        if ((sigVds >  0.0)) begin
          __shot_igs = (__shot_igcsx + __shot_igsov);
          __shot_igd = (__shot_igcdx + __shot_igdov);
          jnoise_s = __jnoisex_s;
          jnoise_d = (__jnoisex_d + __shot_iavl);
        end
        else begin
          __shot_igs = (__shot_igcdx + __shot_igsov);
          __shot_igd = (__shot_igcsx + __shot_igdov);
          jnoise_s = (__jnoisex_s + __shot_iavl);
          jnoise_d = __jnoisex_d;
        end
        if (0) begin
          if ((temp1 >  100.0e-12)) begin
          end
        end
        I(NOII) <+ white_noise((__nt / __mig), "igig");
        I(NOIR) <+ (V(NOIR) / __mig);
        I(NOIC) <+ ddt((__CGeff * V(NOIC)));
        I(GP, SI) <+ (- ddt((((sqrt(__MULT_i) *  0.5) * __CGeff) * V(NOIC))));
        I(GP, DI) <+ (- ddt((((sqrt(__MULT_i) *  0.5) * __CGeff) * V(NOIC))));
        I(DI, SI) <+ (((sigVds * sqrt(__MULT_i)) * __migid) * I(NOII));
        I(DI, SI) <+ white_noise((((__MULT_i * __sqid) * __sqid) * ( 1.0 - (__c_igid * __c_igid))), "idid");
        I(DI, SI) <+ flicker_noise(((sigVds * __MULT_i) * __Sfl), __EF_i, "flicker");
        I(GP, SI) <+ white_noise((__MULT_i * __shot_igs), "igs");
        I(GP, DI) <+ white_noise((__MULT_i * __shot_igd), "igd");
        I(BS, SI) <+ white_noise((__MULT_i * jnoise_s), "ibs");
        I(BD, DI) <+ white_noise((__MULT_i * jnoise_d), "ibd");
        I(DI, SI) <+ flicker_noise(((sigVds * __MULT_i) * Sfledge), __EFEDGE_i, "flicker");
        I(DI, SI) <+ white_noise(((__MULT_i * sqidedge) * sqidedge), "ididedge");
      end
      begin : OPinfo
        __id_op = (((Ids + Idsedge) + Iimpact) - Igcd);
        __is = (((- Ids) - Idsedge) - Igcs);
        __ig = ((((Igcs + Igcd) + Igsov) + Igdov) + __Igb);
        __ib = ((((- Iimpact) - __Igb) - __Igidl) - __Igisl);
        __sig1k = (__CGeff *  6.28318530717959e+3);
        __sig1k = ((__sig1k * __sig1k) * __mig);
        __sdint = sigVds;
        __ctype = __CHNL_TYPE;
        if ((sigVds <  0.0)) begin
          __ise = (__MULT_i * (((__is - Igdov) + __Igidl) - ijun_d));
          __ige = (__MULT_i * __ig);
          __ide = (__MULT_i * (((__id_op - Igsov) + __Igisl) - ijun_s));
          __ibe = (__MULT_i * ((__ib + ijun_s) + ijun_d));
          __ids = (__MULT_i * Ids);
          __idb = (__MULT_i * ((Iimpact + __Igisl) - ijun_s));
          __isb = (__MULT_i * (__Igidl - ijun_d));
          __igs = (__MULT_i * (Igcs + Igdov));
          __igd = (__MULT_i * (Igcd + Igsov));
          __igb = (__MULT_i * __Igb);
          __idedge = (__MULT_i * Idsedge);
          __igcs = (__MULT_i * Igcs);
          __igcd = (__MULT_i * Igcd);
          __iavl = (__MULT_i * Iimpact);
          __igisl = (__MULT_i * __Igidl);
          __igidl = (__MULT_i * __Igisl);
          if ((__SWJUNEXP_i == 1)) begin
            __ijsbot =  0.0;
            __ijsgat =  0.0;
            __ijssti =  0.0;
            __ijdbot =  0.0;
            __ijdgat =  0.0;
            __ijdsti =  0.0;
            __idsatsbot =  0.0;
            __idsatssti =  0.0;
            __idsatsgat =  0.0;
            __idsatsbotd =  0.0;
            __idsatsstid =  0.0;
            __idsatsgatd =  0.0;
          end
          else begin
            __ijsbot = ((__MULT_i * __ABDRAIN_i) * ijunbot_d);
            __ijsgat = ((__MULT_i * __LGDRAIN_i) * ijungat_d);
            __ijssti = ((__MULT_i * __LSDRAIN_i) * ijunsti_d);
            __ijdbot = ((__MULT_i * __ABSOURCE_i) * ijunbot_s);
            __ijdgat = ((__MULT_i * __LGSOURCE_i) * ijungat_s);
            __ijdsti = ((__MULT_i * __LSSOURCE_i) * ijunsti_s);
            __idsatsbot = ((__MULT_i * __ABSOURCE_i) * __idsatbot);
            __idsatssti = ((__MULT_i * __LSSOURCE_i) * __idsatsti);
            __idsatsgat = ((__MULT_i * __LGSOURCE_i) * __idsatgat);
            __idsatsbotd = ((__MULT_i * __ABDRAIN_i) * __idsatbot_d);
            __idsatsstid = ((__MULT_i * __LSDRAIN_i) * __idsatsti_d);
            __idsatsgatd = ((__MULT_i * __LGDRAIN_i) * __idsatgat_d);
          end
          __ijs = (__MULT_i * ijun_d);
          __ijd = (__MULT_i * ijun_s);
          __vds = __Vds;
          __vgs = __Vgs;
          __vsb = __Vsb;
          __vto = ((__VFB_T + (__P_D * __facvsb0)) + (__Gf_dc * sqrt((phit1 * __facvsb0))));
          __vts = __vts_i;
          __vth = __vth_i;
          __vgt = (__vgs - __vth);
          __vdss = __Vdsat_dc;
          __vsat = (__Vds - __vdss);
          __ids_i = ((((((Ids + Idsedge) + Iimpact) + __Igisl) - Igcs) - Igsov) - ijun_s);
          __gm = ((__CHNL_TYPE * __MULT_i) * ddx(__ids_i, V(GP)));
          __gmb = ((__CHNL_TYPE * __MULT_i) * ddx(__ids_i, V(BP)));
          __gds = ((__CHNL_TYPE * __MULT_i) * ddx(__ids_i, V(SI)));
          __gjs = (__MULT_i * ddx(ijun_d, V(BD)));
          __gjd = (__MULT_i * ddx(ijun_s, V(BS)));
          __css = ((__CHNL_TYPE * __MULT_i) * ddx(__Qd, V(DI)));
          __csg = (((- __CHNL_TYPE) * __MULT_i) * ddx(__Qd, V(GP)));
          __csb = (((- __CHNL_TYPE) * __MULT_i) * ddx(__Qd, V(BP)));
          __csd = ((__css - __csg) - __csb);
          __cgs = (((- __CHNL_TYPE) * __MULT_i) * ddx(__Qg, V(DI)));
          __cgg = ((__CHNL_TYPE * __MULT_i) * ddx(__Qg, V(GP)));
          __cgb = (((- __CHNL_TYPE) * __MULT_i) * ddx(__Qg, V(BP)));
          __cgd = ((__cgg - __cgs) - __cgb);
          __cds = (((- __CHNL_TYPE) * __MULT_i) * ddx(__Qs, V(DI)));
          __cdg = (((- __CHNL_TYPE) * __MULT_i) * ddx(__Qs, V(GP)));
          __cdb = (((- __CHNL_TYPE) * __MULT_i) * ddx(__Qs, V(BP)));
          __cdd = ((__cdg + __cds) + __cdb);
          __cbs = (((- __CHNL_TYPE) * __MULT_i) * ddx(__Qb, V(DI)));
          __cbg = (((- __CHNL_TYPE) * __MULT_i) * ddx(__Qb, V(GP)));
          __cbb = ((__CHNL_TYPE * __MULT_i) * ddx(__Qb, V(BP)));
          __cbd = ((__cbb - __cbs) - __cbg);
          __cgsol = ((__CHNL_TYPE * __MULT_i) * ddx(__Qfgd, V(GP)));
          __cgdol = ((__CHNL_TYPE * __MULT_i) * ddx(__Qfgs, V(GP)));
          __cjsbot = ((((- __MULT_i) * __CHNL_TYPE) * __ABDRAIN_i) * ddx(qjunbot_d, V(DI)));
          __cjsgat = ((((- __MULT_i) * __CHNL_TYPE) * __LGDRAIN_i) * ddx(qjungat_d, V(DI)));
          __cjssti = ((((- __MULT_i) * __CHNL_TYPE) * __LSDRAIN_i) * ddx(qjunsti_d, V(DI)));
          __cjs = ((__cjsbot + __cjsgat) + __cjssti);
          __cjdbot = ((((- __MULT_i) * __CHNL_TYPE) * __ABSOURCE_i) * ddx(qjunbot_s, V(SI)));
          __cjdgat = ((((- __MULT_i) * __CHNL_TYPE) * __LGSOURCE_i) * ddx(qjungat_s, V(SI)));
          __cjdsti = ((((- __MULT_i) * __CHNL_TYPE) * __LSSOURCE_i) * ddx(qjunsti_s, V(SI)));
          __cjd = ((__cjdbot + __cjdgat) + __cjdsti);
        end
        else begin
          __ise = (__MULT_i * (((__is - Igsov) + __Igisl) - ijun_s));
          __ige = (__MULT_i * __ig);
          __ide = (__MULT_i * (((__id_op - Igdov) + __Igidl) - ijun_d));
          __ibe = (__MULT_i * ((__ib + ijun_s) + ijun_d));
          __ids = (__MULT_i * Ids);
          __idb = (__MULT_i * ((Iimpact + __Igidl) - ijun_d));
          __isb = (__MULT_i * (__Igisl - ijun_s));
          __igs = (__MULT_i * (Igcs + Igsov));
          __igd = (__MULT_i * (Igcd + Igdov));
          __igb = (__MULT_i * __Igb);
          __idedge = (__MULT_i * Idsedge);
          __igcs = (__MULT_i * Igcs);
          __igcd = (__MULT_i * Igcd);
          __iavl = (__MULT_i * Iimpact);
          __igisl = (__MULT_i * __Igisl);
          __igidl = (__MULT_i * __Igidl);
          if ((__SWJUNEXP_i == 1)) begin
            __ijsbot =  0.0;
            __ijsgat =  0.0;
            __ijssti =  0.0;
            __ijdbot =  0.0;
            __ijdgat =  0.0;
            __ijdsti =  0.0;
            __idsatsbot =  0.0;
            __idsatssti =  0.0;
            __idsatsgat =  0.0;
            __idsatsbotd =  0.0;
            __idsatsstid =  0.0;
            __idsatsgatd =  0.0;
          end
          else begin
            __ijsbot = ((__MULT_i * __ABSOURCE_i) * ijunbot_s);
            __ijsgat = ((__MULT_i * __LGSOURCE_i) * ijungat_s);
            __ijssti = ((__MULT_i * __LSSOURCE_i) * ijunsti_s);
            __ijdbot = ((__MULT_i * __ABDRAIN_i) * ijunbot_d);
            __ijdgat = ((__MULT_i * __LGDRAIN_i) * ijungat_d);
            __ijdsti = ((__MULT_i * __LSDRAIN_i) * ijunsti_d);
            __idsatsbot = ((__MULT_i * __ABSOURCE_i) * __idsatbot);
            __idsatssti = ((__MULT_i * __LSSOURCE_i) * __idsatsti);
            __idsatsgat = ((__MULT_i * __LGSOURCE_i) * __idsatgat);
            __idsatsbotd = ((__MULT_i * __ABDRAIN_i) * __idsatbot_d);
            __idsatsstid = ((__MULT_i * __LSDRAIN_i) * __idsatsti_d);
            __idsatsgatd = ((__MULT_i * __LGDRAIN_i) * __idsatgat_d);
          end
          __ijs = (__MULT_i * ijun_s);
          __ijd = (__MULT_i * ijun_d);
          __vds = __Vds;
          __vgs = __Vgs;
          __vsb = __Vsb;
          __vto = ((__VFB_T + (__P_D * __facvsb0)) + (__Gf_dc * sqrt((phit1 * __facvsb0))));
          __vts = __vts_i;
          __vth = __vth_i;
          __vgt = (__vgs - __vth);
          __vdss = __Vdsat_dc;
          __vsat = (__Vds - __vdss);
          __ids_i = ((((((Ids + Idsedge) + Iimpact) + __Igidl) - Igcd) - Igdov) - ijun_d);
          __gm = ((__CHNL_TYPE * __MULT_i) * ddx(__ids_i, V(GP)));
          __gmb = ((__CHNL_TYPE * __MULT_i) * ddx(__ids_i, V(BP)));
          __gds = ((__CHNL_TYPE * __MULT_i) * ddx(__ids_i, V(DI)));
          __gjs = ((- __MULT_i) * ddx(ijun_s, V(SI)));
          __gjd = ((- __MULT_i) * ddx(ijun_d, V(DI)));
          __cdd = ((__CHNL_TYPE * __MULT_i) * ddx(__Qd, V(DI)));
          __cdg = (((- __CHNL_TYPE) * __MULT_i) * ddx(__Qd, V(GP)));
          __cdb = (((- __CHNL_TYPE) * __MULT_i) * ddx(__Qd, V(BP)));
          __cds = ((__cdd - __cdg) - __cdb);
          __cgd = (((- __CHNL_TYPE) * __MULT_i) * ddx(__Qg, V(DI)));
          __cgg = ((__CHNL_TYPE * __MULT_i) * ddx(__Qg, V(GP)));
          __cgb = (((- __CHNL_TYPE) * __MULT_i) * ddx(__Qg, V(BP)));
          __cgs = ((__cgg - __cgd) - __cgb);
          __csd = (((- __CHNL_TYPE) * __MULT_i) * ddx(__Qs, V(DI)));
          __csg = (((- __CHNL_TYPE) * __MULT_i) * ddx(__Qs, V(GP)));
          __csb = (((- __CHNL_TYPE) * __MULT_i) * ddx(__Qs, V(BP)));
          __css = ((__csg + __csd) + __csb);
          __cbd = (((- __CHNL_TYPE) * __MULT_i) * ddx(__Qb, V(DI)));
          __cbg = (((- __CHNL_TYPE) * __MULT_i) * ddx(__Qb, V(GP)));
          __cbb = ((__CHNL_TYPE * __MULT_i) * ddx(__Qb, V(BP)));
          __cbs = ((__cbb - __cbd) - __cbg);
          __cgsol = ((__CHNL_TYPE * __MULT_i) * ddx(__Qfgs, V(GP)));
          __cgdol = ((__CHNL_TYPE * __MULT_i) * ddx(__Qfgd, V(GP)));
          __cjsbot = ((((- __MULT_i) * __CHNL_TYPE) * __ABSOURCE_i) * ddx(qjunbot_s, V(SI)));
          __cjsgat = ((((- __MULT_i) * __CHNL_TYPE) * __LGSOURCE_i) * ddx(qjungat_s, V(SI)));
          __cjssti = ((((- __MULT_i) * __CHNL_TYPE) * __LSSOURCE_i) * ddx(qjunsti_s, V(SI)));
          __cjs = ((__cjsbot + __cjsgat) + __cjssti);
          __cjdbot = ((((- __MULT_i) * __CHNL_TYPE) * __ABDRAIN_i) * ddx(qjunbot_d, V(DI)));
          __cjdgat = ((((- __MULT_i) * __CHNL_TYPE) * __LGDRAIN_i) * ddx(qjungat_d, V(DI)));
          __cjdsti = ((((- __MULT_i) * __CHNL_TYPE) * __LSDRAIN_i) * ddx(qjunsti_d, V(DI)));
          __cjd = ((__cjdbot + __cjdgat) + __cjdsti);
        end
        __weff = __WE;
        __leff = __LE;
        if ((abs(__gds) <  1.0e-18)) begin
          __u =  0.0;
          __rout =  0.0;
          __vearly =  0.0;
        end
        else begin
          __u = (__gm / __gds);
          __rout = ( 1.0 / __gds);
          __vearly = (__ide / __gds);
        end
        if ((abs(__vgt) <  1.0e-12)) begin
          __beff =  0.0;
        end
        else begin
          __beff = ((abs(__ide) *  2.0) / (__vgt * __vgt));
        end
        if ((abs(((__cgg + __cgsol) + __cgdol)) <  1.0e-30)) begin
          __fug =  0.0;
        end
        else begin
          __fug = (__gm / (((__cgg + __cgsol) + __cgdol) *  6.28318530717959));
        end
        __rg = (__RG_i / __MULT_i);
        __sfl = (__MULT_i * __Sfl);
        if ((abs(__gm) <  1.0e-18)) begin
          __sqrtsff =  0.0;
          __sqrtsfw =  0.0;
        end
        else begin
          __sqrtsff = (sqrt((((__MULT_i * __Sfl) /  1.0e+3) / $mfactor)) / __gm);
          __sqrtsfw = ((sqrt((__MULT_i / $mfactor)) * __sqid) / __gm);
        end
        __sid = ((__MULT_i * __sqid) * __sqid);
        __sig = (((__MULT_i * __nt) * __sig1k) / ((__sig1k * __mig) +  1.0));
        __cigid = __c_igid;
        if ((__sid <=  0.0)) begin
          __fknee =  0.0;
        end
        else begin
          __fknee = (__sfl / __sid);
        end
        __siavl = (__MULT_i * __shot_iavl);
        if ((sigVds <  0.0)) begin
          __sigs = (__MULT_i * (__shot_igcsx + __shot_igdov));
          __sigd = (__MULT_i * (__shot_igcdx + __shot_igsov));
          __ssi = (__MULT_i * __jnoisex_d);
          __sdi = (__MULT_i * __jnoisex_s);
        end
        else begin
          __sigs = (__MULT_i * (__shot_igcsx + __shot_igsov));
          __sigd = (__MULT_i * (__shot_igcdx + __shot_igdov));
          __ssi = (__MULT_i * __jnoisex_s);
          __sdi = (__MULT_i * __jnoisex_d);
        end
        __sfledge = (__MULT_i * Sfledge);
        __sidedge = (__MULT_i * sqidedge);
        __lp_vfb = __VFB_T;
        __lp_stvfb = __STVFB_i;
        __lp_st2vfb = __ST2VFB_i;
        __lp_tox = __TOX_i;
        __lp_epsrox = __EPSROX_i;
        __lp_neff = __NEFF_i;
        __lp_facneffac = __FACNEFFAC_i;
        __lp_gfacnud = __GFACNUD_i;
        __lp_vsbnud = __VSBNUD_i;
        __lp_dvsbnud = __DVSBNUD_i;
        __lp_vnsub = __VNSUB_i;
        __lp_nslp = __NSLP_i;
        __lp_dnsub = __DNSUB_i;
        __lp_dphib = __DPHIB_i;
        __lp_delvtac = __DELVTAC_i;
        __lp_np = __NP_i;
        __lp_toxov = __TOXOV_i;
        __lp_toxovd = __TOXOVD_i;
        __lp_nov = __NOV_i;
        __lp_novd = __NOVD_i;
        __lp_ct = __CT_T;
        __lp_ctg = __CTG_T;
        __lp_ctb = __CTB_i;
        __lp_stct = __STCT_i;
        __lp_cf = __CF_i;
        __lp_cfac = __CFAC_i;
        __lp_cfd = __CFD_i;
        __lp_cfb = __CFB_i;
        __lp_psce = __PSCE_i;
        __lp_psceb = __PSCEB_i;
        __lp_psced = __PSCED_i;
        __lp_betn = __BETN_T;
        __lp_stbet = __STBET_i;
        __lp_mue = __MUE_T;
        __lp_stmue = __STMUE_i;
        __lp_themu = __THEMU_T;
        __lp_stthemu = __STTHEMU_i;
        __lp_cs = __CS_T;
        __lp_stcs = __STCS_i;
        __lp_thecs = __THECS_T;
        __lp_stthecs = __STTHECS_i;
        __lp_xcor = __XCOR_T;
        __lp_stxcor = __STXCOR_i;
        __lp_feta = __FETA_i;
        __lp_rs = __RS_T;
        __lp_strs = __STRS_i;
        __lp_rsb = __RSB_i;
        __lp_rsg = __RSG_i;
        __lp_thesat = __THESAT_T;
        __lp_thesatac = __THESATAC_T;
        __lp_stthesat = __STTHESAT_i;
        __lp_thesatb = __THESATB_i;
        __lp_thesatg = __THESATG_i;
        __lp_ax = __AX_i;
        __lp_axac = __AXAC_i;
        __lp_alp = __ALP_i;
        __lp_alpac = __ALPAC_i;
        __lp_alp1 = __ALP1_i;
        __lp_alp2 = __ALP2_i;
        __lp_vp = __VP_i;
        __lp_a1 = __A1_i;
        __lp_a2 = __A2_T;
        __lp_sta2 = __STA2_i;
        __lp_a3 = __A3_i;
        __lp_a4 = __A4_i;
        __lp_gco = __GCO_i;
        __lp_iginv = __IGINV_i;
        __lp_igov = __IGOV_i;
        __lp_igovd = __IGOVD_i;
        __lp_stig = __STIG_i;
        __lp_gc2 = __GC2_i;
        __lp_gc3 = __GC3_i;
        __lp_gc2ov = __GC2OV_i;
        __lp_gc3ov = __GC3OV_i;
        __lp_chib = __CHIB_i;
        __lp_agidl = __AGIDL_i;
        __lp_agidld = __AGIDLD_i;
        __lp_bgidl = __BGIDL_T;
        __lp_bgidld = __BGIDLD_T;
        __lp_stbgidl = __STBGIDL_i;
        __lp_stbgidld = __STBGIDLD_i;
        __lp_cgidl = __CGIDL_i;
        __lp_cgidld = __CGIDLD_i;
        __lp_cox = __COX_i;
        __lp_cgov = __CGOV_i;
        __lp_cgovd = __CGOVD_i;
        __lp_fcgovacc = __FCGOVACC_i;
        __lp_fcgovaccd = __FCGOVACCD_i;
        __lp_cgovaccg = __CGOVACCG_i;
        __lp_cgbov = __CGBOV_i;
        __lp_cinr = __CINR_i;
        __lp_cinrd = __CINRD_i;
        __lp_dvfbinr = __DVFBINR_i;
        __lp_fcinrdep = __FCINRDEP_i;
        __lp_fcinracc = __FCINRACC_i;
        __lp_axinr = __AXINR_i;
        __lp_cfr = __CFR_i;
        __lp_cfrd = __CFRD_i;
        __lp_fnt = __FNT_i;
        __lp_fntexc = __FNTEXC_i;
        __lp_nfa = __NFA_i;
        __lp_nfb = __NFB_i;
        __lp_nfc = __NFC_i;
        __lp_ef = __EF_i;
        __lp_vfbedge = __VFBEDGE_T;
        __lp_stvfbedge = __STVFBEDGE_i;
        __lp_dphibedge = __DPHIBEDGE_i;
        __lp_neffedge = __NEFFEDGE_i;
        __lp_ctedge = __CTEDGE_i;
        __lp_betnedge = __BETNEDGE_T;
        __lp_stbetedge = __STBETEDGE_i;
        __lp_psceedge = __PSCEEDGE_i;
        __lp_pscebedge = __PSCEBEDGE_i;
        __lp_pscededge = __PSCEDEDGE_i;
        __lp_cfedge = __CFEDGE_i;
        __lp_cfdedge = __CFDEDGE_i;
        __lp_cfbedge = __CFBEDGE_i;
        __lp_fntedge = __FNTEDGE_i;
        __lp_nfaedge = __NFAEDGE_i;
        __lp_nfbedge = __NFBEDGE_i;
        __lp_nfcedge = __NFCEDGE_i;
        __lp_efedge = __EFEDGE_i;
        __lp_rg = __RG_i;
        __lp_rse = __RSE_i;
        __lp_rde = __RDE_i;
        __lp_rbulk = __RBULK_i;
        __lp_rwell = __RWELL_i;
        __lp_rjuns = __RJUNS_i;
        __lp_rjund = __RJUND_i;
        __tk = __TKD;
        __cjosbot = ((__MULT_i * __ABSOURCE_i) * __cjobot);
        __cjossti = ((__MULT_i * __LSSOURCE_i) * __cjosti);
        __cjosgat = ((__MULT_i * __LGSOURCE_i) * __cjogat);
        __vbisbot = __vbibot;
        __vbissti = __vbisti;
        __vbisgat = __vbigat;
        __cjosbotd = ((__MULT_i * __ABDRAIN_i) * __cjobot_d);
        __cjosstid = ((__MULT_i * __LSDRAIN_i) * __cjosti_d);
        __cjosgatd = ((__MULT_i * __LGDRAIN_i) * __cjogat_d);
        __vbisbotd = __vbibot_d;
        __vbisstid = __vbisti_d;
        __vbisgatd = __vbigat_d;
        __lp_munqs = __MUNQS_i;
      end
    end
  end

endmodule
module sg13g2_lv_pmos_psp_rf_model(D, G, S, B);
  inout D, G, S, B;
  electrical D;
  electrical G;
  electrical S;
  electrical B;
  electrical NOI;
  electrical GP;
  electrical SI;
  electrical DI;
  electrical BP;
  electrical BI;
  electrical BS;
  electrical BD;
  electrical INT1;
  electrical INT2;
  electrical INT3;
  electrical INT4;
  electrical INT5;
  electrical INT6;
  electrical INT7;
  electrical INT8;
  electrical INT9;
  branch (NOI) NOII;
  branch (NOI) NOIR;
  branch (NOI) NOIC;
  branch (INT1) SPLINE1;
  branch (INT2) SPLINE2;
  branch (INT3) SPLINE3;
  branch (INT4) SPLINE4;
  branch (INT5) SPLINE5;
  branch (INT6) SPLINE6;
  branch (INT7) SPLINE7;
  branch (INT8) SPLINE8;
  branch (INT9) SPLINE9;
  branch (INT1) RES1;
  branch (INT2) RES2;
  branch (INT3) RES3;
  branch (INT4) RES4;
  branch (INT5) RES5;
  branch (INT6) RES6;
  branch (INT7) RES7;
  branch (INT8) RES8;
  branch (INT9) RES9;
  (* type = "instance" *)
  parameter integer rfmode = 1 from [0:1];
  (* type = "instance" *)
  parameter real w =  280.0e-9;
  (* type = "instance" *)
  parameter real l =  350.0e-9;
  (* type = "instance" *)
  parameter integer nf = 1;
  (* type = "instance" *)
  parameter real mult =  1.0;
  (* type = "instance" *)
  parameter real as =  0.0;
  (* type = "instance" *)
  parameter real ad =  0.0;
  (* type = "instance" *)
  parameter real ps =  0.0;
  (* type = "instance" *)
  parameter real pd =  0.0;
  (* type = "instance" *)
  parameter real dta =  0.0;
  (* type = "instance" *)
  parameter real ngcon =  2.0;
  (* type = "instance" *)
  parameter real delvto =  0.0;
  (* type = "instance" *)
  parameter real factuo =  1.0;
  (* type = "instance" *)
  parameter real pre_layout =  1.0;
  localparam integer __LEVEL = 103;
  localparam integer __TYPE = -1;
  localparam real __W = w;
  localparam real __L = l;
  localparam integer __NF = nf;
  localparam real __MULT = mult;
  localparam real __AS = as;
  localparam real __AD = ad;
  localparam real __PS = ps;
  localparam real __PD = pd;
  localparam real __TR =  27.0;
  localparam real __DTA = dta;
  localparam real __NGCON = ngcon;
  localparam real __DELVTO = delvto;
  localparam real __FACTUO = factuo;
  localparam integer __SWGEO =  1.0;
  localparam integer __SWIGATE =  1.0;
  localparam integer __SWIMPACT =  1.0;
  localparam integer __SWGIDL =  1.0;
  localparam integer __SWJUNCAP =  3.0;
  localparam integer __SWJUNASYM =  0.0;
  localparam integer __SWNUD =  0.0;
  localparam integer __SWEDGE =  0.0;
  localparam integer __SWDELVTAC =  0.0;
  localparam integer __SWIGN =  1.0;
  localparam real __QMC =  1.0;
  localparam real __LVARO =  96.95e-9;
  localparam real __LVARL = -0.03438;
  localparam real __LVARW =  0.0;
  localparam real __LAP =  25.254e-9;
  localparam real __WVARO =  0.0;
  localparam real __WVARL =  0.0;
  localparam real __WVARW =  0.0;
  localparam real __WOT =  15.0e-9;
  localparam real __DLQ = ((-95.922e-9 - ((1 - pre_layout) *  30.0e-9)) + (rfmode * ((((nf < 3))? ( 33.917e-9):(0)) + -20.0e-9)));
  localparam real __DWQ = ((rfmode *  475.99e-9) +  15.0e-9);
  localparam real __VFBO = -0.88703;
  localparam real __VFBL =  0.0089886;
  localparam real __VFBW =  0.0071805;
  localparam real __VFBLW =  0.004075;
  localparam real __STVFBO =  751.11e-6;
  localparam real __STVFBL =  2.4487e-6;
  localparam real __STVFBW =  6.217e-6;
  localparam real __STVFBLW =  226.68e-9;
  localparam real __ST2VFBO =  0.0;
  localparam real __TOXO =  1.9704e-9;
  localparam real __EPSROXO =  3.9;
  localparam real __NSUBO =  460.11e+21;
  localparam real __NSUBW = -0.013639;
  localparam real __WSEG =  10.58e-9;
  localparam real __NPCK =  5.7416e+24;
  localparam real __NPCKW = -1.0;
  localparam real __WSEGP =  100.0e-12;
  localparam real __LPCK =  115.76e-12;
  localparam real __LPCKW = -0.022414;
  localparam real __FOL1 = -0.0081173;
  localparam real __FOL2 =  0.0081347;
  localparam real __FACNEFFACO =  1.0;
  localparam real __FACNEFFACL =  0.0;
  localparam real __FACNEFFACW =  0.0;
  localparam real __FACNEFFACLW =  0.0;
  localparam real __GFACNUDO =  1.0;
  localparam real __GFACNUDL =  0.0;
  localparam real __GFACNUDLEXP =  1.0;
  localparam real __GFACNUDW =  0.0;
  localparam real __GFACNUDLW =  0.0;
  localparam real __VSBNUDO =  0.0;
  localparam real __DVSBNUDO =  1.0;
  localparam real __VNSUBO =  0.0;
  localparam real __NSLPO =  0.05;
  localparam real __DNSUBO =  0.039707;
  localparam real __DPHIBO = -0.089784145;
  localparam real __DPHIBL =  177.36975e-6;
  localparam real __DPHIBLEXP =  2.9957;
  localparam real __DPHIBW =  0.001096441;
  localparam real __DPHIBLW = -0.0030829;
  localparam real __DELVTACO =  0.0;
  localparam real __DELVTACL =  0.0;
  localparam real __DELVTACLEXP =  1.0;
  localparam real __DELVTACW =  0.0;
  localparam real __DELVTACLW =  0.0;
  localparam real __NPO =  126.99e+24;
  localparam real __NPL = -0.095923;
  localparam real __TOXOVO =  1.9704e-9;
  localparam real __TOXOVDO =  2.0e-9;
  localparam real __LOV = ( 25.254e-9 - ((1 - pre_layout) *  8.85e-9));
  localparam real __LOVD =  0.0;
  localparam real __NOVO =  31.04e+24;
  localparam real __NOVDO =  50.0e+24;
  localparam real __CTO =  11.814e-6;
  localparam real __CTL =  0.0135790359;
  localparam real __CTLEXP =  1.4316;
  localparam real __CTW =  0.36122;
  localparam real __CTLW = -0.014902;
  localparam real __CTGO =  0.0;
  localparam real __CTBO =  0.0;
  localparam real __STCTO =  1.0;
  localparam real __CFL =  112.47e-6;
  localparam real __CFLEXP =  3.0355;
  localparam real __CFW = -0.012199;
  localparam real __CFBO =  0.57877;
  localparam real __CFDO =  0.0;
  localparam real __PSCEL =  0.0;
  localparam real __PSCELEXP =  2.0;
  localparam real __PSCEW =  0.0;
  localparam real __PSCEBO =  0.0;
  localparam real __PSCEDO =  0.0;
  localparam real __UO =  0.017232;
  localparam real __FBET1 = -0.2152;
  localparam real __FBET1W = -0.065541;
  localparam real __LP1 =  197.66e-6;
  localparam real __LP1W =  0.0;
  localparam real __FBET2 = -6.171;
  localparam real __LP2 =  12.564e-9;
  localparam real __BETW1 = -0.3268;
  localparam real __BETW2 =  0.060181;
  localparam real __WBET =  542.4e-12;
  localparam real __STBETO =  1.6974;
  localparam real __STBETL = -0.037605;
  localparam real __STBETW = -0.0083384;
  localparam real __STBETLW =  0.0013663;
  localparam real __MUEO =  2.3326;
  localparam real __MUEW = -0.070919528;
  localparam real __STMUEO =  0.84805;
  localparam real __THEMUO =  1.2615902;
  localparam real __STTHEMUO =  4.441e-15;
  localparam real __CSO =  0.94214;
  localparam real __CSL =  0.34682;
  localparam real __CSLEXP =  1.5813;
  localparam real __CSW = -0.11045;
  localparam real __CSLW =  0.014762;
  localparam real __STCSO =  1.0269;
  localparam real __THECSO =  1.4566;
  localparam real __STTHECSO =  0.0;
  localparam real __XCORO =  0.092591;
  localparam real __XCORL =  0.11698;
  localparam real __XCORW = -0.095907;
  localparam real __XCORLW =  0.029574;
  localparam real __STXCORO =  27.756e-18;
  localparam real __FETAO =  1.0;
  localparam real __RSW1 =  538.37736;
  localparam real __RSW2 = -0.088444;
  localparam real __STRSO = -0.3508;
  localparam real __RSBO =  0.06;
  localparam real __RSGO =  0.495;
  localparam real __THESATO =  0.099164;
  localparam real __THESATL =  0.005588242;
  localparam real __THESATLEXP =  2.4434;
  localparam real __THESATW = -0.148446;
  localparam real __THESATLW = -0.103;
  localparam real __STTHESATO =  12.733;
  localparam real __STTHESATL = -1.9651;
  localparam real __STTHESATW = -0.047465;
  localparam real __STTHESATLW =  0.07117;
  localparam real __THESATBO =  0.0;
  localparam real __THESATGO =  0.0;
  localparam real __AXO =  8.1825;
  localparam real __AXL =  0.58095;
  localparam real __ALPL =  0.0047346;
  localparam real __ALPLEXP =  0.8468;
  localparam real __ALPW = -0.21042;
  localparam real __ALP1L1 =  0.0040221;
  localparam real __ALP1LEXP =  0.6408;
  localparam real __ALP1L2 =  16.11e-9;
  localparam real __ALP1W = -0.057981;
  localparam real __ALP2L1 =  0.005286;
  localparam real __ALP2LEXP =  0.25;
  localparam real __ALP2L2 =  0.0;
  localparam real __ALP2W =  0.063581;
  localparam real __VPO =  7.3803e-6;
  localparam real __A1O =  110.7e-6;
  localparam real __A1L =  5.741;
  localparam real __A1W =  5.78;
  localparam real __A2O =  13.33;
  localparam real __STA2O =  2.0;
  localparam real __A3O =  1.526;
  localparam real __A3L = -0.08391;
  localparam real __A3W = -0.004911;
  localparam real __A4O = -0.005545;
  localparam real __A4L =  0.2771;
  localparam real __A4W =  0.7101;
  localparam real __GCOO =  0.01231;
  localparam real __IGINVLW = (((1 - ( 5.803e-9 / l)) *  4.8804e+3) * (( 51.659e-9 / w) + 1));
  localparam real __IGOVW =  1.327e+3;
  localparam real __IGOVDW =  0.0;
  localparam real __STIGO =  2.3506;
  localparam real __GC2O =  0.54762;
  localparam real __GC3O = -0.29543;
  localparam real __CHIBO =  3.1;
  localparam real __AGIDLW =  73.71e-6;
  localparam real __AGIDLDW =  0.0;
  localparam real __BGIDLO =  15.12;
  localparam real __BGIDLDO =  41.0;
  localparam real __STBGIDLO = -0.0014941;
  localparam real __STBGIDLDO =  0.0;
  localparam real __CGIDLO =  0.02068;
  localparam real __CGIDLDO =  0.0;
  localparam real __CGBOVL =  21.86e-18;
  localparam real __CFRDW =  0.0;
  localparam real __FNTO =  1.85;
  localparam real __FNTEXCL =  0.0;
  localparam real __NFALW =  220.9e+24;
  localparam real __NFBLW =  572.3e+6;
  localparam real __NFCLW =  564.1e-9;
  localparam real __EFO =  1.0;
  localparam real __LINTNOI =  10.0e-9;
  localparam real __ALPNOI =  2.118;
  localparam real __WEDGE =  10.0e-9;
  localparam real __WEDGEW =  0.0;
  localparam real __VFBEDGEO = -1.0;
  localparam real __STVFBEDGEO =  500.0e-6;
  localparam real __STVFBEDGEL =  0.0;
  localparam real __STVFBEDGEW =  0.0;
  localparam real __STVFBEDGELW =  0.0;
  localparam real __DPHIBEDGEO =  0.0;
  localparam real __DPHIBEDGEL =  0.0;
  localparam real __DPHIBEDGELEXP =  1.0;
  localparam real __DPHIBEDGEW =  0.0;
  localparam real __DPHIBEDGELW =  0.0;
  localparam real __NSUBEDGEO =  500.0e+21;
  localparam real __NSUBEDGEL =  0.0;
  localparam real __NSUBEDGELEXP =  1.0;
  localparam real __NSUBEDGEW =  0.0;
  localparam real __NSUBEDGELW =  0.0;
  localparam real __CTEDGEO =  0.0;
  localparam real __CTEDGEL =  0.0;
  localparam real __CTEDGELEXP =  1.0;
  localparam real __FBETEDGE =  0.0;
  localparam real __LPEDGE =  10.0e-9;
  localparam real __BETEDGEW =  0.0;
  localparam real __STBETEDGEO =  1.0;
  localparam real __STBETEDGEL =  0.0;
  localparam real __STBETEDGEW =  0.0;
  localparam real __STBETEDGELW =  0.0;
  localparam real __PSCEEDGEL =  0.0;
  localparam real __PSCEEDGELEXP =  2.0;
  localparam real __PSCEEDGEW =  0.0;
  localparam real __PSCEBEDGEO =  0.0;
  localparam real __PSCEDEDGEO =  0.0;
  localparam real __CFEDGEL =  0.0;
  localparam real __CFEDGELEXP =  2.0;
  localparam real __CFEDGEW =  0.0;
  localparam real __CFDEDGEO =  0.0;
  localparam real __CFBEDGEO =  0.0;
  localparam real __FNTEDGEO =  1.0;
  localparam real __NFAEDGELW =  80.0e+21;
  localparam real __NFBEDGELW =  30.0e+6;
  localparam real __NFCEDGELW =  0.0;
  localparam real __EFEDGEO =  1.0;
  localparam real __SAREF =  1.0e-6;
  localparam real __SBREF =  1.0e-6;
  localparam real __WLOD =  0.0;
  localparam real __KUO =  0.0;
  localparam real __KVSAT =  0.0;
  localparam real __TKUO =  0.0;
  localparam real __LKUO =  0.0;
  localparam real __WKUO =  0.0;
  localparam real __PKUO =  0.0;
  localparam real __LLODKUO =  0.0;
  localparam real __WLODKUO =  0.0;
  localparam real __KVTHO =  0.0;
  localparam real __LKVTHO =  0.0;
  localparam real __WKVTHO =  0.0;
  localparam real __PKVTHO =  0.0;
  localparam real __LLODVTH =  0.0;
  localparam real __WLODVTH =  0.0;
  localparam real __STETAO =  0.0;
  localparam real __LODETAO =  1.0;
  localparam real __SCREF =  1.0e-6;
  localparam real __WEB =  0.0;
  localparam real __WEC =  0.0;
  localparam real __KVTHOWEO =  0.0;
  localparam real __KVTHOWEL =  0.0;
  localparam real __KVTHOWEW =  0.0;
  localparam real __KVTHOWELW =  0.0;
  localparam real __KUOWEO =  0.0;
  localparam real __KUOWEL =  0.0;
  localparam real __KUOWEW =  0.0;
  localparam real __KUOWELW =  0.0;
  localparam real __TRJ =  21.0;
  localparam real __SWJUNEXP =  0.0;
  localparam real __IMAX =  0.0016551;
  localparam real __FREV =  1.0e+3;
  localparam real __CJORBOT =  863.06e-6;
  localparam real __CJORSTI =  31.915e-12;
  localparam real __CJORGAT =  27.474e-12;
  localparam real __VBIRBOT =  0.7686;
  localparam real __VBIRSTI =  1.7036;
  localparam real __VBIRGAT =  1.399;
  localparam real __PBOT =  0.3618;
  localparam real __PSTI =  0.2548;
  localparam real __PGAT =  0.6475;
  localparam real __CJORBOTD =  0.001;
  localparam real __CJORSTID =  1.0e-9;
  localparam real __CJORGATD =  1.0e-9;
  localparam real __VBIRBOTD =  1.0;
  localparam real __VBIRSTID =  1.0;
  localparam real __VBIRGATD =  1.0;
  localparam real __PBOTD =  0.5;
  localparam real __PSTID =  0.5;
  localparam real __PGATD =  0.5;
  localparam real __PHIGBOT =  1.204;
  localparam real __PHIGSTI =  0.8186;
  localparam real __PHIGGAT =  1.65;
  localparam real __IDSATRBOT =  26.746e-9;
  localparam real __IDSATRSTI =  1.1115e-15;
  localparam real __IDSATRGAT =  0.0;
  localparam real __CSRHBOT =  100.0;
  localparam real __CSRHSTI =  100.0e-6;
  localparam real __CSRHGAT =  100.0e-6;
  localparam real __XJUNSTI =  62.92e-9;
  localparam real __XJUNGAT =  91.05e-6;
  localparam real __PHIGBOTD =  1.16;
  localparam real __PHIGSTID =  1.16;
  localparam real __PHIGGATD =  1.16;
  localparam real __IDSATRBOTD =  1.0e-12;
  localparam real __IDSATRSTID =  1.0e-18;
  localparam real __IDSATRGATD =  1.0e-18;
  localparam real __CSRHBOTD =  100.0;
  localparam real __CSRHSTID =  100.0e-6;
  localparam real __CSRHGATD =  100.0e-6;
  localparam real __XJUNSTID =  100.0e-9;
  localparam real __XJUNGATD =  100.0e-9;
  localparam real __CTATBOT =  100.0;
  localparam real __CTATSTI =  100.0e-6;
  localparam real __CTATGAT =  100.0e-6;
  localparam real __MEFFTATBOT =  10.0;
  localparam real __MEFFTATSTI =  4.363;
  localparam real __MEFFTATGAT =  0.25;
  localparam real __CTATBOTD =  100.0;
  localparam real __CTATSTID =  100.0e-6;
  localparam real __CTATGATD =  100.0e-6;
  localparam real __MEFFTATBOTD =  0.25;
  localparam real __MEFFTATSTID =  0.25;
  localparam real __MEFFTATGATD =  0.25;
  localparam real __CBBTBOT =  1.0e-12;
  localparam real __CBBTSTI =  1.0e-21;
  localparam real __CBBTGAT =  1.0e-18;
  localparam real __FBBTRBOT =  1.0e+9;
  localparam real __FBBTRSTI =  1.0e+9;
  localparam real __FBBTRGAT =  1.0e+9;
  localparam real __STFBBTBOT = -0.001;
  localparam real __STFBBTSTI = -0.001;
  localparam real __STFBBTGAT = -0.001;
  localparam real __CBBTBOTD =  1.0e-12;
  localparam real __CBBTSTID =  1.0e-18;
  localparam real __CBBTGATD =  1.0e-18;
  localparam real __FBBTRBOTD =  1.0e+9;
  localparam real __FBBTRSTID =  1.0e+9;
  localparam real __FBBTRGATD =  1.0e+9;
  localparam real __STFBBTBOTD = -0.001;
  localparam real __STFBBTSTID = -0.001;
  localparam real __STFBBTGATD = -0.001;
  localparam real __VBRBOT =  10.0;
  localparam real __VBRSTI =  10.0;
  localparam real __VBRGAT =  10.0;
  localparam real __PBRBOT =  4.0;
  localparam real __PBRSTI =  4.0;
  localparam real __PBRGAT =  4.0;
  localparam real __VBRBOTD =  10.0;
  localparam real __VBRSTID =  10.0;
  localparam real __VBRGATD =  10.0;
  localparam real __PBRBOTD =  4.0;
  localparam real __PBRSTID =  4.0;
  localparam real __PBRGATD =  4.0;
  localparam real __VJUNREF =  2.5;
  localparam real __FJUNQ =  0.03;
  localparam real __VJUNREFD =  2.5;
  localparam real __FJUNQD =  0.03;
  localparam real __RINT =  1.0e-12;
  localparam real __RVPOLY =  0.0;
  localparam real __DLSIL =  0.0;
  localparam real __RSH =  0.0;
  localparam real __RSHD =  0.0;
  localparam real __MUNQSO =  1.0;
  localparam integer __SWNQS = (rfmode *  5.0);
  localparam real __CFRW = (((rfmode * ((pre_layout * (((nf > 0))? ( 123.82e-18):(0))) +  1.0e-18)) +  100.0e-18) / nf);
  localparam real __RSHG = (rfmode *  20.0);
  localparam real __RGO = (rfmode *  22.0);
  localparam real __RBULKO = (((rfmode *  0.002) * nf) / w);
  localparam real __RWELLO = (((rfmode *  0.001) * nf) / w);
  localparam real __RJUNSO = (((rfmode *  5.0e+3) * l) / w);
  localparam real __RJUNDO = (((rfmode *  5.0e+3) * l) / w);
  localparam integer __SWSOA = 0;
  localparam real __VGS_MAX =  1.6;
  localparam real __VGD_MAX =  1.6;
  localparam real __VGB_MAX =  1.6;
  localparam real __VDS_MAX =  1.6;
  localparam real __VDB_MAX =  1.6;
  localparam real __VSB_MAX =  1.6;
  localparam real __SA =  0.0;
  localparam real __SB =  0.0;
  localparam real __SD =  0.0;
  localparam real __SCA =  0.0;
  localparam real __SCB =  0.0;
  localparam real __SCC =  0.0;
  localparam real __SC =  0.0;
  localparam real __XGW =  100.0e-9;
  localparam real __NRS =  0.0;
  localparam real __NRD =  0.0;
  localparam real __JW =  1.0e-6;
  localparam real __DELVTOEDGE =  0.0;
  localparam real __FACTUOEDGE =  1.0;
  localparam real __ABSOURCE =  1.0e-12;
  localparam real __LSSOURCE =  1.0e-6;
  localparam real __LGSOURCE =  1.0e-6;
  localparam real __ABDRAIN =  1.0e-12;
  localparam real __LSDRAIN =  1.0e-6;
  localparam real __LGDRAIN =  1.0e-6;
  localparam real __TRISE =  0.0;
  localparam integer __SWQSAT = 0;
  localparam integer __SWQPART = 0;
  localparam integer __SWFIX = 0;
  localparam real __VFB = -1.0;
  localparam real __STVFB =  500.0e-6;
  localparam real __ST2VFB =  0.0;
  localparam real __TOX =  2.0e-9;
  localparam real __EPSROX =  3.9;
  localparam real __NEFF =  500.0e+21;
  localparam real __FACNEFFAC =  1.0;
  localparam real __GFACNUD =  1.0;
  localparam real __VSBNUD =  0.0;
  localparam real __DVSBNUD =  1.0;
  localparam real __VNSUB =  0.0;
  localparam real __NSLP =  0.05;
  localparam real __DNSUB =  0.0;
  localparam real __DPHIB =  0.0;
  localparam real __DELVTAC =  0.0;
  localparam real __NP =  100.0e+24;
  localparam real __TOXOV =  2.0e-9;
  localparam real __TOXOVD =  2.0e-9;
  localparam real __NOV =  50.0e+24;
  localparam real __NOVD =  50.0e+24;
  localparam real __CT =  0.0;
  localparam real __CTG =  0.0;
  localparam real __CTB =  0.0;
  localparam real __STCT =  1.0;
  localparam real __CF =  0.0;
  localparam real __CFAC =  0.0;
  localparam real __CFD =  0.0;
  localparam real __CFB =  0.0;
  localparam real __PSCE =  0.0;
  localparam real __PSCEB =  0.0;
  localparam real __PSCED =  0.0;
  localparam real __BETN =  0.07;
  localparam real __STBET =  1.0;
  localparam real __MUE =  0.5;
  localparam real __STMUE =  0.0;
  localparam real __THEMU =  1.5;
  localparam real __STTHEMU =  1.5;
  localparam real __CS =  0.0;
  localparam real __STCS =  0.0;
  localparam real __THECS =  2.0;
  localparam real __STTHECS =  0.0;
  localparam real __XCOR =  0.0;
  localparam real __STXCOR =  0.0;
  localparam real __FETA =  1.0;
  localparam real __RS =  30.0;
  localparam real __STRS =  1.0;
  localparam real __RSB =  0.0;
  localparam real __RSG =  0.0;
  localparam real __THESAT =  1.0;
  localparam real __THESATAC =  1.0;
  localparam real __STTHESAT =  1.0;
  localparam real __THESATB =  0.0;
  localparam real __THESATG =  0.0;
  localparam real __AX =  3.0;
  localparam real __AXAC =  3.0;
  localparam real __ALP =  0.01;
  localparam real __ALPAC =  0.01;
  localparam real __ALP1 =  0.0;
  localparam real __ALP2 =  0.0;
  localparam real __VP =  0.05;
  localparam real __A1 =  1.0;
  localparam real __A2 =  10.0;
  localparam real __STA2 =  0.0;
  localparam real __A3 =  1.0;
  localparam real __A4 =  0.0;
  localparam real __GCO =  0.0;
  localparam real __IGINV =  0.0;
  localparam real __IGOV =  0.0;
  localparam real __IGOVD =  0.0;
  localparam real __STIG =  2.0;
  localparam real __GC2 =  0.375;
  localparam real __GC3 =  0.063;
  localparam real __GC2OV =  0.375;
  localparam real __GC3OV =  0.063;
  localparam real __CHIB =  3.1;
  localparam real __AGIDL =  0.0;
  localparam real __AGIDLD =  0.0;
  localparam real __BGIDL =  41.0;
  localparam real __BGIDLD =  41.0;
  localparam real __STBGIDL =  0.0;
  localparam real __STBGIDLD =  0.0;
  localparam real __CGIDL =  0.0;
  localparam real __CGIDLD =  0.0;
  localparam real __COX =  10.0e-15;
  localparam real __CGOV =  1.0e-15;
  localparam real __CGOVD =  1.0e-15;
  localparam real __FCGOVACC =  0.0;
  localparam real __FCGOVACCD =  0.0;
  localparam real __CGOVACCG =  1.0;
  localparam real __CGBOV =  0.0;
  localparam real __CINR =  0.0;
  localparam real __CINRD =  0.0;
  localparam real __DVFBINR =  0.0;
  localparam real __FCINRDEP =  0.3;
  localparam real __FCINRACC =  0.5;
  localparam real __AXINR =  0.5;
  localparam real __CFR =  0.0;
  localparam real __CFRD =  0.0;
  localparam real __FNT =  1.0;
  localparam real __FNTEXC =  0.0;
  localparam real __NFA =  80.0e+21;
  localparam real __NFB =  30.0e+6;
  localparam real __NFC =  0.0;
  localparam real __EF =  1.0;
  localparam real __VFBEDGE = -1.0;
  localparam real __STVFBEDGE =  500.0e-6;
  localparam real __DPHIBEDGE =  0.0;
  localparam real __NEFFEDGE =  500.0e+21;
  localparam real __CTEDGE =  0.0;
  localparam real __BETNEDGE =  500.0e-6;
  localparam real __STBETEDGE =  1.0;
  localparam real __PSCEEDGE =  0.0;
  localparam real __PSCEBEDGE =  0.0;
  localparam real __PSCEDEDGE =  0.0;
  localparam real __CFEDGE =  0.0;
  localparam real __CFDEDGE =  0.0;
  localparam real __CFBEDGE =  0.0;
  localparam real __FNTEDGE =  1.0;
  localparam real __NFAEDGE =  80.0e+21;
  localparam real __NFBEDGE =  30.0e+6;
  localparam real __NFCEDGE =  0.0;
  localparam real __EFEDGE =  1.0;
  localparam real __MUNQS =  1.0;
  localparam real __RG =  0.0;
  localparam real __RSE =  0.0;
  localparam real __RDE =  0.0;
  localparam real __RBULK =  0.0;
  localparam real __RWELL =  0.0;
  localparam real __RJUNS =  0.0;
  localparam real __RJUND =  0.0;
  localparam real __CFACL =  0.0;
  localparam real __CFACLEXP =  2.0;
  localparam real __CFACW =  0.0;
  localparam real __THESATACO =  0.0;
  localparam real __THESATACL =  0.05;
  localparam real __THESATACLEXP =  1.0;
  localparam real __THESATACW =  0.0;
  localparam real __THESATACLW =  0.0;
  localparam real __AXACO =  18.0;
  localparam real __AXACL =  0.4;
  localparam real __ALPACL =  500.0e-6;
  localparam real __ALPACLEXP =  1.0;
  localparam real __ALPACW =  0.0;
  localparam real __GC2OVO =  0.375;
  localparam real __GC3OVO =  0.063;
  localparam real __FCGOVACCO =  0.0;
  localparam real __FCGOVACCDO =  0.0;
  localparam real __CGOVACCGO =  1.0;
  localparam real __CINRW =  0.0;
  localparam real __CINRDW =  0.0;
  localparam real __DVFBINRO =  0.0;
  localparam real __FCINRDEPO =  0.3;
  localparam real __FCINRACCO =  0.5;
  localparam real __AXINRO =  0.5;
  localparam real __POVFB = -1.0;
  localparam real __PLVFB =  0.0;
  localparam real __PWVFB =  0.0;
  localparam real __PLWVFB =  0.0;
  localparam real __POSTVFB =  500.0e-6;
  localparam real __PLSTVFB =  0.0;
  localparam real __PWSTVFB =  0.0;
  localparam real __PLWSTVFB =  0.0;
  localparam real __POST2VFB =  0.0;
  localparam real __POTOX =  2.0e-9;
  localparam real __POEPSROX =  3.9;
  localparam real __PONEFF =  500.0e+21;
  localparam real __PLNEFF =  0.0;
  localparam real __PWNEFF =  0.0;
  localparam real __PLWNEFF =  0.0;
  localparam real __POFACNEFFAC =  1.0;
  localparam real __PLFACNEFFAC =  0.0;
  localparam real __PWFACNEFFAC =  0.0;
  localparam real __PLWFACNEFFAC =  0.0;
  localparam real __POGFACNUD =  1.0;
  localparam real __PLGFACNUD =  0.0;
  localparam real __PWGFACNUD =  0.0;
  localparam real __PLWGFACNUD =  0.0;
  localparam real __POVSBNUD =  0.0;
  localparam real __PODVSBNUD =  1.0;
  localparam real __POVNSUB =  0.0;
  localparam real __PONSLP =  0.05;
  localparam real __PODNSUB =  0.0;
  localparam real __PODPHIB =  0.0;
  localparam real __PLDPHIB =  0.0;
  localparam real __PWDPHIB =  0.0;
  localparam real __PLWDPHIB =  0.0;
  localparam real __PODELVTAC =  0.0;
  localparam real __PLDELVTAC =  0.0;
  localparam real __PWDELVTAC =  0.0;
  localparam real __PLWDELVTAC =  0.0;
  localparam real __PONP =  100.0e+24;
  localparam real __PLNP =  0.0;
  localparam real __PWNP =  0.0;
  localparam real __PLWNP =  0.0;
  localparam real __POTOXOV =  2.0e-9;
  localparam real __POTOXOVD =  2.0e-9;
  localparam real __PONOV =  50.0e+24;
  localparam real __PLNOV =  0.0;
  localparam real __PWNOV =  0.0;
  localparam real __PLWNOV =  0.0;
  localparam real __PONOVD =  50.0e+24;
  localparam real __PLNOVD =  0.0;
  localparam real __PWNOVD =  0.0;
  localparam real __PLWNOVD =  0.0;
  localparam real __POCT =  0.0;
  localparam real __PLCT =  0.0;
  localparam real __PWCT =  0.0;
  localparam real __PLWCT =  0.0;
  localparam real __POCTG =  0.0;
  localparam real __POCTB =  0.0;
  localparam real __POSTCT =  1.0;
  localparam real __POCF =  0.0;
  localparam real __PLCF =  0.0;
  localparam real __PWCF =  0.0;
  localparam real __PLWCF =  0.0;
  localparam real __POCFAC =  0.0;
  localparam real __PLCFAC =  0.0;
  localparam real __PWCFAC =  0.0;
  localparam real __PLWCFAC =  0.0;
  localparam real __POCFD =  0.0;
  localparam real __POCFB =  0.0;
  localparam real __POPSCE =  0.0;
  localparam real __PLPSCE =  0.0;
  localparam real __PWPSCE =  0.0;
  localparam real __PLWPSCE =  0.0;
  localparam real __POPSCEB =  0.0;
  localparam real __POPSCED =  0.0;
  localparam real __POBETN =  0.07;
  localparam real __PLBETN =  0.0;
  localparam real __PWBETN =  0.0;
  localparam real __PLWBETN =  0.0;
  localparam real __POSTBET =  1.0;
  localparam real __PLSTBET =  0.0;
  localparam real __PWSTBET =  0.0;
  localparam real __PLWSTBET =  0.0;
  localparam real __POMUE =  0.5;
  localparam real __PLMUE =  0.0;
  localparam real __PWMUE =  0.0;
  localparam real __PLWMUE =  0.0;
  localparam real __POSTMUE =  0.0;
  localparam real __POTHEMU =  1.5;
  localparam real __POSTTHEMU =  1.5;
  localparam real __POCS =  0.0;
  localparam real __PLCS =  0.0;
  localparam real __PWCS =  0.0;
  localparam real __PLWCS =  0.0;
  localparam real __POSTCS =  0.0;
  localparam real __POTHECS =  2.0;
  localparam real __POSTTHECS =  0.0;
  localparam real __POXCOR =  0.0;
  localparam real __PLXCOR =  0.0;
  localparam real __PWXCOR =  0.0;
  localparam real __PLWXCOR =  0.0;
  localparam real __POSTXCOR =  0.0;
  localparam real __POFETA =  1.0;
  localparam real __PORS =  30.0;
  localparam real __PLRS =  0.0;
  localparam real __PWRS =  0.0;
  localparam real __PLWRS =  0.0;
  localparam real __POSTRS =  1.0;
  localparam real __PORSB =  0.0;
  localparam real __PORSG =  0.0;
  localparam real __POTHESAT =  1.0;
  localparam real __PLTHESAT =  0.0;
  localparam real __PWTHESAT =  0.0;
  localparam real __PLWTHESAT =  0.0;
  localparam real __POTHESATAC =  1.0;
  localparam real __PLTHESATAC =  0.0;
  localparam real __PWTHESATAC =  0.0;
  localparam real __PLWTHESATAC =  0.0;
  localparam real __POSTTHESAT =  1.0;
  localparam real __PLSTTHESAT =  0.0;
  localparam real __PWSTTHESAT =  0.0;
  localparam real __PLWSTTHESAT =  0.0;
  localparam real __POTHESATB =  0.0;
  localparam real __PLTHESATB =  0.0;
  localparam real __PWTHESATB =  0.0;
  localparam real __PLWTHESATB =  0.0;
  localparam real __POTHESATG =  0.0;
  localparam real __PLTHESATG =  0.0;
  localparam real __PWTHESATG =  0.0;
  localparam real __PLWTHESATG =  0.0;
  localparam real __POAX =  3.0;
  localparam real __PLAX =  0.0;
  localparam real __PWAX =  0.0;
  localparam real __PLWAX =  0.0;
  localparam real __POAXAC =  3.0;
  localparam real __PLAXAC =  0.0;
  localparam real __PWAXAC =  0.0;
  localparam real __PLWAXAC =  0.0;
  localparam real __POALP =  0.01;
  localparam real __PLALP =  0.0;
  localparam real __PWALP =  0.0;
  localparam real __PLWALP =  0.0;
  localparam real __POALPAC =  0.01;
  localparam real __PLALPAC =  0.0;
  localparam real __PWALPAC =  0.0;
  localparam real __PLWALPAC =  0.0;
  localparam real __POALP1 =  0.0;
  localparam real __PLALP1 =  0.0;
  localparam real __PWALP1 =  0.0;
  localparam real __PLWALP1 =  0.0;
  localparam real __POALP2 =  0.0;
  localparam real __PLALP2 =  0.0;
  localparam real __PWALP2 =  0.0;
  localparam real __PLWALP2 =  0.0;
  localparam real __POVP =  0.05;
  localparam real __POA1 =  1.0;
  localparam real __PLA1 =  0.0;
  localparam real __PWA1 =  0.0;
  localparam real __PLWA1 =  0.0;
  localparam real __POA2 =  10.0;
  localparam real __POSTA2 =  0.0;
  localparam real __POA3 =  1.0;
  localparam real __PLA3 =  0.0;
  localparam real __PWA3 =  0.0;
  localparam real __PLWA3 =  0.0;
  localparam real __POA4 =  0.0;
  localparam real __PLA4 =  0.0;
  localparam real __PWA4 =  0.0;
  localparam real __PLWA4 =  0.0;
  localparam real __POGCO =  0.0;
  localparam real __POIGINV =  0.0;
  localparam real __PLIGINV =  0.0;
  localparam real __PWIGINV =  0.0;
  localparam real __PLWIGINV =  0.0;
  localparam real __POIGOV =  0.0;
  localparam real __PLIGOV =  0.0;
  localparam real __PWIGOV =  0.0;
  localparam real __PLWIGOV =  0.0;
  localparam real __POIGOVD =  0.0;
  localparam real __PLIGOVD =  0.0;
  localparam real __PWIGOVD =  0.0;
  localparam real __PLWIGOVD =  0.0;
  localparam real __POSTIG =  2.0;
  localparam real __POGC2 =  0.375;
  localparam real __POGC3 =  0.063;
  localparam real __POGC2OV =  0.375;
  localparam real __POGC3OV =  0.063;
  localparam real __POCHIB =  3.1;
  localparam real __POAGIDL =  0.0;
  localparam real __PLAGIDL =  0.0;
  localparam real __PWAGIDL =  0.0;
  localparam real __PLWAGIDL =  0.0;
  localparam real __POAGIDLD =  0.0;
  localparam real __PLAGIDLD =  0.0;
  localparam real __PWAGIDLD =  0.0;
  localparam real __PLWAGIDLD =  0.0;
  localparam real __POBGIDL =  41.0;
  localparam real __POBGIDLD =  41.0;
  localparam real __POSTBGIDL =  0.0;
  localparam real __POSTBGIDLD =  0.0;
  localparam real __POCGIDL =  0.0;
  localparam real __POCGIDLD =  0.0;
  localparam real __POCOX =  10.0e-15;
  localparam real __PLCOX =  0.0;
  localparam real __PWCOX =  0.0;
  localparam real __PLWCOX =  0.0;
  localparam real __POCGOV =  1.0e-15;
  localparam real __PLCGOV =  0.0;
  localparam real __PWCGOV =  0.0;
  localparam real __PLWCGOV =  0.0;
  localparam real __POCGOVD =  1.0e-15;
  localparam real __PLCGOVD =  0.0;
  localparam real __PWCGOVD =  0.0;
  localparam real __PLWCGOVD =  0.0;
  localparam real __POFCGOVACC =  0.0;
  localparam real __POFCGOVACCD =  0.0;
  localparam real __POCGOVACCG =  1.0;
  localparam real __POCGBOV =  0.0;
  localparam real __PLCGBOV =  0.0;
  localparam real __PWCGBOV =  0.0;
  localparam real __PLWCGBOV =  0.0;
  localparam real __POCINR =  0.0;
  localparam real __PLCINR =  0.0;
  localparam real __PWCINR =  0.0;
  localparam real __PLWCINR =  0.0;
  localparam real __POCINRD =  0.0;
  localparam real __PLCINRD =  0.0;
  localparam real __PWCINRD =  0.0;
  localparam real __PLWCINRD =  0.0;
  localparam real __PODVFBINR =  0.0;
  localparam real __POFCINRDEP =  0.3;
  localparam real __POFCINRACC =  0.5;
  localparam real __POAXINR =  0.5;
  localparam real __POCFR =  0.0;
  localparam real __PLCFR =  0.0;
  localparam real __PWCFR =  0.0;
  localparam real __PLWCFR =  0.0;
  localparam real __POCFRD =  0.0;
  localparam real __PLCFRD =  0.0;
  localparam real __PWCFRD =  0.0;
  localparam real __PLWCFRD =  0.0;
  localparam real __POFNT =  1.0;
  localparam real __POFNTEXC =  0.0;
  localparam real __PLFNTEXC =  0.0;
  localparam real __PWFNTEXC =  0.0;
  localparam real __PLWFNTEXC =  0.0;
  localparam real __PONFA =  80.0e+21;
  localparam real __PLNFA =  0.0;
  localparam real __PWNFA =  0.0;
  localparam real __PLWNFA =  0.0;
  localparam real __PONFB =  30.0e+6;
  localparam real __PLNFB =  0.0;
  localparam real __PWNFB =  0.0;
  localparam real __PLWNFB =  0.0;
  localparam real __PONFC =  0.0;
  localparam real __PLNFC =  0.0;
  localparam real __PWNFC =  0.0;
  localparam real __PLWNFC =  0.0;
  localparam real __POEF =  1.0;
  localparam real __POVFBEDGE = -1.0;
  localparam real __POSTVFBEDGE =  0.0;
  localparam real __PLSTVFBEDGE =  0.0;
  localparam real __PWSTVFBEDGE =  0.0;
  localparam real __PLWSTVFBEDGE =  0.0;
  localparam real __PODPHIBEDGE =  0.0;
  localparam real __PLDPHIBEDGE =  0.0;
  localparam real __PWDPHIBEDGE =  0.0;
  localparam real __PLWDPHIBEDGE =  0.0;
  localparam real __PONEFFEDGE =  500.0e+21;
  localparam real __PLNEFFEDGE =  0.0;
  localparam real __PWNEFFEDGE =  0.0;
  localparam real __PLWNEFFEDGE =  0.0;
  localparam real __POCTEDGE =  0.0;
  localparam real __PLCTEDGE =  0.0;
  localparam real __PWCTEDGE =  0.0;
  localparam real __PLWCTEDGE =  0.0;
  localparam real __POBETNEDGE =  500.0e-6;
  localparam real __PLBETNEDGE =  0.0;
  localparam real __PWBETNEDGE =  0.0;
  localparam real __PLWBETNEDGE =  0.0;
  localparam real __POSTBETEDGE =  1.0;
  localparam real __PLSTBETEDGE =  0.0;
  localparam real __PWSTBETEDGE =  0.0;
  localparam real __PLWSTBETEDGE =  0.0;
  localparam real __POPSCEEDGE =  0.0;
  localparam real __PLPSCEEDGE =  0.0;
  localparam real __PWPSCEEDGE =  0.0;
  localparam real __PLWPSCEEDGE =  0.0;
  localparam real __POPSCEBEDGE =  0.0;
  localparam real __POPSCEDEDGE =  0.0;
  localparam real __POCFEDGE =  0.0;
  localparam real __PLCFEDGE =  0.0;
  localparam real __PWCFEDGE =  0.0;
  localparam real __PLWCFEDGE =  0.0;
  localparam real __POCFDEDGE =  0.0;
  localparam real __POCFBEDGE =  0.0;
  localparam real __POFNTEDGE =  1.0;
  localparam real __PONFAEDGE =  80.0e+21;
  localparam real __PLNFAEDGE =  0.0;
  localparam real __PWNFAEDGE =  0.0;
  localparam real __PLWNFAEDGE =  0.0;
  localparam real __PONFBEDGE =  30.0e+6;
  localparam real __PLNFBEDGE =  0.0;
  localparam real __PWNFBEDGE =  0.0;
  localparam real __PLWNFBEDGE =  0.0;
  localparam real __PONFCEDGE =  0.0;
  localparam real __PLNFCEDGE =  0.0;
  localparam real __PWNFCEDGE =  0.0;
  localparam real __PLWNFCEDGE =  0.0;
  localparam real __POEFEDGE =  1.0;
  localparam real __POKVTHOWE =  0.0;
  localparam real __PLKVTHOWE =  0.0;
  localparam real __PWKVTHOWE =  0.0;
  localparam real __PLWKVTHOWE =  0.0;
  localparam real __POKUOWE =  0.0;
  localparam real __PLKUOWE =  0.0;
  localparam real __PWKUOWE =  0.0;
  localparam real __PLWKUOWE =  0.0;
  localparam real __LMIN = 0;
  localparam real __LMAX =  1.0;
  localparam real __WMIN =  0.0;
  localparam real __WMAX =  1.0;
  localparam real __KVSATAC =  0.0;
  localparam real __IFACTOR =  1.0;
  localparam real __CFACTOR =  1.0;

  integer __CHNL_TYPE;
  real __NF_i, __invNF, __L_i, __W_i, __SA_i, __SB_i, __SD_i, __SC_i, __XGW_i, __JW_i, __SCA_i, __SCB_i, __SCC_i, __NGCON_i, __MULT_i, __FACTUO_i, __DELVTO_i;
  real __FACTUOEDGE_i, __DELVTOEDGE_i;
  real __ABS_i, __LSS_i, __LGS_i, __ABD_i, __LSD_i, __LGD_i, __jwcorr, __jww;
  real __CFACL_i, __CFACW_i, __CFACLEXP_i, __THESATACO_i, __THESATACL_i, __THESATACLEXP_i, __THESATACW_i, __THESATACLW_i, __AXACO_i, __AXACL_i, __ALPACL_i;
  real __ALPACLEXP_i, __ALPACW_i, __POCFAC_i, __PLCFAC_i, __PWCFAC_i, __PLWCFAC_i, __POTHESATAC_i, __PLTHESATAC_i, __PWTHESATAC_i, __PLWTHESATAC_i;
  real __POAXAC_i, __PLAXAC_i, __PWAXAC_i, __PLWAXAC_i, __POALPAC_i, __PLALPAC_i, __PWALPAC_i, __PLWALPAC_i, __KVSATAC_i;
  real __VFB_p, __STVFB_p, __ST2VFB_p, __TOX_p, __EPSROX_p, __NEFF_p, __FACNEFFAC_p, __GFACNUD_p, __VSBNUD_p, __DVSBNUD_p, __VNSUB_p, __NSLP_p, __DNSUB_p;
  real __DPHIB_p, __DELVTAC_p, __NP_p, __CT_p, __CTG_p, __CTB_p, __STCT_p, __TOXOV_p, __TOXOVD_p, __NOV_p, __NOVD_p, __PSCE_p, __PSCED_p, __PSCEB_p, __CF_p, __CFAC_p;
  real __CFD_p, __CFB_p, __BETN_p, __STBET_p, __MUE_p, __STMUE_p, __THEMU_p, __STTHEMU_p, __CS_p, __STCS_p, __THECS_p, __STTHECS_p, __XCOR_p, __STXCOR_p;
  real __FETA_p, __RS_p, __STRS_p, __RSB_p, __RSG_p, __THESAT_p, __THESATAC_p, __STTHESAT_p, __THESATB_p, __THESATG_p, __AX_p, __AXAC_p, __ALP_p, __ALPAC_p;
  real __ALP1_p, __ALP2_p, __VP_p, __A1_p, __A2_p, __STA2_p, __A3_p, __A4_p, __GCO_p, __IGINV_p, __IGOV_p, __IGOVD_p, __STIG_p, __GC2_p, __GC3_p, __GC2OV_p, __GC3OV_p;
  real __CHIB_p, __AGIDL_p, __AGIDLD_p, __BGIDL_p, __BGIDLD_p, __STBGIDL_p, __STBGIDLD_p, __CGIDL_p, __CGIDLD_p, __COX_p, __CGOV_p, __CGOVD_p, __FCGOVACC_p;
  real __FCGOVACCD_p, __CGOVACCG_p, __CGBOV_p, __CINR_p, __CINRD_p, __DVFBINR_p, __FCINRDEP_p, __FCINRACC_p, __AXINR_p, __CFR_p, __CFRD_p, __FNT_p, __FNTEXC_p;
  real __NFA_p, __NFB_p, __NFC_p, __EF_p, __VFBEDGE_p, __STVFBEDGE_p, __DPHIBEDGE_p, __NEFFEDGE_p, __CTEDGE_p, __BETNEDGE_p, __STBETEDGE_p, __PSCEEDGE_p;
  real __PSCEBEDGE_p, __PSCEDEDGE_p, __CFEDGE_p, __CFDEDGE_p, __CFBEDGE_p, __FNTEDGE_p, __NFAEDGE_p, __NFBEDGE_p, __NFCEDGE_p, __EFEDGE_p, __RG_p, __RSH_i;
  real __RSHD_i, __RSE_p, __RDE_p, __RWELL_p, __RBULK_p, __RJUNS_p, __RJUND_p;
  real __MUNQS_p;
  real __VFB_i, __STVFB_i, __ST2VFB_i, __STCT_i, __TOX_i, __EPSROX_i, __NEFF_i, __FACNEFFAC_i, __GFACNUD_i, __VSBNUD_i, __DVSBNUD_i, __VNSUB_i, __NSLP_i;
  real __DNSUB_i, __DPHIB_i, __DELVTAC_i, __NP_i, __CT_i, __CTG_i, __CTB_i, __TOXOV_i, __TOXOVD_i, __NOV_i, __NOVD_i, __CF_i, __CFAC_i, __CFD_i, __CFB_i, __PSCE_i, __PSCEB_i;
  real __PSCED_i, __BETN_i, __STBET_i, __MUE_i, __STMUE_i, __THEMU_i, __STTHEMU_i, __CS_i, __STCS_i, __THECS_i, __STTHECS_i, __XCOR_i, __STXCOR_i, __FETA_i, __RS_i, __STRS_i;
  real __RSB_i, __RSG_i, __THESAT_i, __THESATAC_i, __STTHESAT_i, __THESATB_i, __THESATG_i, __AX_i, __AXAC_i, __ALP_i, __ALPAC_i, __ALP1_i, __ALP2_i, __VP_i, __A1_i, __A2_i;
  real __STA2_i, __A3_i, __A4_i, __GCO_i, __IGINV_i, __IGOV_i, __IGOVD_i, __STIG_i, __GC2_i, __GC3_i, __GC2OV_i, __GC3OV_i, __CHIB_i, __AGIDL_i, __AGIDLD_i, __BGIDL_i;
  real __BGIDLD_i, __STBGIDL_i, __STBGIDLD_i, __CGIDL_i, __CGIDLD_i, __COX_i, __CGOV_i, __CGOVD_i, __FCGOVACC_i, __FCGOVACCD_i, __CGOVACCG_i, __CGBOV_i, __CINR_i;
  real __CINRD_i, __DVFBINR_i, __FCINRDEP_i, __FCINRACC_i, __AXINR_i, __CFR_i, __CFRD_i, __FNT_i, __FNTEXC_i, __NFA_i, __NFB_i, __NFC_i, __EF_i, __VFBEDGE_i, __STVFBEDGE_i;
  real __DPHIBEDGE_i, __NEFFEDGE_i, __CTEDGE_i, __BETNEDGE_i, __STBETEDGE_i, __PSCEEDGE_i, __PSCEBEDGE_i, __PSCEDEDGE_i, __CFEDGE_i, __CFDEDGE_i, __CFBEDGE_i;
  real __FNTEDGE_i, __NFAEDGE_i, __NFBEDGE_i, __NFCEDGE_i, __EFEDGE_i, __RG_i, __RSE_i, __RDE_i, __RBULK_i, __RJUNS_i, __RJUND_i, __RWELL_i;
  real __MUNQS_i;
  real __iL, __iW, __delLPS, __delWOD, __LE, __WE, __LEcv, __WEcv, __Lcv, __Wcv, __iLE, __iWE, __L_f, __L_slif, __W_f, __XGWE, __NSUB0e, __NPCKe, __LPCKe, __AA, __BB, __NSUB;
  real __FBET1e, __LP1e, __GPE, __GWE, __tmpx, __Lnoi, __Lred, __WE_edge, __iWE_edge, __GPE_edge, __KVTHOWE, __KUOWE;
  real __iLEWE, __iiLE, __iiWE, __iiLEWE, __iiiLEWE, __iLEcv, __iiLEcv, __iiWEcv, __iiLEWEcv, __iiiLEWEcv, __iLcv, __iiLcv, __iiWcv, __iiLWcv, __iiiLWcv;
  real __TKR, __TKA, __rTa, __delTa, __phita, __inv_phita, __TKD, __TKD_sq, __delT, __rTn, __ln_rTn, __inv_phit, __Eg, __phibFac;
  real __tkr, __tkd, __auxt, __KBOL_over_QELE, __phitr, __phitrinv, __phitd, __phitdinv;
  real __perfc, __berfc, __cerfc;
  real __deltaphigr, __deltaphigd, __pmax;
  real __phigrbot, __phigrsti, __phigrgat, __phigdbot, __phigdsti, __phigdgat;
  real __ftdbot, __ftdsti, __ftdgat, __idsatbot, __idsatsti, __idsatgat;
  real __ubibot, __ubisti, __ubigat, __vbibot, __vbisti, __vbigat;
  real __vbibot2, __vbisti2, __vbigat2, __pbot2, __psti2, __pgat2, __vbibot2r, __vbisti2r, __vbigat2r;
  real __vbiinvbot, __vbiinvsti, __vbiinvgat;
  real __one_minus_PBOT, __one_minus_PSTI, __one_minus_PGAT;
  real __one_over_one_minus_PBOT, __one_over_one_minus_PSTI, __one_over_one_minus_PGAT;
  real __cjobot, __cjosti, __cjogat;
  real __qprefbot, __qprefsti, __qprefgat, __qpref2bot, __qpref2sti, __qpref2gat;
  real __wdepnulrbot, __wdepnulrsti, __wdepnulrgat, __wdepnulrinvbot, __wdepnulrinvsti, __wdepnulrinvgat;
  real __VBIRBOTinv, __VBIRSTIinv, __VBIRGATinv;
  real __deltaEbot, __deltaEsti, __deltaEgat, __atatbot, __atatsti, __atatgat;
  real __btatpartbot, __btatpartsti, __btatpartgat;
  real __fbbtbot, __fbbtsti, __fbbtgat;
  real __alphaav, __fstopbot, __fstopsti, __fstopgat, __VBRinvbot, __VBRinvsti, __VBRinvgat;
  real __slopebot, __slopesti, __slopegat;
  real __vmaxbot, __vmaxsti, __vmaxgat;
  real __SWJUNEXP_i;
  real __I1, __I2, __I3, __I4, __I5;
  real __I1_cor, __I2_cor, __I3_cor, __I4_cor, __I5_cor;
  real __V1, __V2, __V3, __V4, __V5;
  real __alphaje, __m0_rev, __mcor_rev;
  real __tt0, __tt1, __tt2, __tm0, __tm1;
  real __FRACNA, __FRACNB, __FRACI;
  real __zfrac;
  real __ijunfor1, __ijunfor2, __ijunrev;
  real __CJORBOTD_i, __CJORSTID_i, __CJORGATD_i, __VBIRBOTD_i, __VBIRSTID_i, __VBIRGATD_i;
  real __PBOTD_i, __PSTID_i, __PGATD_i, __PHIGBOTD_i, __PHIGSTID_i, __PHIGGATD_i;
  real __IDSATRBOTD_i, __IDSATRSTID_i, __IDSATRGATD_i, __XJUNSTID_i, __XJUNGATD_i;
  real __CSRHBOTD_i, __CSRHSTID_i, __CSRHGATD_i, __CTATBOTD_i, __CTATSTID_i, __CTATGATD_i;
  real __MEFFTATBOTD_i, __MEFFTATSTID_i, __MEFFTATGATD_i;
  real __CBBTBOTD_i, __CBBTSTID_i, __CBBTGATD_i, __FBBTRBOTD_i, __FBBTRSTID_i, __FBBTRGATD_i;
  real __STFBBTBOTD_i, __STFBBTSTID_i, __STFBBTGATD_i;
  real __VBRBOTD_i, __VBRSTID_i, __VBRGATD_i, __PBRBOTD_i, __PBRSTID_i, __PBRGATD_i;
  real __VJUNREFD_i, __FJUNQD_i;
  real __phigrbot_d, __phigrsti_d, __phigrgat_d, __phigdbot_d, __phigdsti_d, __phigdgat_d;
  real __ftdbot_d, __ftdsti_d, __ftdgat_d, __idsatbot_d, __idsatsti_d, __idsatgat_d;
  real __ubibot_d, __ubisti_d, __ubigat_d, __vbibot_d, __vbisti_d, __vbigat_d;
  real __vbiinvbot_d, __vbiinvsti_d, __vbiinvgat_d;
  real __one_minus_PBOT_d, __one_minus_PSTI_d, __one_minus_PGAT_d;
  real __one_over_one_minus_PBOT_d, __one_over_one_minus_PSTI_d, __one_over_one_minus_PGAT_d;
  real __cjobot_d, __cjosti_d, __cjogat_d;
  real __qprefbot_d, __qprefsti_d, __qprefgat_d, __qpref2bot_d, __qpref2sti_d, __qpref2gat_d;
  real __wdepnulrbot_d, __wdepnulrsti_d, __wdepnulrgat_d, __wdepnulrinvbot_d, __wdepnulrinvsti_d, __wdepnulrinvgat_d;
  real __VBIRBOTinv_d, __VBIRSTIinv_d, __VBIRGATinv_d;
  real __deltaEbot_d, __deltaEsti_d, __deltaEgat_d, __atatbot_d, __atatsti_d, __atatgat_d;
  real __btatpartbot_d, __btatpartsti_d, __btatpartgat_d;
  real __fbbtbot_d, __fbbtsti_d, __fbbtgat_d;
  real __fstopbot_d, __fstopsti_d, __fstopgat_d, __VBRinvbot_d, __VBRinvsti_d, __VBRinvgat_d;
  real __slopebot_d, __slopesti_d, __slopegat_d;
  real __ABSOURCE_i, __LSSOURCE_i, __LGSOURCE_i, __AS_i, __PS_i;
  real __zflagbot_s, __zflagsti_s, __zflaggat_s;
  real __VMAX_s, __exp_VMAX_over_phitd_s, __vbimin_s, __vch_s, __vfmin_s, __vbbtlim_s;
  real __xhighf1_s, __expxhf1_s, __xhighf2_s, __expxhf2_s, __xhighr_s, __expxhr_s, __m0flag_s;
  real __ISATFOR1_s, __MFOR1_s, __ISATFOR2_s, __MFOR2_s, __ISATREV_s, __MREV_s;
  real __ABDRAIN_i, __LSDRAIN_i, __LGDRAIN_i, __AD_i, __PD_i;
  real __zflagbot_d, __zflagsti_d, __zflaggat_d;
  real __VMAX_d, __exp_VMAX_over_phitd_d, __vbimin_d, __vch_d, __vfmin_d, __vbbtlim_d;
  real __xhighf1_d, __expxhf1_d, __xhighf2_d, __expxhf2_d, __xhighr_d, __expxhr_d, __m0flag_d;
  real __ISATFOR1_d, __MFOR1_d, __ISATFOR2_d, __MFOR2_d, __ISATREV_d, __MREV_d;
  real __VFB_T, __CT_T, __CTG_T, __BETN_T, __MUE_T, __THEMU_T, __CS_T, __THECS_T, __XCOR_T, __RS_T, __BGIDL_T, __BGIDLD_T, __A2_T, __VFBEDGE_T, __BETNEDGE_T;
  real __phit, __BET_i, __BETEDGE_i, __nt0, __nt, __THESAT_T, __THESATAC_T, __Sfl_prefac, __phit0edge, __Gfedge2, __lnGfedge2, __Sfl_prefac_edge;
  real __ntedge;
  real __phib_dc, __G_0_dc, __kp, __np, __arg2max, __qlim2, __qb0, __dphibq, __sqrt_phib_dc, __phix_dc, __aphi_dc, __bphi_dc, __phix2, __phix1_dc, __alpha_b;
  real __us1, __us21, __phib_ac, __G_0_ac, __phix_ac, __aphi_ac, __bphi_ac, __phix1_ac, __tf_ct, __tf_bet, __tf_mue, __tf_cs, __tf_xcor, __tf_ther, __THER_i, __tf_thesat;
  real __tf_betedge, __phibedge, __Gfedge, __phixedge, __aphiedge, __bphiedge, __phix2edge, __phix1edge;
  real __EPSSI, __EPSOX, __CoxPrime, __tox_sq, __Cox_over_q, __NEFFAC_i, __qq, __E_eff0, __eta_mu, __eta_mu1, __inv_AX, __inv_VP, __CoxovPrime, __CoxovPrime_d, __GOV_s;
  real __GOV_d, __GOV2_s, __GOV2_d, __dxgb_ov_th, __dxgb_ov_s, __dxgb_ov_d, __SP_OV_eps2_s, __SP_OV_a_s, __SP_OV_delta1_s, __SP_OV_eps2_d, __SP_OV_a_d, __SP_OV_delta1_d;
  real __inv_CHIB, __B_fact, __BCH, __BOV, __BOV_d, __GCQ, __GCQOV, __tf_ig, __AGIDLs, __AGIDLDs, __BGIDLs, __BGIDLDs, __Vinr_max, __ainr, __fac_exc, __ggate, __gsource;
  real __gdrain, __gbulk, __gjuns, __gjund, __gwell;
  real __Vgs, __Vds, __Vsb, __Vdb, __Vgb, __Vjun_s, __Vjun_d, __VgsPrime, __VsbPrime, __VdbPrime, __VgdPrime;
  real __Vdsx;
  real __Vgb1, __Vdsp, __delVg, __Vdsat_lim, __Vdsat;
  real __xgs_ov, __xgd_ov, __xgb_ov, __Vsbstar_dc, __Vsbstar_dc_tmp, __Vmb, __us, __usnew, __Vmbnew, __qeff1_dc, __Voxm_dc, __GdL_dc, __eta_p_dc, __Gvsat_dc;
  real __Gmob_dL_dc, __x_ds_dc, __x_m_dc, __Gf_dc, __Vdsat_dc, __Udse_dc, __SP_OV_xg, __xs_ov, __xd_ov, __Vovs, __Vovd, __zg, __TP, __Fs1, __Fs2, __Fs3, __Fs, __Vm, __Dch;
  real __arg2mina, __psi_t, __arg1, __Dsi, __Dgate, __Igc0, __igc, __igcd_h, __u0, __x, __u0_div_H, __Bg, __Ag, __xsq, __inv_x, __ex, __inv_ex, __Sg, __Igc, __Igb, __Vtovd, __Igidl;
  real __Vtovs, __Igisl, __delVsat, __Vsbstar_ac, __xg_ac, __Gf_ac, __Vgb1_ac, __qeff1_ac, __Voxm_ac, __alpha_ac, __dps_ac, __qim_ac, __GdL_ac, __H_ac, __QG, __QI, __QD;
  real __QB, __Fj, __Fj2, __QCLM, __Qg, __Qd, __Qb, __Qs, __Qsinr, __Qdinr, __Qginr, __Qg_ov_s, __Qg_ov_d, __Qg_ov, __Qgs_ov, __Qgd_ov, __Qgb_ov, __Qfgs, __Qfgd, __rgatenoise;
  real __rsourcenoise, __rdrainnoise, __rbulknoise, __rwellnoise, __rjundnoise, __rjunsnoise;
  real __tme1, __tme2;
  real __inv_GOV, __SP_OV_eps, __SP_OV_delta, __mutau, __nu;
  real __Q_EDGE_xsth, __Q_EDGE_xth0, __Q_EDGE_xth, __Q_EDGE_n, __Q_EDGE_n_inv, __Q_EDGE_xgt, __Q_EDGE_xgt0, __Q_EDGE_xgt0e, __Q_EDGE_qi0si, __Q_EDGE_qi0;
  real __Q_EDGE_exp_x, __Q_EDGE_d0, __Q_EDGE_d0p, __Q_EDGE_sqerr, __Q_EDGE_errq;
  real __N1, __Nm1, __Delta_N1, __Sfl, __t1, __sqt2, __t2, __r, __lc, __lcinv2, __g_ideal, __mid, __temp2_exc, __wsat_exc, __temp_exc, __thesat1_exc, __zsat_exc, __Gvsat_exc;
  real __gfac, __Sidexc, __sqid, __mig, __migid0, __migid, __CGeff, __sqig, __c_igid, __shot_igcsx, __shot_igcdx, __shot_igsov, __shot_igdov, __shot_iavl, __jnoisex_s, __jnoisex_d;
  real __shot_igs, __shot_igd, __anoisedge, __N1edge, __Nm1edge, __Delta_N1edge, __H0edge, __t1edge, __sqt2edge, __t2edge, __redge, __lcedge, __lcinv2edge;
  real __g_idealedge;
  integer __SWNQS_i;
  real __xgm_dc, __thesat1_dc, __xgm_ac, __x_m_ac, __thesat1_ac, __margin_dc, __margin_ac;
  real __Qp1_0, __Qp2_0, __Qp3_0, __Qp4_0, __Qp5_0, __Qp6_0, __Qp7_0, __Qp8_0, __Qp9_0, __fk1, __fk2, __fk3, __fk4, __fk5, __fk6, __fk7, __fk8, __fk9, __phi_p1, __phi_p2, __phi_p3;
  real __phi_p4, __phi_p5, __phi_p6, __phi_p7, __phi_p8, __phi_p9, __Qp1, __Qp2, __Qp3, __Qp4, __Qp5, __Qp6, __Qp7, __Qp8, __Qp9, __Qp0, __QpN, __QG_NQS, __QS_NQS, __QD_NQS, __pd;
  real __Gp, __Gp2, __a_factrp, __marginp, __x_sp, __x_dp, __zsat_nqs, __dfQi, __fQi, __dQis, __dQis_1, __d2Qis, __dQbs, __dQy, __d2Qy, __dpsy2, __ym, __Tnorm, __Qb_tmp;
  real __QbSIGN, __r_nqs, __vnorm, __vnorm_inv, __NQS_xg1, __NQS_yg, __NQS_z, __NQS_eta, __NQS_a, __NQS_c, __NQS_tau, __NQS_D0, __NQS_xi, __NQS_p, __NQS_q, __NQS_temp;
  real __NQS_A_fac, __NQS_xbar, __NQS_w, __NQS_x0, __NQS_u, __NQS_y0, __xphi, __fk0, __thesat2, __Fvsat, __temp3, __temp4, __temp5, __temp6, __temp7, __temp8, __temp9;
  real __gmin;
  real __id_op, __is, __ig, __ib, __P_D, __facvsb, __facvsb0, __sig1k, __vth_i, __vts_i, __ids_i;
  (* units=""             ,                             desc="Flag for channel type" *)
  real __ctype;
  (* units=""             ,                             desc="Flag for source-drain interchange" *)
  real __sdint;
  (* units="A"            , multiplicity="multiply",    desc="Total source current" *)
  real __ise;
  (* units="A"            , multiplicity="multiply",    desc="Total gate current" *)
  real __ige;
  (* units="A"            , multiplicity="multiply",    desc="Total drain current" *)
  real __ide;
  (* units="A"            , multiplicity="multiply",    desc="Total bulk current" *)
  real __ibe;
  (* units="A"            , multiplicity="multiply",    desc="Drain current, excl. edge transistor currents, avalanche, tunnel, GISL, GIDL, and junction currents" *)
  real __ids;
  (* units="A"            , multiplicity="multiply",    desc="Drain to bulk current" *)
  real __idb;
  (* units="A"            , multiplicity="multiply",    desc="Source to bulk current" *)
  real __isb;
  (* units="A"            , multiplicity="multiply",    desc="Gate-source tunneling current" *)
  real __igs;
  (* units="A"            , multiplicity="multiply",    desc="Gate-drain tunneling current" *)
  real __igd;
  (* units="A"            , multiplicity="multiply",    desc="Gate-bulk tunneling current" *)
  real __igb;
  (* units="A"            , multiplicity="multiply",    desc="Drain current of edge transistors" *)
  real __idedge;
  (* units="A"            , multiplicity="multiply",    desc="Gate-channel tunneling current (source component)" *)
  real __igcs;
  (* units="A"            , multiplicity="multiply",    desc="Gate-channel tunneling current (drain component)" *)
  real __igcd;
  (* units="A"            , multiplicity="multiply",    desc="Substrate current due to weak avelanche" *)
  real __iavl;
  (* units="A"            , multiplicity="multiply",    desc="Gate-induced source leakage current" *)
  real __igisl;
  (* units="A"            , multiplicity="multiply",    desc="Gate-induced drain leakage current" *)
  real __igidl;
  (* units="A"            , multiplicity="multiply",    desc="Total source junction current" *)
  real __ijs;
  (* units="A"            , multiplicity="multiply",    desc="Source junction current (bottom component)" *)
  real __ijsbot;
  (* units="A"            , multiplicity="multiply",    desc="Source junction current (gate-edge component)" *)
  real __ijsgat;
  (* units="A"            , multiplicity="multiply",    desc="Source junction current (STI-edge component)" *)
  real __ijssti;
  (* units="A"            , multiplicity="multiply",    desc="Total drain junction current" *)
  real __ijd;
  (* units="A"            , multiplicity="multiply",    desc="Drain junction current (bottom component)" *)
  real __ijdbot;
  (* units="A"            , multiplicity="multiply",    desc="Drain junction current (gate-edge component)" *)
  real __ijdgat;
  (* units="A"            , multiplicity="multiply",    desc="Drain junction current (STI-edge component)" *)
  real __ijdsti;
  (* units="V"            ,                             desc="Drain-source voltage" *)
  real __vds;
  (* units="V"            ,                             desc="Gate-source voltage" *)
  real __vgs;
  (* units="V"            ,                             desc="Source-bulk voltage" *)
  real __vsb;
  (* units="V"            ,                             desc="Zero-bias threshold voltage" *)
  real __vto;
  (* units="V"            ,                             desc="Threshold voltage including back bias effects" *)
  real __vts;
  (* units="V"            ,                             desc="Threshold voltage including back bias and drain bias effects" *)
  real __vth;
  (* units="V"            ,                             desc="Effective gate drive voltage including back bias and drain bias effects" *)
  real __vgt;
  (* units="V"            ,                             desc="Drain saturation voltage at actual bias" *)
  real __vdss;
  (* units=""             ,                             desc="Saturation limit" *)
  real __vsat;
  (* units="S"            , multiplicity="multiply",    desc="Transconductance" *)
  real __gm;
  (* units="S"            , multiplicity="multiply",    desc="Substrate transconductance" *)
  real __gmb;
  (* units="S"            , multiplicity="multiply",    desc="Output conductance" *)
  real __gds;
  (* units="S"            , multiplicity="multiply",    desc="Source junction conductance" *)
  real __gjs;
  (* units="S"            , multiplicity="multiply",    desc="Drain junction conductance" *)
  real __gjd;
  (* units="F"            , multiplicity="multiply",    desc="Drain capacitance" *)
  real __cdd;
  (* units="F"            , multiplicity="multiply",    desc="Drain-gate capacitance" *)
  real __cdg;
  (* units="F"            , multiplicity="multiply",    desc="Drain-source capacitance" *)
  real __cds;
  (* units="F"            , multiplicity="multiply",    desc="Drain-bulk capacitance" *)
  real __cdb;
  (* units="F"            , multiplicity="multiply",    desc="Gate-drain capacitance" *)
  real __cgd;
  (* units="F"            , multiplicity="multiply",    desc="Gate capacitance" *)
  real __cgg;
  (* units="F"            , multiplicity="multiply",    desc="Gate-source capacitance" *)
  real __cgs;
  (* units="F"            , multiplicity="multiply",    desc="Gate-bulk capacitance" *)
  real __cgb;
  (* units="F"            , multiplicity="multiply",    desc="Source-drain capacitance" *)
  real __csd;
  (* units="F"            , multiplicity="multiply",    desc="Source-gate capacitance" *)
  real __csg;
  (* units="F"            , multiplicity="multiply",    desc="Source capacitance" *)
  real __css;
  (* units="F"            , multiplicity="multiply",    desc="Source-bulk capacitance" *)
  real __csb;
  (* units="F"            , multiplicity="multiply",    desc="Bulk-drain capacitance" *)
  real __cbd;
  (* units="F"            , multiplicity="multiply",    desc="Bulk-gate capacitance" *)
  real __cbg;
  (* units="F"            , multiplicity="multiply",    desc="Bulk-source capacitance" *)
  real __cbs;
  (* units="F"            , multiplicity="multiply",    desc="Bulk capacitance" *)
  real __cbb;
  (* units="F"            , multiplicity="multiply",    desc="Total gate-source overlap capacitance" *)
  real __cgsol;
  (* units="F"            , multiplicity="multiply",    desc="Total gate-drain overlap capacitance" *)
  real __cgdol;
  (* units="F"            , multiplicity="multiply",    desc="Total source junction capacitance" *)
  real __cjs;
  (* units="F"            , multiplicity="multiply",    desc="Source junction capacitance (bottom component)" *)
  real __cjsbot;
  (* units="F"            , multiplicity="multiply",    desc="Source junction capacitance (gate-edge component)" *)
  real __cjsgat;
  (* units="F"            , multiplicity="multiply",    desc="Source junction capacitance (STI-edge component)" *)
  real __cjssti;
  (* units="F"            , multiplicity="multiply",    desc="Total drain junction capacitance" *)
  real __cjd;
  (* units="F"            , multiplicity="multiply",    desc="Drain junction capacitance (bottom component)" *)
  real __cjdbot;
  (* units="F"            , multiplicity="multiply",    desc="Drain junction capacitance (gate-edge component)" *)
  real __cjdgat;
  (* units="F"            , multiplicity="multiply",    desc="Drain junction capacitance (STI-edge component)" *)
  real __cjdsti;
  (* units="m"            ,                             desc="Effective channel width for geometrical models" *)
  real __weff;
  (* units="m"            ,                             desc="Effective channel length for geometrical models" *)
  real __leff;
  (* units=""             ,                             desc="Transistor gain" *)
  real __u;
  (* units="Ohm"          , multiplicity="divide",      desc="Small-signal output resistance" *)
  real __rout;
  (* units="V"            ,                             desc="Equivalent Early voltage" *)
  real __vearly;
  (* units="A/V^2"        , multiplicity="multiply",    desc="Gain factor" *)
  real __beff;
  (* units="Hz"           ,                             desc="Unity gain frequency at actual bias" *)
  real __fug;
  (* units="Ohm"          , multiplicity="divide",      desc="Gate resistance" *)
  real __rg;
  (* units="A^2/Hz"       , multiplicity="multiply",    desc="Flicker noise current spectral density at 1 Hz" *)
  real __sfl;
  (* units="V/sqrt(Hz)"   ,                             desc="Input-referred RMS white noise voltage spectral density at 1 kHz" *)
  real __sqrtsff;
  (* units="V/sqrt(Hz)"   ,                             desc="Input-referred RMS white noise voltage spectral density" *)
  real __sqrtsfw;
  (* units="A^2/Hz"       , multiplicity="multiply",    desc="White noise current spectral density" *)
  real __sid;
  (* units="A^2/Hz"       , multiplicity="multiply",    desc="Induced gate noise current spectral density at 1 Hz" *)
  real __sig;
  (* units=""             ,                             desc="Imaginary part of correlation coefficient between Sig and Sid" *)
  real __cigid;
  (* units="Hz"           ,                             desc="Cross-over frequency above which white noise is dominant" *)
  real __fknee;
  (* units="A^2/Hz"       , multiplicity="multiply",    desc="Gate-source current noise spectral density" *)
  real __sigs;
  (* units="A^2/Hz"       , multiplicity="multiply",    desc="Gate-drain current noise spectral density" *)
  real __sigd;
  (* units="A^2/Hz"       , multiplicity="multiply",    desc="Impact ionization current noise spectral density" *)
  real __siavl;
  (* units="A^2/Hz"       , multiplicity="multiply",    desc="Total source junction current noise spectral density" *)
  real __ssi;
  (* units="A^2/Hz"       , multiplicity="multiply",    desc="Total drain junction current noise spectral density" *)
  real __sdi;
  (* units="A^2/Hz"       , multiplicity="multiply",    desc="Flicker noise current spectral density at 1 Hz of edge transistors" *)
  real __sfledge;
  (* units="A^2/Hz"       , multiplicity="multiply",    desc="White noise current spectral density of edge transistors" *)
  real __sidedge;
  (* units="V"            ,                             desc="Local parameter VFB after T-scaling and clipping" *)
  real __lp_vfb;
  (* units="V/K"          ,                             desc="Local parameter STVFB after clipping" *)
  real __lp_stvfb;
  (* units="K^-1"         ,                             desc="Local parameter ST2VFB after clipping" *)
  real __lp_st2vfb;
  (* units="m"            ,                             desc="Local parameter TOX after clipping" *)
  real __lp_tox;
  (* units=""             ,                             desc="Local parameter EPSROX after clipping" *)
  real __lp_epsrox;
  (* units="m^-3"         ,                             desc="Local parameter NEFF after clipping" *)
  real __lp_neff;
  (* units=""             ,                             desc="Local parameter FACNEFFAC after clipping" *)
  real __lp_facneffac;
  (* units=""             ,                             desc="Local parameter GFACNUD after clipping" *)
  real __lp_gfacnud;
  (* units="V"            ,                             desc="Local parameter VSBNUD after clipping" *)
  real __lp_vsbnud;
  (* units="V"            ,                             desc="Local parameter DVSBNUD after clipping" *)
  real __lp_dvsbnud;
  (* units="V"            ,                             desc="Local parameter VNSUB after clipping" *)
  real __lp_vnsub;
  (* units="V"            ,                             desc="Local parameter NSLP after clipping" *)
  real __lp_nslp;
  (* units="V^-1"         ,                             desc="Local parameter DNSUB after clipping" *)
  real __lp_dnsub;
  (* units="V"            ,                             desc="Local parameter DPHIB after clipping" *)
  real __lp_dphib;
  (* units="V"            ,                             desc="Local parameter DELVTAC after clipping" *)
  real __lp_delvtac;
  (* units="m^-3"         ,                             desc="Local parameter NP after clipping" *)
  real __lp_np;
  (* units="m"            ,                             desc="Local parameter TOXOV after clipping" *)
  real __lp_toxov;
  (* units="m"            ,                             desc="Local parameter TOXOVD after clipping" *)
  real __lp_toxovd;
  (* units="m^-3"         ,                             desc="Local parameter NOV after clipping" *)
  real __lp_nov;
  (* units="m^-3"         ,                             desc="Local parameter NOVD after clipping" *)
  real __lp_novd;
  (* units=""             ,                             desc="Local parameter CT after clipping" *)
  real __lp_ct;
  (* units=""             ,                             desc="Local parameter CTG after clipping" *)
  real __lp_ctg;
  (* units=""             ,                             desc="Local parameter CTB after clipping" *)
  real __lp_ctb;
  (* units=""             ,                             desc="Local parameter STCT after clipping" *)
  real __lp_stct;
  (* units=""             ,                             desc="Local parameter CF after clipping" *)
  real __lp_cf;
  (* units=""             ,                             desc="Local parameter CFAC after clipping" *)
  real __lp_cfac;
  (* units="V^-1"         ,                             desc="Local parameter CFD after clipping" *)
  real __lp_cfd;
  (* units="V^-1"         ,                             desc="Local parameter CFB after clipping" *)
  real __lp_cfb;
  (* units=""             ,                             desc="Local parameter PSCE after clipping" *)
  real __lp_psce;
  (* units="V^-1"         ,                             desc="Local parameter PSCEB after clipping" *)
  real __lp_psceb;
  (* units="V^-1"         ,                             desc="Local parameter PSCED after clipping" *)
  real __lp_psced;
  (* units="m^2/(V s)"    ,                             desc="Local parameter BETN after T-scaling and clipping" *)
  real __lp_betn;
  (* units=""             ,                             desc="Local parameter STBET after clipping" *)
  real __lp_stbet;
  (* units="m/V"          ,                             desc="Local parameter MUE after T-scaling and clipping" *)
  real __lp_mue;
  (* units=""             ,                             desc="Local parameter STMUE after clipping" *)
  real __lp_stmue;
  (* units=""             ,                             desc="Local parameter THEMU after T-scaling and clipping" *)
  real __lp_themu;
  (* units=""             ,                             desc="Local parameter STTHEMU after clipping" *)
  real __lp_stthemu;
  (* units=""             ,                             desc="Local parameter CS after T-scaling and clipping" *)
  real __lp_cs;
  (* units=""             ,                             desc="Local parameter STCS after clipping" *)
  real __lp_stcs;
  (* units=""             ,                             desc="Local parameter THECS after T-scaling and clipping" *)
  real __lp_thecs;
  (* units=""             ,                             desc="Local parameter STTHECS after clipping" *)
  real __lp_stthecs;
  (* units="V^-1"         ,                             desc="Local parameter XCOR after T-scaling and clipping" *)
  real __lp_xcor;
  (* units=""             ,                             desc="Local parameter STXCOR after clipping" *)
  real __lp_stxcor;
  (* units=""             ,                             desc="Local parameter FETA after clipping" *)
  real __lp_feta;
  (* units="Ohm"          , multiplicity="divide",      desc="Local parameter RS after T-scaling and clipping" *)
  real __lp_rs;
  (* units=""             ,                             desc="Local parameter STRS after clipping" *)
  real __lp_strs;
  (* units="V^-1"         ,                             desc="Local parameter RSB after clipping" *)
  real __lp_rsb;
  (* units="V^-1"         ,                             desc="Local parameter RSG after clipping" *)
  real __lp_rsg;
  (* units="V^-1"         ,                             desc="Local parameter THESAT after T-scaling and clipping" *)
  real __lp_thesat;
  (* units="V^-1"         ,                             desc="Local parameter THESATAC after T-scaling and clipping" *)
  real __lp_thesatac;
  (* units=""             ,                             desc="Local parameter STTHESAT after clipping" *)
  real __lp_stthesat;
  (* units="V^-1"         ,                             desc="Local parameter THESATB after clipping" *)
  real __lp_thesatb;
  (* units="V^-1"         ,                             desc="Local parameter THESATG after clipping" *)
  real __lp_thesatg;
  (* units=""             ,                             desc="Local parameter AX after clipping" *)
  real __lp_ax;
  (* units=""             ,                             desc="Local parameter AXAC after clipping" *)
  real __lp_axac;
  (* units=""             ,                             desc="Local parameter ALP after clipping" *)
  real __lp_alp;
  (* units=""             ,                             desc="Local parameter ALPAC after clipping" *)
  real __lp_alpac;
  (* units="V"            ,                             desc="Local parameter ALP1 after clipping" *)
  real __lp_alp1;
  (* units="V^-1"         ,                             desc="Local parameter ALP2 after clipping" *)
  real __lp_alp2;
  (* units="V"            ,                             desc="Local parameter VP after clipping" *)
  real __lp_vp;
  (* units=""             ,                             desc="Local parameter A1 after clipping" *)
  real __lp_a1;
  (* units="V"            ,                             desc="Local parameter A2 after T-scaling and clipping" *)
  real __lp_a2;
  (* units=""             ,                             desc="Local parameter STA2 after clipping" *)
  real __lp_sta2;
  (* units=""             ,                             desc="Local parameter A3 after clipping" *)
  real __lp_a3;
  (* units="1/sqrt(V)"    ,                             desc="Local parameter A4 after clipping" *)
  real __lp_a4;
  (* units=""             ,                             desc="Local parameter GCO after clipping" *)
  real __lp_gco;
  (* units="A"            , multiplicity="multiply",    desc="Local parameter IGINV after T-scaling and clipping" *)
  real __lp_iginv;
  (* units="A"            , multiplicity="multiply",    desc="Local parameter IGOV after T-scaling and clipping" *)
  real __lp_igov;
  (* units="A"            , multiplicity="multiply",    desc="Local parameter IGOVD after T-scaling and clipping" *)
  real __lp_igovd;
  (* units=""             ,                             desc="Local parameter STIG after clipping" *)
  real __lp_stig;
  (* units=""             ,                             desc="Local parameter GC2 after clipping" *)
  real __lp_gc2;
  (* units=""             ,                             desc="Local parameter GC3 after clipping" *)
  real __lp_gc3;
  (* units=""             ,                             desc="Local parameter GC2OV after clipping" *)
  real __lp_gc2ov;
  (* units=""             ,                             desc="Local parameter GC3OV after clipping" *)
  real __lp_gc3ov;
  (* units="V"            ,                             desc="Local parameter CHIB after clipping" *)
  real __lp_chib;
  (* units="A/V^3"        ,                             desc="Local parameter AGIDL after clipping" *)
  real __lp_agidl;
  (* units="A/V^3"        ,                             desc="Local parameter AGIDLD after clipping" *)
  real __lp_agidld;
  (* units="V"            ,                             desc="Local parameter BGIDL after T-scaling and clipping" *)
  real __lp_bgidl;
  (* units="V"            ,                             desc="Local parameter BGIDLD after T-scaling and clipping" *)
  real __lp_bgidld;
  (* units="V/K"          ,                             desc="Local parameter STBGIDL after clipping" *)
  real __lp_stbgidl;
  (* units="V/K"          ,                             desc="Local parameter STBGIDLD after clipping" *)
  real __lp_stbgidld;
  (* units=""             ,                             desc="Local parameter CGIDL after clipping" *)
  real __lp_cgidl;
  (* units=""             ,                             desc="Local parameter CGIDLD after clipping" *)
  real __lp_cgidld;
  (* units="F"            , multiplicity="multiply",    desc="Local parameter COX after clipping" *)
  real __lp_cox;
  (* units="F"            , multiplicity="multiply",    desc="Local parameter CGOV after clipping" *)
  real __lp_cgov;
  (* units="F"            , multiplicity="multiply",    desc="Local parameter CGOVD after clipping" *)
  real __lp_cgovd;
  (* units=""             ,                             desc="Local parameter FCGOVACC after clipping" *)
  real __lp_fcgovacc;
  (* units=""             ,                             desc="Local parameter FCGOVACCD after clipping" *)
  real __lp_fcgovaccd;
  (* units=""             ,                             desc="Local parameter CGOVACCG after clipping" *)
  real __lp_cgovaccg;
  (* units="F"            , multiplicity="multiply",    desc="Local parameter CGBOV after clipping" *)
  real __lp_cgbov;
  (* units="F"            , multiplicity="multiply",    desc="Local parameter CINR after clipping" *)
  real __lp_cinr;
  (* units="F"            , multiplicity="multiply",    desc="Local parameter CINRD after clipping" *)
  real __lp_cinrd;
  (* units="V"            ,                             desc="Local parameter DVFBINR after clipping" *)
  real __lp_dvfbinr;
  (* units=""             ,                             desc="Local parameter FCINRDEP after clipping" *)
  real __lp_fcinrdep;
  (* units=""             ,                             desc="Local parameter FCINRACC after clipping" *)
  real __lp_fcinracc;
  (* units=""             ,                             desc="Local parameter AXINR after clipping" *)
  real __lp_axinr;
  (* units="F"            , multiplicity="multiply",    desc="Local parameter CFR after clipping" *)
  real __lp_cfr;
  (* units="F"            , multiplicity="multiply",    desc="Local parameter CFRD after clipping" *)
  real __lp_cfrd;
  (* units=""             ,                             desc="Local parameter FNT after clipping" *)
  real __lp_fnt;
  (* units=""             ,                             desc="Local parameter FNTEXC after clipping" *)
  real __lp_fntexc;
  (* units="1/(V m^4)"    ,                             desc="Local parameter NFA after clipping" *)
  real __lp_nfa;
  (* units="1/(V m^4)"    ,                             desc="Local parameter NFB after clipping" *)
  real __lp_nfb;
  (* units="V^-1"         ,                             desc="Local parameter NFC after clipping" *)
  real __lp_nfc;
  (* units=""             ,                             desc="Local parameter EF after clipping" *)
  real __lp_ef;
  (* units="V"            ,                             desc="Local parameter VFBEDGE after T-scaling and clipping" *)
  real __lp_vfbedge;
  (* units="V/K"          ,                             desc="Local parameter STVFBEDGE after clipping" *)
  real __lp_stvfbedge;
  (* units="V"            ,                             desc="Local parameter DPHIBEDGE after clipping" *)
  real __lp_dphibedge;
  (* units="m^-3"         ,                             desc="Local parameter NEFFEDGE after clipping" *)
  real __lp_neffedge;
  (* units=""             ,                             desc="Local parameter CTEDGE after clipping" *)
  real __lp_ctedge;
  (* units="m^2/V/s"      ,                             desc="Local parameter BETNEDGE after T-scaling and clipping" *)
  real __lp_betnedge;
  (* units=""             ,                             desc="Local parameter STBETEDGE after clipping" *)
  real __lp_stbetedge;
  (* units=""             ,                             desc="Local parameter PSCEEDGE after clipping" *)
  real __lp_psceedge;
  (* units="V^-1"         ,                             desc="Local parameter PSCEBEDGE after clipping" *)
  real __lp_pscebedge;
  (* units="V^-1"         ,                             desc="Local parameter PSCEDEDGE after clipping" *)
  real __lp_pscededge;
  (* units="V"            ,                             desc="Local parameter CFEDGE after clipping" *)
  real __lp_cfedge;
  (* units="V^-1"         ,                             desc="Local parameter CFDEDGE after clipping" *)
  real __lp_cfdedge;
  (* units="V^-1"         ,                             desc="Local parameter CFBEDGE after clipping" *)
  real __lp_cfbedge;
  (* units=""             ,                             desc="Local parameter FNTEDGE after clipping" *)
  real __lp_fntedge;
  (* units="1/(V m^4)"    ,                             desc="Local parameter NFAEDGE after clipping" *)
  real __lp_nfaedge;
  (* units="1/(V m^4)"    ,                             desc="Local parameter NFBEDGE after clipping" *)
  real __lp_nfbedge;
  (* units="V^-1"         ,                             desc="Local parameter NFCEDGE after clipping" *)
  real __lp_nfcedge;
  (* units=""             ,                             desc="Local parameter EFEDGE after clipping" *)
  real __lp_efedge;
  (* units="Ohm"          , multiplicity="divide",      desc="Local parameter RG after clipping" *)
  real __lp_rg;
  (* units="Ohm"          , multiplicity="divide",      desc="Local parameter RSE after clipping" *)
  real __lp_rse;
  (* units="Ohm"          , multiplicity="divide",      desc="Local parameter RDE after clipping" *)
  real __lp_rde;
  (* units="Ohm"          , multiplicity="divide",      desc="Local parameter RBULK after clipping" *)
  real __lp_rbulk;
  (* units="Ohm"          , multiplicity="divide",      desc="Local parameter RWELL after clipping" *)
  real __lp_rwell;
  (* units="Ohm"          , multiplicity="divide",      desc="Local parameter RJUNS after clipping" *)
  real __lp_rjuns;
  (* units="Ohm"          , multiplicity="divide",      desc="Local parameter RJUND after clipping" *)
  real __lp_rjund;
  (* units="K"            ,                             desc="Device Temperature" *)
  real __tk;
  (* units="F"            , multiplicity="multiply",    desc="Bottom component of total zero-bias source junction capacitance at device temperature" *)
  real __cjosbot;
  (* units="F"            , multiplicity="multiply",    desc="STI-edge component of total zero-bias source junction capacitance at device temperature" *)
  real __cjossti;
  (* units="F"            , multiplicity="multiply",    desc="Gate-edge component of total zero-bias source junction capacitance at device temperature" *)
  real __cjosgat;
  (* units="V"            ,                             desc="Built-in voltage of source-side bottom junction at device temperature" *)
  real __vbisbot;
  (* units="V"            ,                             desc="Built-in voltage of source-side STI-edge junction at device temperature" *)
  real __vbissti;
  (* units="V"            ,                             desc="Built-in voltage of source-side gate-edge junction at device temperature" *)
  real __vbisgat;
  (* units="A"            , multiplicity="multiply",    desc="Total source-side bottom junction saturation current" *)
  real __idsatsbot;
  (* units="A"            , multiplicity="multiply",    desc="Total source-side STI-edge junction saturation current" *)
  real __idsatssti;
  (* units="A"            , multiplicity="multiply",    desc="Total source-side gate-edge junction saturation current" *)
  real __idsatsgat;
  (* units="F"            , multiplicity="multiply",    desc="Bottom component of total zero-bias drain junction capacitance at device temperature" *)
  real __cjosbotd;
  (* units="F"            , multiplicity="multiply",    desc="STI-edge component of total zero-bias drain junction capacitance at device temperature" *)
  real __cjosstid;
  (* units="F"            , multiplicity="multiply",    desc="Gate-edge component of total zero-bias drain junction capacitance at device temperature" *)
  real __cjosgatd;
  (* units="V"            ,                             desc="Built-in voltage of drain-side bottom junction at device temperature" *)
  real __vbisbotd;
  (* units="V"            ,                             desc="Built-in voltage of drain-side STI-edge junction at device temperature" *)
  real __vbisstid;
  (* units="V"            ,                             desc="Built-in voltage of drain-side gate-edge junction at device temperature" *)
  real __vbisgatd;
  (* units="A"            , multiplicity="multiply",    desc="Total drain-side bottom junction saturation current" *)
  real __idsatsbotd;
  (* units="A"            , multiplicity="multiply",    desc="Total drain-side STI-edge junction saturation current" *)
  real __idsatsstid;
  (* units="A"            , multiplicity="multiply",    desc="Total drain-side gate-edge junction saturation current" *)
  real __idsatsgatd;
  (* units=""             ,                             desc="Local parameter MUNQS after clipping" *)
  real __lp_munqs;

  analog begin
    begin : initial_model
      if (0) begin
      end
      else begin
        __CHNL_TYPE = -1;
      end
      __EPSSI =  104.47941624768e-12;
      if ((__SWNQS <  0.5)) begin
        __SWNQS_i = 0;
      end
      else begin
        if ((__SWNQS <  1.5)) begin
          __SWNQS_i = 1;
        end
        else begin
          if ((__SWNQS <  2.5)) begin
            __SWNQS_i = 2;
          end
          else begin
            if ((__SWNQS <  4.0)) begin
              __SWNQS_i = 3;
            end
            else begin
              if ((__SWNQS <  7.0)) begin
                __SWNQS_i = 5;
              end
              else begin
                __SWNQS_i = 9;
              end
            end
          end
        end
      end
      __r_nqs =  1.0e+3;
      __vnorm =  10.0;
      __vnorm_inv = ( 1.0 / __vnorm);
      __CFACL_i =  112.47e-6;
      if (0) begin
      end
      __CFACLEXP_i =  3.0355;
      if (0) begin
      end
      __CFACW_i = -0.012199;
      if (0) begin
      end
      __THESATACO_i =  0.099164;
      if (0) begin
      end
      __THESATACL_i =  0.005588242;
      if (0) begin
      end
      __THESATACLEXP_i =  2.4434;
      if (0) begin
      end
      __THESATACW_i = -0.148446;
      if (0) begin
      end
      __THESATACLW_i = -0.103;
      if (0) begin
      end
      __AXACO_i =  8.1825;
      if (0) begin
      end
      __AXACL_i =  0.58095;
      if (0) begin
      end
      __ALPACL_i =  0.0047346;
      if (0) begin
      end
      __ALPACLEXP_i =  0.8468;
      if (0) begin
      end
      __ALPACW_i = -0.21042;
      if (0) begin
      end
      __POCFAC_i =  0.0;
      if (0) begin
      end
      __PLCFAC_i =  0.0;
      if (0) begin
      end
      __PWCFAC_i =  0.0;
      if (0) begin
      end
      __PLWCFAC_i =  0.0;
      if (0) begin
      end
      __POTHESATAC_i =  1.0;
      if (0) begin
      end
      __PLTHESATAC_i =  0.0;
      if (0) begin
      end
      __PWTHESATAC_i =  0.0;
      if (0) begin
      end
      __PLWTHESATAC_i =  0.0;
      if (0) begin
      end
      __POAXAC_i =  3.0;
      if (0) begin
      end
      __PLAXAC_i =  0.0;
      if (0) begin
      end
      __PWAXAC_i =  0.0;
      if (0) begin
      end
      __PLWAXAC_i =  0.0;
      if (0) begin
      end
      __POALPAC_i =  0.01;
      if (0) begin
      end
      __PLALPAC_i =  0.0;
      if (0) begin
      end
      __PWALPAC_i =  0.0;
      if (0) begin
      end
      __PLWALPAC_i =  0.0;
      if (0) begin
      end
      __KVSATAC_i =  0.0;
      if (0) begin
      end
      __TKR =  300.15;
      __TKA = ($temperature + __DTA);
      __rTa = (__TKA / __TKR);
      __delTa = (__TKA - __TKR);
      __phita = (__TKA *  86.1726105451295e-6);
      __inv_phita = ( 1.0 / __phita);
      __TKD = __TKA;
      __TKD_sq = (__TKD * __TKD);
      __delT = (__TKD - __TKR);
      __rTn = (__TKR / __TKD);
      __ln_rTn = ln(__rTn);
      __phit = (__TKD *  86.1726105451295e-6);
      __inv_phit = ( 1.0 / __phit);
      __Eg = (( 1.179 - (__TKD *  90.25e-6)) - (__TKD_sq *  305.0e-9));
      __phibFac = (((((__TKD *  450.0e-6) +  1.045) * (((__TKD *  0.0014) +  0.523) - (__TKD_sq *  1.48e-6))) * __TKD_sq) /  90.0e+3);
      __phibFac = (((__phibFac >  0.001))? (__phibFac):( 0.001));
      __nt0 = (__TKD *  55.22602e-24);
      __SWJUNEXP_i =  0.0;
      if (0) begin
      end
      else begin
        __SWJUNEXP_i =  0.0;
      end
      if (1) begin
        __CJORBOTD_i =  863.06e-6;
        __CJORSTID_i =  31.915e-12;
        __CJORGATD_i =  27.474e-12;
        __VBIRBOTD_i =  0.7686;
        __VBIRSTID_i =  1.7036;
        __VBIRGATD_i =  1.399;
        __PBOTD_i =  0.3618;
        __PSTID_i =  0.2548;
        __PGATD_i =  0.6475;
        __PHIGBOTD_i =  1.204;
        __PHIGSTID_i =  0.8186;
        __PHIGGATD_i =  1.65;
        __IDSATRBOTD_i =  26.746e-9;
        __IDSATRSTID_i =  1.1115e-15;
        __IDSATRGATD_i =  0.0;
        __CSRHBOTD_i =  100.0;
        __CSRHSTID_i =  100.0e-6;
        __CSRHGATD_i =  100.0e-6;
        __XJUNSTID_i =  62.92e-9;
        __XJUNGATD_i =  91.05e-6;
        __CTATBOTD_i =  100.0;
        __CTATSTID_i =  100.0e-6;
        __CTATGATD_i =  100.0e-6;
        __MEFFTATBOTD_i =  10.0;
        __MEFFTATSTID_i =  4.363;
        __MEFFTATGATD_i =  0.25;
        __CBBTBOTD_i =  1.0e-12;
        __CBBTSTID_i =  1.0e-21;
        __CBBTGATD_i =  1.0e-18;
        __FBBTRBOTD_i =  1.0e+9;
        __FBBTRSTID_i =  1.0e+9;
        __FBBTRGATD_i =  1.0e+9;
        __STFBBTBOTD_i = -0.001;
        __STFBBTSTID_i = -0.001;
        __STFBBTGATD_i = -0.001;
        __VBRBOTD_i =  10.0;
        __VBRSTID_i =  10.0;
        __VBRGATD_i =  10.0;
        __PBRBOTD_i =  4.0;
        __PBRSTID_i =  4.0;
        __PBRGATD_i =  4.0;
        __VJUNREFD_i =  2.5;
        __FJUNQD_i =  0.03;
      end
      else begin
      end
      __tkr =  294.15;
      __tkd = max(($temperature + __DTA),  23.15);
      __auxt = (__tkd / __tkr);
      __KBOL_over_QELE =  86.1726105451295e-6;
      __phitr = (__KBOL_over_QELE * __tkr);
      __phitrinv = ( 1.0 / __phitr);
      __phitd = (__KBOL_over_QELE * __tkd);
      __phitdinv = ( 1.0 / __phitd);
      __deltaphigr = ((- ((__tkr *  702.0e-6) * __tkr)) / (__tkr +  1.108e+3));
      __phigrbot = (__deltaphigr +  1.204);
      __phigrsti = (__deltaphigr +  0.8186);
      __phigrgat = (__deltaphigr +  1.65);
      __deltaphigd = ((- ((__tkd *  702.0e-6) * __tkd)) / (__tkd +  1.108e+3));
      __phigdbot = (__deltaphigd +  1.204);
      __phigdsti = (__deltaphigd +  0.8186);
      __phigdgat = (__deltaphigd +  1.65);
      __ftdbot = (pow(__auxt,  1.5) * exp((((__phigrbot * __phitrinv) - (__phigdbot * __phitdinv)) *  0.5)));
      __ftdsti = (pow(__auxt,  1.5) * exp((((__phigrsti * __phitrinv) - (__phigdsti * __phitdinv)) *  0.5)));
      __ftdgat = (pow(__auxt,  1.5) * exp((((__phigrgat * __phitrinv) - (__phigdgat * __phitdinv)) *  0.5)));
      __idsatbot = ((__ftdbot *  26.746e-9) * __ftdbot);
      __idsatsti = ((__ftdsti *  1.1115e-15) * __ftdsti);
      __idsatgat =  0.0;
      __ubibot = ((__auxt *  0.7686) - ((__phitd *  2.0) * ln(__ftdbot)));
      __ubisti = ((__auxt *  1.7036) - ((__phitd *  2.0) * ln(__ftdsti)));
      __ubigat = ((__auxt *  1.399) - ((__phitd *  2.0) * ln(__ftdgat)));
      __vbibot = (__ubibot + (__phitd * ln((exp((( 0.05 - __ubibot) * __phitdinv)) + 1))));
      __vbisti = (__ubisti + (__phitd * ln((exp((( 0.05 - __ubisti) * __phitdinv)) + 1))));
      __vbigat = (__ubigat + (__phitd * ln((exp((( 0.05 - __ubigat) * __phitdinv)) + 1))));
      __vbiinvbot = ( 1.0 / __vbibot);
      __vbiinvsti = ( 1.0 / __vbisti);
      __vbiinvgat = ( 1.0 / __vbigat);
      __one_minus_PBOT =  0.6382;
      __one_minus_PSTI =  0.7452;
      __one_minus_PGAT =  0.3525;
      __one_over_one_minus_PBOT = ( 1.0 / __one_minus_PBOT);
      __one_over_one_minus_PSTI = ( 1.0 / __one_minus_PSTI);
      __one_over_one_minus_PGAT = ( 1.0 / __one_minus_PGAT);
      __cjobot = (pow((__vbiinvbot *  0.7686),  0.3618) *  863.06e-6);
      __cjosti = (pow((__vbiinvsti *  1.7036),  0.2548) *  31.915e-12);
      __cjogat = (pow((__vbiinvgat *  1.399),  0.6475) *  27.474e-12);
      __qprefbot = ((__cjobot * __vbibot) * __one_over_one_minus_PBOT);
      __qprefsti = ((__cjosti * __vbisti) * __one_over_one_minus_PSTI);
      __qprefgat = ((__cjogat * __vbigat) * __one_over_one_minus_PGAT);
      __qpref2bot = (__cjobot *  2.0);
      __qpref2sti = (__cjosti *  2.0);
      __qpref2gat = (__cjogat *  2.0);
      __wdepnulrbot = (__EPSSI /  863.06e-6);
      __wdepnulrsti = (__EPSSI *  1.97148676171079e+3);
      __wdepnulrgat = (__EPSSI *  3.31404236732911e+6);
      __wdepnulrinvbot = ( 1.0 / __wdepnulrbot);
      __wdepnulrinvsti = ( 1.0 / __wdepnulrsti);
      __wdepnulrinvgat = ( 1.0 / __wdepnulrgat);
      __VBIRBOTinv =  1.30106687483737;
      __VBIRSTIinv =  0.586992251702278;
      __VBIRGATinv =  0.714796283059328;
      __perfc =  0.517816437097108;
      __berfc = (( 4.5392668 - pow(__perfc, -2.0)) /  3.0);
      __cerfc = ( 0.70785336 - __berfc);
      __deltaEbot = max((__phigdbot *  0.5), __phitd);
      __deltaEsti = max((__phigdsti *  0.5), __phitd);
      __deltaEgat = max((__phigdgat *  0.5), __phitd);
      __atatbot = (__deltaEbot * __phitdinv);
      __atatsti = (__deltaEsti * __phitdinv);
      __atatgat = (__deltaEgat * __phitdinv);
      __btatpartbot = (sqrt((((__deltaEbot * __deltaEbot) * __deltaEbot) *  46.703929935305e-48)) /  316.371504e-36);
      __btatpartsti = (sqrt((((__deltaEsti * __deltaEsti) * __deltaEsti) *  20.376924630774e-48)) /  316.371504e-36);
      __btatpartgat = (sqrt((((__deltaEgat * __deltaEgat) * __deltaEgat) *  1.1675982483826e-48)) /  316.371504e-36);
      __fbbtbot = ((((__tkd - __tkr) * -0.001) +  1.0) *  1.0e+9);
      __fbbtsti = ((((__tkd - __tkr) * -0.001) +  1.0) *  1.0e+9);
      __fbbtgat = ((((__tkd - __tkr) * -0.001) +  1.0) *  1.0e+9);
      __fbbtbot = (((__fbbtbot >  0.0))? (__fbbtbot):( 0.0));
      __fbbtsti = (((__fbbtsti >  0.0))? (__fbbtsti):( 0.0));
      __fbbtgat = (((__fbbtgat >  0.0))? (__fbbtgat):( 0.0));
      __alphaav =  0.999;
      __fstopbot = ( 1.0 / ( 1.0 - pow(__alphaav,  4.0)));
      __fstopsti = ( 1.0 / ( 1.0 - pow(__alphaav,  4.0)));
      __fstopgat = ( 1.0 / ( 1.0 - pow(__alphaav,  4.0)));
      __VBRinvbot =  0.1;
      __VBRinvsti =  0.1;
      __VBRinvgat =  0.1;
      __slopebot = (((- ((__fstopbot * __fstopbot) * pow(__alphaav,  3.0))) *  4.0) * __VBRinvbot);
      __slopesti = (((- ((__fstopsti * __fstopsti) * pow(__alphaav,  3.0))) *  4.0) * __VBRinvsti);
      __slopegat = (((- ((__fstopgat * __fstopgat) * pow(__alphaav,  3.0))) *  4.0) * __VBRinvgat);
      __phigrbot_d = (__PHIGBOTD_i + __deltaphigr);
      __phigrsti_d = (__PHIGSTID_i + __deltaphigr);
      __phigrgat_d = (__PHIGGATD_i + __deltaphigr);
      __phigdbot_d = (__PHIGBOTD_i + __deltaphigd);
      __phigdsti_d = (__PHIGSTID_i + __deltaphigd);
      __phigdgat_d = (__PHIGGATD_i + __deltaphigd);
      __ftdbot_d = (pow(__auxt,  1.5) * exp((((__phigrbot_d * __phitrinv) - (__phigdbot_d * __phitdinv)) *  0.5)));
      __ftdsti_d = (pow(__auxt,  1.5) * exp((((__phigrsti_d * __phitrinv) - (__phigdsti_d * __phitdinv)) *  0.5)));
      __ftdgat_d = (pow(__auxt,  1.5) * exp((((__phigrgat_d * __phitrinv) - (__phigdgat_d * __phitdinv)) *  0.5)));
      __idsatbot_d = ((__IDSATRBOTD_i * __ftdbot_d) * __ftdbot_d);
      __idsatsti_d = ((__IDSATRSTID_i * __ftdsti_d) * __ftdsti_d);
      __idsatgat_d = ((__IDSATRGATD_i * __ftdgat_d) * __ftdgat_d);
      __ubibot_d = ((__VBIRBOTD_i * __auxt) - ((__phitd *  2.0) * ln(__ftdbot_d)));
      __ubisti_d = ((__VBIRSTID_i * __auxt) - ((__phitd *  2.0) * ln(__ftdsti_d)));
      __ubigat_d = ((__VBIRGATD_i * __auxt) - ((__phitd *  2.0) * ln(__ftdgat_d)));
      __vbibot_d = (__ubibot_d + (__phitd * ln((exp((( 0.05 - __ubibot_d) * __phitdinv)) +  1.0))));
      __vbisti_d = (__ubisti_d + (__phitd * ln((exp((( 0.05 - __ubisti_d) * __phitdinv)) +  1.0))));
      __vbigat_d = (__ubigat_d + (__phitd * ln((exp((( 0.05 - __ubigat_d) * __phitdinv)) +  1.0))));
      __vbiinvbot_d = ( 1.0 / __vbibot_d);
      __vbiinvsti_d = ( 1.0 / __vbisti_d);
      __vbiinvgat_d = ( 1.0 / __vbigat_d);
      __one_minus_PBOT_d = ( 1.0 - __PBOTD_i);
      __one_minus_PSTI_d = ( 1.0 - __PSTID_i);
      __one_minus_PGAT_d = ( 1.0 - __PGATD_i);
      __one_over_one_minus_PBOT_d = ( 1.0 / __one_minus_PBOT_d);
      __one_over_one_minus_PSTI_d = ( 1.0 / __one_minus_PSTI_d);
      __one_over_one_minus_PGAT_d = ( 1.0 / __one_minus_PGAT_d);
      __cjobot_d = (__CJORBOTD_i * pow((__VBIRBOTD_i * __vbiinvbot_d), __PBOTD_i));
      __cjosti_d = (__CJORSTID_i * pow((__VBIRSTID_i * __vbiinvsti_d), __PSTID_i));
      __cjogat_d = (__CJORGATD_i * pow((__VBIRGATD_i * __vbiinvgat_d), __PGATD_i));
      __qprefbot_d = ((__cjobot_d * __vbibot_d) * __one_over_one_minus_PBOT_d);
      __qprefsti_d = ((__cjosti_d * __vbisti_d) * __one_over_one_minus_PSTI_d);
      __qprefgat_d = ((__cjogat_d * __vbigat_d) * __one_over_one_minus_PGAT_d);
      __qpref2bot_d = (__cjobot_d *  2.0);
      __qpref2sti_d = (__cjosti_d *  2.0);
      __qpref2gat_d = (__cjogat_d *  2.0);
      __wdepnulrbot_d = (__EPSSI / __CJORBOTD_i);
      __wdepnulrsti_d = ((__XJUNSTID_i * __EPSSI) / __CJORSTID_i);
      __wdepnulrgat_d = ((__XJUNGATD_i * __EPSSI) / __CJORGATD_i);
      __wdepnulrinvbot_d = ( 1.0 / __wdepnulrbot_d);
      __wdepnulrinvsti_d = ( 1.0 / __wdepnulrsti_d);
      __wdepnulrinvgat_d = ( 1.0 / __wdepnulrgat_d);
      __VBIRBOTinv_d = ( 1.0 / __VBIRBOTD_i);
      __VBIRSTIinv_d = ( 1.0 / __VBIRSTID_i);
      __VBIRGATinv_d = ( 1.0 / __VBIRGATD_i);
      __deltaEbot_d = max((__phigdbot_d *  0.5), __phitd);
      __deltaEsti_d = max((__phigdsti_d *  0.5), __phitd);
      __deltaEgat_d = max((__phigdgat_d *  0.5), __phitd);
      __atatbot_d = (__deltaEbot_d * __phitdinv);
      __atatsti_d = (__deltaEsti_d * __phitdinv);
      __atatgat_d = (__deltaEgat_d * __phitdinv);
      __btatpartbot_d = (sqrt(((__MEFFTATBOTD_i *  4.6703929935305e-48) * ((__deltaEbot_d * __deltaEbot_d) * __deltaEbot_d))) /  316.371504e-36);
      __btatpartsti_d = (sqrt(((__MEFFTATSTID_i *  4.6703929935305e-48) * ((__deltaEsti_d * __deltaEsti_d) * __deltaEsti_d))) /  316.371504e-36);
      __btatpartgat_d = (sqrt(((__MEFFTATGATD_i *  4.6703929935305e-48) * ((__deltaEgat_d * __deltaEgat_d) * __deltaEgat_d))) /  316.371504e-36);
      __fbbtbot_d = (__FBBTRBOTD_i * ((__STFBBTBOTD_i * (__tkd - __tkr)) +  1.0));
      __fbbtsti_d = (__FBBTRSTID_i * ((__STFBBTSTID_i * (__tkd - __tkr)) +  1.0));
      __fbbtgat_d = (__FBBTRGATD_i * ((__STFBBTGATD_i * (__tkd - __tkr)) +  1.0));
      __fbbtbot_d = (((__fbbtbot_d >  0.0))? (__fbbtbot_d):( 0.0));
      __fbbtsti_d = (((__fbbtsti_d >  0.0))? (__fbbtsti_d):( 0.0));
      __fbbtgat_d = (((__fbbtgat_d >  0.0))? (__fbbtgat_d):( 0.0));
      __fstopbot_d = ( 1.0 / ( 1.0 - pow(__alphaav, __PBRBOTD_i)));
      __fstopsti_d = ( 1.0 / ( 1.0 - pow(__alphaav, __PBRSTID_i)));
      __fstopgat_d = ( 1.0 / ( 1.0 - pow(__alphaav, __PBRGATD_i)));
      __VBRinvbot_d = ( 1.0 / __VBRBOTD_i);
      __VBRinvsti_d = ( 1.0 / __VBRSTID_i);
      __VBRinvgat_d = ( 1.0 / __VBRGATD_i);
      __slopebot_d = (((- ((__fstopbot_d * __fstopbot_d) * pow(__alphaav, (__PBRBOTD_i -  1.0)))) * __PBRBOTD_i) * __VBRinvbot_d);
      __slopesti_d = (((- ((__fstopsti_d * __fstopsti_d) * pow(__alphaav, (__PBRSTID_i -  1.0)))) * __PBRSTID_i) * __VBRinvsti_d);
      __slopegat_d = (((- ((__fstopgat_d * __fstopgat_d) * pow(__alphaav, (__PBRGATD_i -  1.0)))) * __PBRGATD_i) * __VBRinvgat_d);
      __gmin = $simparam("gmin",  0.0);
    end
    begin : initial_instance
      real Invsa, Invsb, Invsaref, Invsbref, Kstressu0, rhobeta, rhobetaref, Kstressvth0;
      real temp0, temp00, templ, tempw, Lx, Wx, loop, tmpa, tmpb;
      __NF_i =  1.0;
      __invNF =  1.0;
      __LE =  0.0;
      __WE =  0.0;
      __L_i = __L;
      __W_i = __W;
      __SA_i =  0.0;
      __SB_i =  0.0;
      __SD_i =  0.0;
      __SC_i =  0.0;
      __XGW_i =  100.0e-9;
      __ABSOURCE_i =  1.0e-12;
      __LSSOURCE_i =  1.0e-6;
      __LGSOURCE_i =  1.0e-6;
      __ABDRAIN_i =  1.0e-12;
      __LSDRAIN_i =  1.0e-6;
      __LGDRAIN_i =  1.0e-6;
      __AS_i = __AS;
      __PS_i = __PS;
      __AD_i = __AD;
      __PD_i = __PD;
      __JW_i =  1.0e-6;
      if (1) begin
        __NF_i = (((__NF >  1.0))? (__NF):( 1.0));
        __NF_i = $floor((__NF_i +  0.5));
        __invNF = ( 1.0 / __NF_i);
      end
      __W_i = ((((__W_i * __invNF) >  1.0e-9))? ((__W_i * __invNF)):( 1.0e-9));
      __SCA_i =  0.0;
      __SCB_i =  0.0;
      __SCC_i =  0.0;
      __NGCON_i = (((__NGCON <  1.5))? ( 1.0):( 2.0));
      __iL = ( 1.0e-6 / __L_i);
      __iW = ( 1.0e-6 / __W_i);
      __delLPS = (((__iL * -0.03438) +  1.0) *  96.95e-9);
      __delWOD =  0.0;
      if (0) begin
      end
      __LE = (((((__L_i + __delLPS) -  50.508e-9) >  1.0e-9))? (((__L_i + __delLPS) -  50.508e-9)):( 1.0e-9));
      __WE = (((((__W_i + __delWOD) -  30.0e-9) >  1.0e-9))? (((__W_i + __delWOD) -  30.0e-9)):( 1.0e-9));
      __LEcv = ((((((__L_i + __delLPS) -  50.508e-9) + __DLQ) >  1.0e-9))? ((((__L_i + __delLPS) -  50.508e-9) + __DLQ)):( 1.0e-9));
      __WEcv = ((((((__W_i + __delWOD) -  30.0e-9) + __DWQ) >  1.0e-9))? ((((__W_i + __delWOD) -  30.0e-9) + __DWQ)):( 1.0e-9));
      __Lcv = (((((__L_i + __delLPS) + __DLQ) >  1.0e-9))? (((__L_i + __delLPS) + __DLQ)):( 1.0e-9));
      __Wcv = (((((__W_i + __delWOD) + __DWQ) >  1.0e-9))? (((__W_i + __delWOD) + __DWQ)):( 1.0e-9));
      __iLE = ( 1.0e-6 / __LE);
      __iWE = ( 1.0e-6 / __WE);
      __L_f = ((((__L_i + __delLPS) >  1.0e-9))? ((__L_i + __delLPS)):( 1.0e-9));
      __L_slif = (((__L_f >  1.0e-9))? (__L_f):( 1.0e-9));
      __W_f = ((((__W_i + __delWOD) >  1.0e-9))? ((__W_i + __delWOD)):( 1.0e-9));
      __XGWE = ((((__XGW_i - (__delWOD *  0.5)) >  1.0e-9))? ((__XGW_i - (__delWOD *  0.5))):( 1.0e-9));
      __VFB_p = -1.0;
      __STVFB_p =  500.0e-6;
      __ST2VFB_p =  0.0;
      __TOX_p =  2.0e-9;
      __EPSROX_p =  3.9;
      __NEFF_p =  500.0e+21;
      __FACNEFFAC_p =  1.0;
      __GFACNUD_p =  1.0;
      __VSBNUD_p =  0.0;
      __DVSBNUD_p =  1.0;
      __VNSUB_p =  0.0;
      __NSLP_p =  0.05;
      __DNSUB_p =  0.0;
      __DPHIB_p =  0.0;
      __DELVTAC_p =  0.0;
      __NP_p =  100.0e+24;
      __TOXOV_p =  2.0e-9;
      __TOXOVD_p =  2.0e-9;
      __NOV_p =  50.0e+24;
      __NOVD_p =  50.0e+24;
      __CT_p =  0.0;
      __CTG_p =  0.0;
      __CTB_p =  0.0;
      __STCT_p =  1.0;
      __PSCE_p =  0.0;
      __PSCED_p =  0.0;
      __PSCEB_p =  0.0;
      __CF_p =  0.0;
      __CFAC_p =  0.0;
      if (0) begin
      end
      __CFD_p =  0.0;
      __CFB_p =  0.0;
      __BETN_p =  0.07;
      __STBET_p =  1.0;
      __MUE_p =  0.5;
      __STMUE_p =  0.0;
      __THEMU_p =  1.5;
      __STTHEMU_p =  1.5;
      __CS_p =  0.0;
      __STCS_p =  0.0;
      __THECS_p =  2.0;
      __STTHECS_p =  0.0;
      __XCOR_p =  0.0;
      __STXCOR_p =  0.0;
      __FETA_p =  1.0;
      __RS_p =  30.0;
      __STRS_p =  1.0;
      __RSB_p =  0.0;
      __RSG_p =  0.0;
      __THESAT_p =  1.0;
      __THESATAC_p =  1.0;
      if (0) begin
      end
      __STTHESAT_p =  1.0;
      __THESATB_p =  0.0;
      __THESATG_p =  0.0;
      __AX_p =  3.0;
      __AXAC_p =  3.0;
      if (0) begin
      end
      __ALP_p =  0.01;
      __ALPAC_p =  0.01;
      if (0) begin
      end
      __ALP1_p =  0.0;
      __ALP2_p =  0.0;
      __VP_p =  0.05;
      __A1_p =  1.0;
      __A2_p =  10.0;
      __STA2_p =  0.0;
      __A3_p =  1.0;
      __A4_p =  0.0;
      __GCO_p =  0.0;
      __IGINV_p =  0.0;
      __IGOV_p =  0.0;
      __IGOVD_p =  0.0;
      __STIG_p =  2.0;
      __GC2_p =  0.375;
      __GC3_p =  0.063;
      __GC2OV_p =  0.375;
      __GC3OV_p =  0.063;
      __CHIB_p =  3.1;
      __AGIDL_p =  0.0;
      __AGIDLD_p =  0.0;
      __BGIDL_p =  41.0;
      __BGIDLD_p =  41.0;
      __STBGIDL_p =  0.0;
      __STBGIDLD_p =  0.0;
      __CGIDL_p =  0.0;
      __CGIDLD_p =  0.0;
      __COX_p =  10.0e-15;
      __CGOV_p =  1.0e-15;
      __CGOVD_p =  1.0e-15;
      __FCGOVACC_p =  0.0;
      __FCGOVACCD_p =  0.0;
      __CGOVACCG_p =  1.0;
      __CGBOV_p =  0.0;
      __CINR_p =  0.0;
      __CINRD_p =  0.0;
      __DVFBINR_p =  0.0;
      __FCINRDEP_p =  0.3;
      __FCINRACC_p =  0.5;
      __AXINR_p =  0.5;
      __CFR_p =  0.0;
      __CFRD_p =  0.0;
      __FNT_p =  1.0;
      __FNTEXC_p =  0.0;
      __NFA_p =  80.0e+21;
      __NFB_p =  30.0e+6;
      __NFC_p =  0.0;
      __EF_p =  1.0;
      __VFBEDGE_p = -1.0;
      __STVFBEDGE_p =  500.0e-6;
      __DPHIBEDGE_p =  0.0;
      __NEFFEDGE_p =  500.0e+21;
      __CTEDGE_p =  0.0;
      __BETNEDGE_p =  500.0e-6;
      __STBETEDGE_p =  1.0;
      __PSCEEDGE_p =  0.0;
      __PSCEBEDGE_p =  0.0;
      __PSCEDEDGE_p =  0.0;
      __CFEDGE_p =  0.0;
      __CFDEDGE_p =  0.0;
      __CFBEDGE_p =  0.0;
      __FNTEDGE_p =  1.0;
      __NFAEDGE_p =  80.0e+21;
      __NFBEDGE_p =  30.0e+6;
      __NFCEDGE_p =  0.0;
      __EFEDGE_p =  1.0;
      __RG_p =  0.0;
      __RSE_p =  0.0;
      __RDE_p =  0.0;
      __RWELL_p =  0.0;
      __RBULK_p =  0.0;
      __RJUNS_p =  0.0;
      __RJUND_p =  0.0;
      __MUNQS_p =  1.0;
      if (1) begin
        __VFB_p = ((((__iLE *  0.0089886) + -0.88703) + (__iWE *  0.0071805)) + ((__iLE *  0.004075) * __iWE));
        __STVFB_p = ((((__iLE *  2.4487e-6) +  751.11e-6) + (__iWE *  6.217e-6)) + ((__iLE *  226.68e-9) * __iWE));
        __ST2VFB_p =  0.0;
        __TOX_p =  1.9704e-9;
        __EPSROX_p =  3.9;
        __NSUB0e = (((((((__iWE * -0.013639) * ln(((__WE /  10.58e-9) +  1.0))) +  1.0) >  0.001))? ((((__iWE * -0.013639) * ln(((__WE /  10.58e-9) +  1.0))) +  1.0)):( 0.001)) *  460.11e+21);
        __NPCKe = (((((((__iWE * -1.0) * ln(((__WE /  100.0e-12) +  1.0))) +  1.0) >  0.001))? ((((__iWE * -1.0) * ln(((__WE /  100.0e-12) +  1.0))) +  1.0)):( 0.001)) *  5.7416e+24);
        __LPCKe = (((((((__iWE * -0.022414) * ln(((__WE /  100.0e-12) +  1.0))) +  1.0) >  0.001))? ((((__iWE * -0.022414) * ln(((__WE /  100.0e-12) +  1.0))) +  1.0)):( 0.001)) *  115.76e-12);
        if ((__LE > (__LPCKe *  2.0))) begin
          __AA =  75.0e+9;
          __BB = (sqrt((__NSUB0e + (__NPCKe *  0.5))) - sqrt(__NSUB0e));
          __NSUB = (sqrt(__NSUB0e) + (__AA * ln(((((__LPCKe *  2.0) / __LE) * (exp((__BB / __AA)) -  1.0)) +  1.0))));
          __NSUB = (__NSUB * __NSUB);
        end
        else begin
          if ((__LE >= __LPCKe)) begin
            __NSUB = (__NSUB0e + ((__NPCKe * __LPCKe) / __LE));
          end
          else begin
            __NSUB = (__NSUB0e + (__NPCKe * ( 2.0 - (__LE / __LPCKe))));
          end
        end
        __NEFF_p = (__NSUB * (( 1.0 - (__iLE * -0.0081173)) - ((__iLE *  0.0081347) * __iLE)));
        __FACNEFFAC_p =  1.0;
        __GFACNUD_p =  1.0;
        __VSBNUD_p =  0.0;
        __DVSBNUD_p =  1.0;
        __VNSUB_p =  0.0;
        __NSLP_p =  0.05;
        __DNSUB_p =  0.039707;
        __DPHIB_p = ((((pow(__iLE,  2.9957) *  177.36975e-6) + -0.089784145) + (__iWE *  0.001096441)) + ((__iLE * -0.0030829) * __iWE));
        __DELVTAC_p =  0.0;
        __NP_p = (((( 1.0e-6 > ((__iLE * -0.095923) +  1.0)))? ( 1.0e-6):(((__iLE * -0.095923) +  1.0))) *  126.99e+24);
        __TOXOV_p =  1.9704e-9;
        __TOXOVD_p =  2.0e-9;
        __NOV_p =  31.04e+24;
        __NOVD_p =  50.0e+24;
        __CT_p = ((((pow(__iLE,  1.4316) *  0.0135790359) +  11.814e-6) * ((__iWE *  0.36122) +  1.0)) * (((__iLE * -0.014902) * __iWE) +  1.0));
        __CTG_p =  0.0;
        __CTB_p =  0.0;
        __STCT_p =  1.0;
        __CF_p = ((pow(__iLE,  3.0355) *  112.47e-6) * ((__iWE * -0.012199) +  1.0));
        __CFAC_p = ((__CFACL_i * pow(__iLE, __CFACLEXP_i)) * ((__CFACW_i * __iWE) +  1.0));
        __CFD_p =  0.0;
        __CFB_p =  0.57877;
        __PSCE_p =  0.0;
        __PSCED_p =  0.0;
        __PSCEB_p =  0.0;
        __FBET1e = (((__iWE * -0.065541) +  1.0) * -0.2152);
        __LP1e =  197.66e-6;
        __GPE = (((((__FBET1e * __LP1e) / __LE) * ( 1.0 - exp(((- __LE) / __LP1e)))) +  1.0) + ((-77.532444e-9 / __LE) * ( 1.0 - exp(((- __LE) /  12.564e-9)))));
        __GPE = (((__GPE >  1.0e-15))? (__GPE):( 1.0e-15));
        __GWE = (((__iWE * -0.3268) +  1.0) + ((__iWE *  0.060181) * ln(((__WE /  542.4e-12) +  1.0))));
        __BETN_p = (((__WE *  0.017232) / (__GPE * __LE)) * __GWE);
        __STBET_p = ((((__iLE * -0.037605) +  1.6974) + (__iWE * -0.0083384)) + ((__iLE *  0.0013663) * __iWE));
        __MUE_p = (((__iWE * -0.070919528) +  1.0) *  2.3326);
        __STMUE_p =  0.84805;
        __THEMU_p =  1.2615902;
        __STTHEMU_p =  4.441e-15;
        __CS_p = ((((pow(__iLE,  1.5813) *  0.34682) +  0.94214) * ((__iWE * -0.11045) +  1.0)) * (((__iLE *  0.014762) * __iWE) +  1.0));
        __STCS_p =  1.0269;
        __THECS_p =  1.4566;
        __STTHECS_p =  0.0;
        __XCOR_p = (((((__iLE *  0.11698) +  1.0) *  0.092591) * ((__iWE * -0.095907) +  1.0)) * (((__iLE *  0.029574) * __iWE) +  1.0));
        __STXCOR_p =  27.756e-18;
        __FETA_p =  1.0;
        __RS_p = ((__iWE *  538.37736) * ((__iWE * -0.088444) +  1.0));
        __STRS_p = -0.3508;
        __RSB_p =  0.06;
        __RSG_p =  0.495;
        __THESAT_p = ((((((__GWE *  0.005588242) / __GPE) * pow(__iLE,  2.4434)) +  0.099164) * ((__iWE * -0.148446) +  1.0)) * (((__iLE * -0.103) * __iWE) +  1.0));
        __THESATAC_p = (((__THESATACO_i + (((__THESATACL_i * __GWE) / __GPE) * pow(__iLE, __THESATACLEXP_i))) * ((__THESATACW_i * __iWE) +  1.0)) * (((__THESATACLW_i * __iLE) * __iWE) +  1.0));
        __STTHESAT_p = ((((__iLE * -1.9651) +  12.733) + (__iWE * -0.047465)) + ((__iLE *  0.07117) * __iWE));
        __THESATB_p =  0.0;
        __THESATG_p =  0.0;
        __AX_p = ( 8.1825 / ((__iLE *  0.58095) +  1.0));
        __AXAC_p = (__AXACO_i / ((__AXACL_i * __iLE) +  1.0));
        __ALP_p = ((pow(__iLE,  0.8468) *  0.0047346) * ((__iWE * -0.21042) +  1.0));
        __ALPAC_p = ((__ALPACL_i * pow(__iLE, __ALPACLEXP_i)) * ((__ALPACW_i * __iWE) +  1.0));
        __tmpx = pow(__iLE,  0.6408);
        __ALP1_p = (((__tmpx *  0.0040221) * ((__iWE * -0.057981) +  1.0)) / (((__iLE *  16.11e-9) * __tmpx) +  1.0));
        __tmpx = pow(__iLE,  0.25);
        __ALP2_p = ((__tmpx *  0.005286) * ((__iWE *  0.063581) +  1.0));
        __VP_p =  7.3803e-6;
        __A1_p = ((((__iLE *  5.741) +  1.0) *  110.7e-6) * ((__iWE *  5.78) +  1.0));
        __A2_p =  13.33;
        __STA2_p =  2.0;
        __A3_p = ((((__iLE * -0.08391) +  1.0) *  1.526) * ((__iWE * -0.004911) +  1.0));
        __A4_p = ((((__iLE *  0.2771) +  1.0) * -0.005545) * ((__iWE *  0.7101) +  1.0));
        __GCO_p =  0.01231;
        __IGINV_p = (__IGINVLW / (__iWE * __iLE));
        __IGOV_p = ((__LOV *  1.327e+3) / (__iWE *  1.0e-6));
        __IGOVD_p = ( 0.0 / (__iWE *  1.0e-6));
        __STIG_p =  2.3506;
        __GC2_p =  0.54762;
        __GC3_p = -0.29543;
        __GC2OV_p =  0.375;
        __GC3OV_p =  0.063;
        __CHIB_p =  3.1;
        __AGIDL_p = ((__LOV *  73.71e-6) / (__iWE *  1.0e-6));
        __AGIDLD_p = ( 0.0 / (__iWE *  1.0e-6));
        __BGIDL_p =  15.12;
        __BGIDLD_p =  41.0;
        __STBGIDL_p = -0.0014941;
        __STBGIDLD_p =  0.0;
        __CGIDL_p =  0.02068;
        __CGIDLD_p =  0.0;
        __COX_p = (((__WEcv *  34.53133248864e-12) * __LEcv) /  1.9704e-9);
        __CGOV_p = (((__WEcv *  34.53133248864e-12) * __LOV) /  1.9704e-9);
        __CGOVD_p =  0.0;
        __FCGOVACC_p =  0.0;
        __FCGOVACCD_p =  0.0;
        __CGOVACCG_p =  1.0;
        __CGBOV_p = (__Lcv *  21.86e-12);
        __CINR_p =  0.0;
        __CINRD_p =  0.0;
        __DVFBINR_p =  0.0;
        __FCINRDEP_p =  0.3;
        __FCINRACC_p =  0.5;
        __AXINR_p =  0.5;
        __CFR_p = ((__CFRW * __Wcv) /  1.0e-6);
        __CFRD_p =  0.0;
        temp0 = ( 1.0 - (__iLE *  0.02));
        __Lnoi = (((temp0 >  0.001))? (temp0):( 0.001));
        __Lred = ( 1.0 / pow(__Lnoi,  2.118));
        __FNT_p =  1.85;
        __FNTEXC_p =  0.0;
        __NFA_p = (((__Lred * __iWE) * __iLE) *  220.9e+24);
        __NFB_p = (((__Lred * __iWE) * __iLE) *  572.3e+6);
        __NFC_p = (((__Lred * __iWE) * __iLE) *  564.1e-9);
        __EF_p =  1.0;
        __WE_edge =  20.0e-9;
        __iWE_edge = ( 1.0e-6 / __WE_edge);
        __VFBEDGE_p = -1.0;
        __STVFBEDGE_p =  500.0e-6;
        __DPHIBEDGE_p =  0.0;
        __NEFFEDGE_p =  500.0e+21;
        __CTEDGE_p =  0.0;
        __GPE_edge = ((( 0.0 / __LE) * ( 1.0 - exp(((- __LE) /  10.0e-9)))) +  1.0);
        __GPE_edge = (((__GPE_edge >  1.0e-15))? (__GPE_edge):( 1.0e-15));
        __BETNEDGE_p = ((__WE_edge *  0.017232) / (__GPE_edge * __LE));
        __STBETEDGE_p =  1.0;
        __PSCEEDGE_p =  0.0;
        __PSCEBEDGE_p =  0.0;
        __PSCEDEDGE_p =  0.0;
        __CFEDGE_p =  0.0;
        __CFDEDGE_p =  0.0;
        __CFBEDGE_p =  0.0;
        __FNTEDGE_p =  1.0;
        __NFAEDGE_p = ((__iWE_edge * __iLE) *  80.0e+21);
        __NFBEDGE_p = ((__iWE_edge * __iLE) *  30.0e+6);
        __NFCEDGE_p =  0.0;
        __EFEDGE_p =  1.0;
      end
      __KVTHOWE =  0.0;
      __KUOWE =  0.0;
      if (0) begin
      end
      if (1) begin
        __RG_p = ((((__RSHG * (((__W_f *  0.333333333333333) / __NGCON_i) + __XGWE)) / (__NGCON_i * __L_slif)) + ( 1.0e-12 / (__W_f * __L_f))) + (__NF_i * __RGO));
        __RSH_i =  0.0;
        __RSHD_i =  0.0;
        if (1) begin
          __RSHD_i = __RSH_i;
        end
        __RSE_p =  0.0;
        __RDE_p =  0.0;
        __RWELL_p = (__NF_i * __RWELLO);
        __RBULK_p = (__NF_i * __RBULKO);
        __RJUNS_p = (__NF_i * __RJUNSO);
        __RJUND_p = (__NF_i * __RJUNDO);
        __MUNQS_p =  1.0;
        tmpa =  0.0;
        tmpb =  0.0;
        loop =  0.0;
        if ((((__SA_i >  0.0) && (__SB_i >  0.0)) && ((__NF_i ==  1.0) || ((__NF_i >  1.0) && (__SD_i >  0.0))))) begin
          while ((loop < (__NF_i -  0.5))) begin
            tmpa = (tmpa + ( 1.0 / ((__SA_i + (__L_i *  0.5)) + (loop * (__SD_i + __L_i)))));
            tmpb = (tmpb + ( 1.0 / ((__SB_i + (__L_i *  0.5)) + (loop * (__SD_i + __L_i)))));
            loop = (loop +  1.0);
          end
          Invsa = (tmpa * __invNF);
          Invsb = (tmpb * __invNF);
          Invsaref = ( 1.0 / ((__L_i *  0.5) +  1.0e-6));
          Invsbref = ( 1.0 / ((__L_i *  0.5) +  1.0e-6));
          Lx = ((((__L_i + __delLPS) >  1.0e-9))? ((__L_i + __delLPS)):( 1.0e-9));
          Wx = ((((__W_i + __delWOD) >  1.0e-9))? ((__W_i + __delWOD)):( 1.0e-9));
          templ = ( 1.0 / pow(Lx,  0.0));
          tempw = ( 1.0 / pow(Wx,  0.0));
          Kstressu0 =  1.0;
          rhobeta = ( 0.0 / Kstressu0);
          rhobetaref = ( 0.0 / Kstressu0);
          templ = ( 1.0 / pow(Lx,  0.0));
          tempw = ( 1.0 / pow(Wx,  0.0));
          Kstressvth0 =  1.0;
          temp0 = (((Invsa + Invsb) - Invsaref) - Invsbref);
          temp00 = ((rhobeta +  1.0) / (rhobetaref +  1.0));
          __BETN_p = (__BETN_p * temp00);
          __THESAT_p = (__THESAT_p * temp00);
          __THESATAC_p = (((__THESATAC_p * temp00) * ((__KVSATAC_i * rhobetaref) +  1.0)) / ((__KVSATAC_i * rhobeta) +  1.0));
          __BETNEDGE_p = (__BETNEDGE_p * temp00);
          temp00 = ( 0.0 / Kstressvth0);
          __VFB_p = (__VFB_p + temp00);
          __VFBEDGE_p = (__VFBEDGE_p + temp00);
          temp00 = ( 0.0 / pow(Kstressvth0,  1.0));
          __CF_p = (__CF_p + temp00);
          __CFAC_p = (__CFAC_p + temp00);
          __CFEDGE_p = (__CFEDGE_p + temp00);
        end
        if (((((__SCA_i >  0.0) || (__SCB_i >  0.0)) || (__SCC_i >  0.0)) || (__SC_i >  0.0))) begin
          if ((((__SCA_i ==  0.0) && (__SCB_i ==  0.0)) && (__SCC_i ==  0.0))) begin
            temp0 = (__SC_i + __W_i);
            temp00 =  1.0e+6;
            __SCA_i = ( 1.0e-12 / (__SC_i * temp0));
            __SCB_i = (((((__SC_i *  0.1) +  10.0e-9) * exp(((__SC_i * -10.0) * temp00))) - (((temp0 *  0.1) +  10.0e-9) * exp(((temp0 * -10.0) * temp00)))) / __W_i);
            __SCC_i = (((((__SC_i *  0.05) +  2.5e-9) * exp(((__SC_i * -20.0) * temp00))) - (((temp0 *  0.05) +  2.5e-9) * exp(((temp0 * -20.0) * temp00)))) / __W_i);
          end
          temp0 = __SCA_i;
          __VFB_p = (__VFB_p + (__KVTHOWE * temp0));
          __BETN_p = (__BETN_p * ((__KUOWE * temp0) +  1.0));
          __VFBEDGE_p = (__VFBEDGE_p + (__KVTHOWE * temp0));
          __BETNEDGE_p = (__BETNEDGE_p * ((__KUOWE * temp0) +  1.0));
        end
      end
      __VFB_i = __VFB_p;
      __STVFB_i = __STVFB_p;
      __ST2VFB_i = __ST2VFB_p;
      __TOX_i = (((__TOX_p >  100.0e-12))? (__TOX_p):( 100.0e-12));
      __EPSROX_i = (((__EPSROX_p >  1.0))? (__EPSROX_p):( 1.0));
      __NEFF_i = (((__NEFF_p >  100.0e+18))? ((((__NEFF_p <  100.0e+24))? (__NEFF_p):( 100.0e+24))):( 100.0e+18));
      __FACNEFFAC_i = (((__FACNEFFAC_p >  0.0))? (__FACNEFFAC_p):( 0.0));
      __GFACNUD_i = (((__GFACNUD_p >  0.01))? (__GFACNUD_p):( 0.01));
      __VSBNUD_i = (((__VSBNUD_p >  0.0))? (__VSBNUD_p):( 0.0));
      __DVSBNUD_i = (((__DVSBNUD_p >  0.1))? (__DVSBNUD_p):( 0.1));
      __VNSUB_i = __VNSUB_p;
      __NSLP_i = (((__NSLP_p >  0.001))? (__NSLP_p):( 0.001));
      __DNSUB_i = (((__DNSUB_p >  0.0))? ((((__DNSUB_p <  1.0))? (__DNSUB_p):( 1.0))):( 0.0));
      __DPHIB_i = __DPHIB_p;
      __DELVTAC_i = __DELVTAC_p;
      __NP_i = (((__NP_p >  0.0))? (__NP_p):( 0.0));
      __TOXOV_i = (((__TOXOV_p >  100.0e-12))? (__TOXOV_p):( 100.0e-12));
      __TOXOVD_i = (((__TOXOVD_p >  100.0e-12))? (__TOXOVD_p):( 100.0e-12));
      __NOV_i = (((__NOV_p >  100.0e+21))? ((((__NOV_p <  1.0e+27))? (__NOV_p):( 1.0e+27))):( 100.0e+21));
      __NOVD_i = (((__NOVD_p >  100.0e+21))? ((((__NOVD_p <  1.0e+27))? (__NOVD_p):( 1.0e+27))):( 100.0e+21));
      __CT_i = (((__CT_p >  0.0))? (__CT_p):( 0.0));
      __CTG_i = (((__CTG_p >  0.0))? (__CTG_p):( 0.0));
      __CTB_i = __CTB_p;
      __STCT_i = __STCT_p;
      __CF_i = (((__CF_p >  0.0))? (__CF_p):( 0.0));
      __CFAC_i = (((__CFAC_p >  0.0))? (__CFAC_p):( 0.0));
      __CFD_i = (((__CFD_p >  0.0))? (__CFD_p):( 0.0));
      __CFB_i = (((__CFB_p >  0.0))? ((((__CFB_p <  1.0))? (__CFB_p):( 1.0))):( 0.0));
      __PSCE_i = (((__PSCE_p >  0.0))? (__PSCE_p):( 0.0));
      __PSCEB_i = (((__PSCEB_p >  0.0))? ((((__PSCEB_p <  1.0))? (__PSCEB_p):( 1.0))):( 0.0));
      __PSCED_i = (((__PSCED_p >  0.0))? (__PSCED_p):( 0.0));
      __BETN_i = (((__BETN_p >  0.0))? (__BETN_p):( 0.0));
      __STBET_i = __STBET_p;
      __MUE_i = (((__MUE_p >  0.0))? (__MUE_p):( 0.0));
      __STMUE_i = __STMUE_p;
      __THEMU_i = (((__THEMU_p >  0.0))? (__THEMU_p):( 0.0));
      __STTHEMU_i = __STTHEMU_p;
      __CS_i = (((__CS_p >  0.0))? (__CS_p):( 0.0));
      __STCS_i = __STCS_p;
      __THECS_i = (((__THECS_p >  0.0))? (__THECS_p):( 0.0));
      __STTHECS_i = __STTHECS_p;
      __XCOR_i = (((__XCOR_p >  0.0))? (__XCOR_p):( 0.0));
      __STXCOR_i = __STXCOR_p;
      __FETA_i = (((__FETA_p >  0.0))? (__FETA_p):( 0.0));
      __RS_i = (((__RS_p >  0.0))? (__RS_p):( 0.0));
      __STRS_i = __STRS_p;
      __RSB_i = (((__RSB_p > -0.5))? ((((__RSB_p <  1.0))? (__RSB_p):( 1.0))):(-0.5));
      __RSG_i = (((__RSG_p > -0.5))? (__RSG_p):(-0.5));
      __THESAT_i = (((__THESAT_p >  0.0))? (__THESAT_p):( 0.0));
      __THESATAC_i = (((__THESATAC_p >  0.0))? (__THESATAC_p):( 0.0));
      __STTHESAT_i = __STTHESAT_p;
      __THESATB_i = (((__THESATB_p > -0.5))? ((((__THESATB_p <  1.0))? (__THESATB_p):( 1.0))):(-0.5));
      __THESATG_i = (((__THESATG_p > -0.5))? (__THESATG_p):(-0.5));
      __AX_i = (((__AX_p >  2.0))? (__AX_p):( 2.0));
      __AXAC_i = (((__AXAC_p >  2.0))? (__AXAC_p):( 2.0));
      __ALP_i = (((__ALP_p >  0.0))? (__ALP_p):( 0.0));
      __ALPAC_i = (((__ALPAC_p >  0.0))? (__ALPAC_p):( 0.0));
      __ALP1_i = (((__ALP1_p >  0.0))? (__ALP1_p):( 0.0));
      __ALP2_i = (((__ALP2_p >  0.0))? (__ALP2_p):( 0.0));
      __VP_i = (((__VP_p >  100.0e-12))? (__VP_p):( 100.0e-12));
      __A1_i = (((__A1_p >  0.0))? (__A1_p):( 0.0));
      __A2_i = (((__A2_p >  0.0))? (__A2_p):( 0.0));
      __STA2_i = __STA2_p;
      __A3_i = (((__A3_p >  0.0))? (__A3_p):( 0.0));
      __A4_i = (((__A4_p >  0.0))? (__A4_p):( 0.0));
      __GCO_i = (((__GCO_p > -10.0))? ((((__GCO_p <  10.0))? (__GCO_p):( 10.0))):(-10.0));
      __IGINV_i = (((__IGINV_p >  0.0))? (__IGINV_p):( 0.0));
      __IGOV_i = (((__IGOV_p >  0.0))? (__IGOV_p):( 0.0));
      __IGOVD_i = (((__IGOVD_p >  0.0))? (__IGOVD_p):( 0.0));
      __STIG_i = __STIG_p;
      __GC2_i = (((__GC2_p >  0.0))? ((((__GC2_p <  10.0))? (__GC2_p):( 10.0))):( 0.0));
      __GC3_i = (((__GC3_p > -10.0))? ((((__GC3_p <  10.0))? (__GC3_p):( 10.0))):(-10.0));
      __GC2OV_i = __GC2_i;
      __GC3OV_i = __GC3_i;
      if (0) begin
      end
      __CHIB_i = (((__CHIB_p >  1.0))? (__CHIB_p):( 1.0));
      __AGIDL_i = (((__AGIDL_p >  0.0))? (__AGIDL_p):( 0.0));
      __AGIDLD_i = (((__AGIDLD_p >  0.0))? (__AGIDLD_p):( 0.0));
      __BGIDL_i = (((__BGIDL_p >  0.0))? (__BGIDL_p):( 0.0));
      __BGIDLD_i = (((__BGIDLD_p >  0.0))? (__BGIDLD_p):( 0.0));
      __STBGIDL_i = __STBGIDL_p;
      __STBGIDLD_i = __STBGIDLD_p;
      __CGIDL_i = __CGIDL_p;
      __CGIDLD_i = __CGIDLD_p;
      __COX_i = (((__COX_p >  0.0))? (__COX_p):( 0.0));
      __CGOV_i = (((__CGOV_p >  0.0))? (__CGOV_p):( 0.0));
      __CGOVD_i = (((__CGOVD_p >  0.0))? (__CGOVD_p):( 0.0));
      __FCGOVACC_i = (((__FCGOVACC_p >  0.0))? ((((__FCGOVACC_p <  1.0))? (__FCGOVACC_p):( 1.0))):( 0.0));
      __FCGOVACCD_i = (((__FCGOVACCD_p >  0.0))? ((((__FCGOVACCD_p <  1.0))? (__FCGOVACCD_p):( 1.0))):( 0.0));
      __CGOVACCG_i = (((__CGOVACCG_p >  0.1))? ((((__CGOVACCG_p <  1.0))? (__CGOVACCG_p):( 1.0))):( 0.1));
      __CGBOV_i = (((__CGBOV_p >  0.0))? (__CGBOV_p):( 0.0));
      __CINR_i = (((__CINR_p >  0.0))? (__CINR_p):( 0.0));
      __CINRD_i = (((__CINRD_p >  0.0))? (__CINRD_p):( 0.0));
      __DVFBINR_i = __DVFBINR_p;
      __FCINRDEP_i = (((__FCINRDEP_p >  0.0))? ((((__FCINRDEP_p <  1.0))? (__FCINRDEP_p):( 1.0))):( 0.0));
      __FCINRACC_i = (((__FCINRACC_p >  0.0))? ((((__FCINRACC_p <  1.0))? (__FCINRACC_p):( 1.0))):( 0.0));
      __AXINR_i = (((__AXINR_p >  0.01))? ((((__AXINR_p <  1.0))? (__AXINR_p):( 1.0))):( 0.01));
      __CFR_i = (((__CFR_p >  0.0))? (__CFR_p):( 0.0));
      __CFRD_i = (((__CFRD_p >  0.0))? (__CFRD_p):( 0.0));
      __FNT_i = (((__FNT_p >  0.0))? (__FNT_p):( 0.0));
      __FNTEXC_i = (((__FNTEXC_p >  0.0))? (__FNTEXC_p):( 0.0));
      __NFA_i = (((__NFA_p >  0.0))? (__NFA_p):( 0.0));
      __NFB_i = (((__NFB_p >  0.0))? (__NFB_p):( 0.0));
      __NFC_i = (((__NFC_p >  0.0))? (__NFC_p):( 0.0));
      __EF_i = (((__EF_p >  0.0))? (__EF_p):( 0.0));
      __VFBEDGE_i = __VFBEDGE_p;
      __STVFBEDGE_i = __STVFBEDGE_p;
      __DPHIBEDGE_i = __DPHIBEDGE_p;
      __NEFFEDGE_i = (((__NEFFEDGE_p >  100.0e+18))? ((((__NEFFEDGE_p <  100.0e+24))? (__NEFFEDGE_p):( 100.0e+24))):( 100.0e+18));
      __CTEDGE_i = (((__CTEDGE_p >  0.0))? (__CTEDGE_p):( 0.0));
      __BETNEDGE_i = (((__BETNEDGE_p >  0.0))? (__BETNEDGE_p):( 0.0));
      __STBETEDGE_i = __STBETEDGE_p;
      __PSCEEDGE_i = (((__PSCEEDGE_p >  0.0))? (__PSCEEDGE_p):( 0.0));
      __PSCEBEDGE_i = (((__PSCEBEDGE_p >  0.0))? ((((__PSCEBEDGE_p <  1.0))? (__PSCEBEDGE_p):( 1.0))):( 0.0));
      __PSCEDEDGE_i = (((__PSCEDEDGE_p >  0.0))? (__PSCEDEDGE_p):( 0.0));
      __CFEDGE_i = (((__CFEDGE_p >  0.0))? (__CFEDGE_p):( 0.0));
      __CFDEDGE_i = (((__CFDEDGE_p >  0.0))? (__CFDEDGE_p):( 0.0));
      __CFBEDGE_i = (((__CFBEDGE_p >  0.0))? ((((__CFBEDGE_p <  1.0))? (__CFBEDGE_p):( 1.0))):( 0.0));
      __FNTEDGE_i = (((__FNTEDGE_p >  0.0))? (__FNTEDGE_p):( 0.0));
      __NFAEDGE_i = (((__NFAEDGE_p >  0.0))? (__NFAEDGE_p):( 0.0));
      __NFBEDGE_i = (((__NFBEDGE_p >  0.0))? (__NFBEDGE_p):( 0.0));
      __NFCEDGE_i = (((__NFCEDGE_p >  0.0))? (__NFCEDGE_p):( 0.0));
      __EFEDGE_i = (((__EFEDGE_p >  0.0))? (__EFEDGE_p):( 0.0));
      __RG_i = (((__RG_p >  0.0))? (__RG_p):( 0.0));
      __RSE_i = (((__RSE_p >  0.0))? (__RSE_p):( 0.0));
      __RDE_i = (((__RDE_p >  0.0))? (__RDE_p):( 0.0));
      __RBULK_i = (((__RBULK_p >  0.0))? (__RBULK_p):( 0.0));
      __RJUNS_i = (((__RJUNS_p >  0.0))? (__RJUNS_p):( 0.0));
      __RJUND_i = (((__RJUND_p >  0.0))? (__RJUND_p):( 0.0));
      __RWELL_i = (((__RWELL_p >  0.0))? (__RWELL_p):( 0.0));
      __MULT_i = ((((__MULT * __NF_i) >  0.0))? ((__MULT * __NF_i)):( 0.0));
      __FACTUO_i = __FACTUO;
      __DELVTO_i = __DELVTO;
      __FACTUOEDGE_i =  1.0;
      __DELVTOEDGE_i =  0.0;
      __MUNQS_i = (((__MUNQS_p >  0.0))? (__MUNQS_p):( 0.0));
      if (1) begin
        __TOXOVD_i = __TOXOV_i;
        __NOVD_i = __NOV_i;
        __AGIDLD_i = __AGIDL_i;
        __BGIDLD_i = __BGIDL_i;
        __STBGIDLD_i = __STBGIDL_i;
        __CGIDLD_i = __CGIDL_i;
        __IGOVD_i = __IGOV_i;
        __CGOVD_i = __CGOV_i;
        __FCGOVACCD_i = __FCGOVACC_i;
        __CINRD_i = __CINR_i;
        __CFRD_i = __CFR_i;
      end
      __EPSOX = (__EPSROX_i *  8.8541878176e-12);
      __CoxPrime = (__EPSOX / __TOX_i);
      __tox_sq = (__TOX_i * __TOX_i);
      __Cox_over_q = (__CoxPrime /  160.21918e-21);
      __NEFFAC_i = (__FACNEFFAC_i * __NEFF_i);
      __NEFFAC_i = (((__NEFFAC_i >  100.0e+18))? ((((__NEFFAC_i <  100.0e+24))? (__NEFFAC_i):( 100.0e+24))):( 100.0e+18));
      __qq =  0.0;
      if (1) begin
        __qq = (pow(__CoxPrime,  0.666666666666667) *  2.3807972);
        if ((__CHNL_TYPE == -1)) begin
          __qq = (__qq *  1.25146501348372);
        end
      end
      __E_eff0 = ((__CoxPrime *  10.0e-9) / __EPSSI);
      __eta_mu = (__FETA_i *  0.5);
      __eta_mu1 =  0.5;
      if ((__CHNL_TYPE == -1)) begin
        __eta_mu = (__FETA_i *  0.333333333333333);
        __eta_mu1 =  0.333333333333333;
      end
      __inv_AX = ( 1.0 / __AX_i);
      __inv_VP = ( 1.0 / __VP_i);
      __CoxovPrime = (__EPSOX / __TOXOV_i);
      __CoxovPrime_d = (__EPSOX / __TOXOVD_i);
      __GOV_s = (sqrt((((__NOV_i *  320.43836e-21) * __EPSSI) * __inv_phita)) / __CoxovPrime);
      __GOV_d = (sqrt((((__NOVD_i *  320.43836e-21) * __EPSSI) * __inv_phita)) / __CoxovPrime_d);
      __GOV2_s = (__GOV_s * __GOV_s);
      __GOV2_d = (__GOV_d * __GOV_d);
      __dxgb_ov_th = ((ln((exp(((__CGOVACCG_i *  0.005) * __inv_phita)) -  1.0)) / __CGOVACCG_i) - ln((exp((__inv_phita *  0.005)) -  1.0)));
      __dxgb_ov_s = (ln((__GOV_s *  0.5)) + __dxgb_ov_th);
      __dxgb_ov_d = (ln((__GOV_d *  0.5)) + __dxgb_ov_th);
      __inv_GOV = ( 1.0 / __GOV_s);
      __SP_OV_eps = ((__GOV_s *  3.1) +  8.5);
      __SP_OV_eps2_s = (__SP_OV_eps * __SP_OV_eps);
      __SP_OV_delta = (__SP_OV_eps *  0.5);
      if ((__inv_GOV <  0.06)) begin
        __SP_OV_a_s = (__inv_GOV *  64.0);
      end
      else begin
        if ((__inv_GOV <=  0.45)) begin
          __SP_OV_a_s = ((__inv_GOV *  22.0) +  3.0);
        end
        else begin
          if ((__inv_GOV <=  1.6)) begin
            __SP_OV_a_s = ((__inv_GOV * -7.2) +  15.5);
          end
          else begin
            __SP_OV_a_s = __GOV_s;
          end
        end
      end
      __SP_OV_delta1_s = ((__SP_OV_delta + (__GOV2_s *  0.5)) - (__GOV_s * sqrt(((__SP_OV_delta + (__GOV2_s *  0.25)) + __SP_OV_a_s))));
      __inv_GOV = ( 1.0 / __GOV_d);
      __SP_OV_eps = ((__GOV_d *  3.1) +  8.5);
      __SP_OV_eps2_d = (__SP_OV_eps * __SP_OV_eps);
      __SP_OV_delta = (__SP_OV_eps *  0.5);
      if ((__inv_GOV <  0.06)) begin
        __SP_OV_a_d = (__inv_GOV *  64.0);
      end
      else begin
        if ((__inv_GOV <=  0.45)) begin
          __SP_OV_a_d = ((__inv_GOV *  22.0) +  3.0);
        end
        else begin
          if ((__inv_GOV <=  1.6)) begin
            __SP_OV_a_d = ((__inv_GOV * -7.2) +  15.5);
          end
          else begin
            __SP_OV_a_d = __GOV_d;
          end
        end
      end
      __SP_OV_delta1_d = ((__SP_OV_delta + (__GOV2_d *  0.5)) - (__GOV_d * sqrt(((__SP_OV_delta + (__GOV2_d *  0.25)) + __SP_OV_a_d))));
      __phib_dc = ((__Eg + __DPHIB_i) + ((__phit *  2.0) * ln(((__NEFF_i * pow(__phibFac, -0.75)) *  40.0e-27))));
      __phib_dc = (((__phib_dc >  0.05))? (__phib_dc):( 0.05));
      __G_0_dc = (sqrt((((__NEFF_i *  320.43836e-21) * __EPSSI) * __inv_phit)) / __CoxPrime);
      __kp =  0.0;
      __np =  0.0;
      if ((__NP_i >  0.0)) begin
        __arg2max = ( 80.0e+6 / __tox_sq);
        __np = (((__NP_i > __arg2max))? (__NP_i):(__arg2max));
        __np = ((( 5.0e+24 > __np))? ( 5.0e+24):(__np));
        __kp = ((((__CoxPrime *  2.0) * __CoxPrime) * __phit) / ((__np *  160.21918e-21) * __EPSSI));
      end
      __qlim2 = ((__phit *  100.0) * __phit);
      if (1) begin
        __qb0 = sqrt((((__phit * __G_0_dc) * __G_0_dc) * __phib_dc));
        __dphibq = ((__qq *  0.75) * pow(__qb0,  0.666666666666667));
        __phib_dc = (__phib_dc + __dphibq);
        __G_0_dc = (__G_0_dc * (((__dphibq *  1.33333333333333) / __qb0) +  1.0));
      end
      __sqrt_phib_dc = sqrt(__phib_dc);
      __phix_dc = (__phib_dc *  0.95);
      __aphi_dc = ((__phib_dc *  0.0025) * __phib_dc);
      __bphi_dc = __aphi_dc;
      __phix2 = (sqrt(__bphi_dc) *  0.5);
      __phix1_dc = (((__phix_dc - __phix2) - sqrt((((__phix_dc - __phix2) * (__phix_dc - __phix2)) + __aphi_dc))) *  0.5);
      __alpha_b = ((__phib_dc + __Eg) *  0.5);
      __us1 = (sqrt((__VSBNUD_i + __phib_dc)) - __sqrt_phib_dc);
      __us21 = ((sqrt(((__VSBNUD_i + __DVSBNUD_i) + __phib_dc)) - __sqrt_phib_dc) - __us1);
      __phib_ac = (((__Eg + __DPHIB_i) + __DELVTAC_i) + ((__phit *  2.0) * ln(((__NEFFAC_i * pow(__phibFac, -0.75)) *  40.0e-27))));
      __phib_ac = (((__phib_ac >  0.05))? (__phib_ac):( 0.05));
      __G_0_ac = (sqrt((((__NEFFAC_i *  320.43836e-21) * __EPSSI) * __inv_phit)) / __CoxPrime);
      if (1) begin
        __qb0 = sqrt((((__phit * __G_0_ac) * __G_0_ac) * __phib_ac));
        __dphibq = ((__qq *  0.75) * pow(__qb0,  0.666666666666667));
        __phib_ac = (__phib_ac + __dphibq);
        __G_0_ac = (__G_0_ac * (((__dphibq *  1.33333333333333) / __qb0) +  1.0));
      end
      __phix_ac = (__phib_ac *  0.95);
      __aphi_ac = ((__phib_ac *  0.0025) * __phib_ac);
      __bphi_ac = __aphi_ac;
      __phix2 = (sqrt(__bphi_ac) *  0.5);
      __phix1_ac = (((__phix_ac - __phix2) - sqrt((((__phix_ac - __phix2) * (__phix_ac - __phix2)) + __aphi_ac))) *  0.5);
      __VFB_T = ((__VFB_i + ((__STVFB_i * __delT) * ((__ST2VFB_i * __delT) +  1.0))) + __DELVTO_i);
      __tf_ct = exp((__STCT_i * __ln_rTn));
      __CT_T = (__CT_i * __tf_ct);
      __CTG_T = (__CTG_i / __rTn);
      __tf_bet = exp((__STBET_i * __ln_rTn));
      __BETN_T = (__BETN_i * __tf_bet);
      __BET_i = ((__FACTUO_i * __BETN_T) * __CoxPrime);
      __THEMU_T = (__THEMU_i * exp((__STTHEMU_i * __ln_rTn)));
      __tf_mue = exp((__STMUE_i * __ln_rTn));
      __MUE_T = (__MUE_i * __tf_mue);
      __THECS_T = (__THECS_i * exp((__STTHECS_i * __ln_rTn)));
      __tf_cs = exp((__STCS_i * __ln_rTn));
      __CS_T = (__CS_i * __tf_cs);
      __tf_xcor = exp((__STXCOR_i * __ln_rTn));
      __XCOR_T = (__XCOR_i * __tf_xcor);
      __tf_ther = exp((__STRS_i * __ln_rTn));
      __RS_T = (__RS_i * __tf_ther);
      __THER_i = ((__BET_i *  2.0) * __RS_T);
      __tf_thesat = exp((__STTHESAT_i * __ln_rTn));
      __THESAT_T = (__THESAT_i * __tf_thesat);
      __THESATAC_T = (__THESATAC_i * __tf_thesat);
      __A2_T = (__A2_i * exp(((- __STA2_i) * __ln_rTn)));
      __nt = ((__FNT_i *  55.22602e-24) * __TKD);
      __Sfl_prefac = (((__phit * __phit) * __BET_i) / __Cox_over_q);
      if (0) begin
      end
      else begin
        __VFBEDGE_T =  0.0;
        __tf_betedge =  1.0;
        __BETNEDGE_T =  0.0;
        __BETEDGE_i =  0.0;
        __phit0edge = __phit;
        __phibedge =  0.0;
        __Gfedge =  1.0;
        __Gfedge2 =  1.0;
        __lnGfedge2 =  0.0;
        __phixedge =  0.0;
        __aphiedge =  0.0;
        __bphiedge =  0.0;
        __phix2edge =  0.0;
        __phix1edge =  0.0;
        __Sfl_prefac_edge =  0.0;
        __ntedge =  1.0;
      end
      __inv_CHIB = ( 1.0 / __CHIB_i);
      __B_fact = (sqrt((__CHIB_i *  291.89956209565e-51)) *  12.643363733543e+33);
      __BCH = (__B_fact * __TOX_i);
      __BOV = (__B_fact * __TOXOV_i);
      __BOV_d = (__B_fact * __TOXOVD_i);
      __GCQ =  0.0;
      if ((__GC3_i <  0.0)) begin
        __GCQ = ((__GC2_i * -0.495) / __GC3_i);
      end
      __GCQOV = __GCQ;
      if (0) begin
        if ((__GC3OV_i <  0.0)) begin
        end
      end
      __tf_ig = pow(__rTa, __STIG_i);
      __IGINV_i = (__IGINV_i * __tf_ig);
      __IGOV_i = (__IGOV_i * __tf_ig);
      __IGOVD_i = (__IGOVD_i * __tf_ig);
      __AGIDLs = ((__AGIDL_i *  4.0e-18) / (__TOXOV_i * __TOXOV_i));
      __AGIDLDs = ((__AGIDLD_i *  4.0e-18) / (__TOXOVD_i * __TOXOVD_i));
      __B_fact = (((((__STBGIDL_i * __delTa) +  1.0) >  0.0))? (((__STBGIDL_i * __delTa) +  1.0)):( 0.0));
      __BGIDL_T = (__BGIDL_i * __B_fact);
      __BGIDLs = ((__BGIDL_T * __TOXOV_i) *  500.0e+6);
      __B_fact = (((((__STBGIDLD_i * __delTa) +  1.0) >  0.0))? (((__STBGIDLD_i * __delTa) +  1.0)):( 0.0));
      __BGIDLD_T = (__BGIDLD_i * __B_fact);
      __BGIDLDs = ((__BGIDLD_T * __TOXOVD_i) *  500.0e+6);
      __Vinr_max =  0.0;
      if ((__FCINRACC_i >  100.0e-12)) begin
        __Vinr_max = ( 0.75 / __FCINRACC_i);
      end
      __ainr = (__AXINR_i * __AXINR_i);
      __fac_exc = (__FNTEXC_i *  910.93826e-24);
      if ((__RG_i >  0.0)) begin
        __ggate = ( 1.0 / __RG_i);
      end
      else begin
        __ggate =  0.0;
      end
      if ((__RSE_i >  0.0)) begin
        __gsource = ( 1.0 / __RSE_i);
      end
      else begin
        __gsource =  0.0;
      end
      if ((__RDE_i >  0.0)) begin
        __gdrain = ( 1.0 / __RDE_i);
      end
      else begin
        __gdrain =  0.0;
      end
      if ((__RBULK_i >  0.0)) begin
        __gbulk = ( 1.0 / __RBULK_i);
      end
      else begin
        __gbulk =  0.0;
      end
      if ((__RJUNS_i >  0.0)) begin
        __gjuns = ( 1.0 / __RJUNS_i);
      end
      else begin
        __gjuns =  0.0;
      end
      if ((__RJUND_i >  0.0)) begin
        __gjund = ( 1.0 / __RJUND_i);
      end
      else begin
        __gjund =  0.0;
      end
      if ((__RWELL_i >  0.0)) begin
        __gwell = ( 1.0 / __RWELL_i);
      end
      else begin
        __gwell =  0.0;
      end
      __ABS_i =  0.0;
      __LSS_i =  0.0;
      __LGS_i =  0.0;
      __ABD_i =  0.0;
      __LSD_i =  0.0;
      __LGD_i =  0.0;
      __jwcorr =  0.0;
      __jww = __WE;
      if (0) begin
      end
      if (1) begin
        __jwcorr =  1.0;
      end
      __ABS_i = (__ABSOURCE_i * __invNF);
      __LSS_i = (__LSSOURCE_i * __invNF);
      __LGS_i = (__LGSOURCE_i * __invNF);
      __ABD_i = (__ABDRAIN_i * __invNF);
      __LSD_i = (__LSDRAIN_i * __invNF);
      __LGD_i = (__LGDRAIN_i * __invNF);
      if (1) begin
        __ABS_i = (__AS_i * __invNF);
        __LSS_i = ((__PS_i * __invNF) - (__jwcorr * __jww));
        __LGS_i = __jww;
        __ABD_i = (__AD_i * __invNF);
        __LSD_i = ((__PD_i * __invNF) - (__jwcorr * __jww));
        __LGD_i = __jww;
      end
      if (1) begin
        __ABSOURCE_i = (((__ABS_i >  0.0))? (__ABS_i):( 0.0));
        __LSSOURCE_i = (((__LSS_i >  0.0))? (__LSS_i):( 0.0));
        __LGSOURCE_i = (((__LGS_i >  0.0))? (__LGS_i):( 0.0));
        __ABDRAIN_i = (((__ABD_i >  0.0))? (__ABD_i):( 0.0));
        __LSDRAIN_i = (((__LSD_i >  0.0))? (__LSD_i):( 0.0));
        __LGDRAIN_i = (((__LGD_i >  0.0))? (__LGD_i):( 0.0));
      end
      else begin
      end
      __vbimin_s =  0.0;
      __vbimin_d =  0.0;
      __vfmin_s =  0.0;
      __vfmin_d =  0.0;
      __vch_s =  0.0;
      __vch_d =  0.0;
      __vbbtlim_s =  0.0;
      __vbbtlim_d =  0.0;
      __VMAX_s =  0.0;
      __VMAX_d =  0.0;
      __exp_VMAX_over_phitd_s =  0.0;
      __exp_VMAX_over_phitd_d =  0.0;
      __ISATFOR1_s =  0.0;
      __ISATFOR1_d =  0.0;
      __MFOR1_s =  1.0;
      __MFOR1_d =  1.0;
      __ISATFOR2_s =  0.0;
      __ISATFOR2_d =  0.0;
      __MFOR2_s =  1.0;
      __MFOR2_d =  1.0;
      __ISATREV_s =  0.0;
      __ISATREV_d =  0.0;
      __MREV_s =  1.0;
      __MREV_d =  1.0;
      __m0flag_s =  0.0;
      __m0flag_d =  0.0;
      __xhighf1_s =  0.0;
      __xhighf1_d =  0.0;
      __expxhf1_s =  0.0;
      __expxhf1_d =  0.0;
      __xhighf2_s =  0.0;
      __xhighf2_d =  0.0;
      __expxhf2_s =  0.0;
      __expxhf2_d =  0.0;
      __xhighr_s =  0.0;
      __xhighr_d =  0.0;
      __expxhr_s =  0.0;
      __expxhr_d =  0.0;
      __zflagbot_s =  1.0;
      __zflagbot_d =  1.0;
      __zflagsti_s =  1.0;
      __zflagsti_d =  1.0;
      __zflaggat_s =  1.0;
      __zflaggat_d =  1.0;
      __m0_rev =  0.0;
      __mcor_rev =  0.0;
      __I1_cor =  0.0;
      __I2_cor =  0.0;
      __I3_cor =  0.0;
      __I4_cor =  0.0;
      __I5_cor =  0.0;
      __tt0 =  0.0;
      __tt1 =  0.0;
      __tt2 =  0.0;
      __zfrac =  0.0;
      __alphaje =  0.0;
      if (1) begin
        if (((__idsatbot * __ABSOURCE_i) >  0.0)) begin
          __vmaxbot = (__phitd * ln((( 0.0016551 / (__idsatbot * __ABSOURCE_i)) +  1.0)));
        end
        else begin
          __vmaxbot =  100.0e+6;
        end
        if (((__idsatsti * __LSSOURCE_i) >  0.0)) begin
          __vmaxsti = (__phitd * ln((( 0.0016551 / (__idsatsti * __LSSOURCE_i)) +  1.0)));
        end
        else begin
          __vmaxsti =  100.0e+6;
        end
        if (((__idsatgat * __LGSOURCE_i) >  0.0)) begin
          __vmaxgat = (__phitd * ln((( 0.0016551 / (__idsatgat * __LGSOURCE_i)) +  1.0)));
        end
        else begin
          __vmaxgat =  100.0e+6;
        end
        __VMAX_s = min(min(__vmaxbot, __vmaxsti), __vmaxgat);
        if ((abs((__VMAX_s * __phitdinv)) <  230.258509299405)) begin
          __exp_VMAX_over_phitd_s = exp((__VMAX_s * __phitdinv));
        end
        else begin
          if (((__VMAX_s * __phitdinv) <  0.0)) begin
            __exp_VMAX_over_phitd_s = ( 100.0e-102 / (((-230.258509299405 - (__VMAX_s * __phitdinv)) * ((((-230.258509299405 - (__VMAX_s * __phitdinv)) * (((-230.258509299405 - (__VMAX_s * __phitdinv)) *  0.333333333333333) +  1.0)) *  0.5) +  1.0)) +  1.0));
          end
          else begin
            __exp_VMAX_over_phitd_s = (((((__VMAX_s * __phitdinv) -  230.258509299405) * (((((__VMAX_s * __phitdinv) -  230.258509299405) * ((((__VMAX_s * __phitdinv) -  230.258509299405) *  0.333333333333333) +  1.0)) *  0.5) +  1.0)) +  1.0) *  10.0e+99);
          end
        end
        __vbibot2 = __vbibot;
        __vbisti2 = __vbisti;
        __vbigat2 = __vbigat;
        __pbot2 =  0.3618;
        __psti2 =  0.2548;
        __pgat2 =  0.6475;
        __vbibot2r =  0.7686;
        __vbisti2r =  1.7036;
        __vbigat2r =  1.399;
        if ((__ABSOURCE_i ==  0.0)) begin
          __vbibot2 = (__vbisti + __vbigat);
          __pbot2 =  0.22932;
          __vbibot2r =  3.1026;
        end
        if ((__LSSOURCE_i ==  0.0)) begin
          __vbisti2 = (__vbibot + __vbigat);
          __psti2 =  0.32562;
          __vbisti2r =  2.1676;
        end
        if ((__LGSOURCE_i ==  0.0)) begin
          __vbigat2 = (__vbibot + __vbisti);
          __pgat2 =  0.22932;
          __vbigat2r =  2.4722;
        end
        __vbimin_s = min(min(__vbibot2, __vbisti2), __vbigat2);
        __vch_s = (__vbimin_s *  0.1);
        __pmax = max(max(__pbot2, __psti2), __pgat2);
        __vfmin_s = (__vbimin_s * ( 1.0 - pow( 2.0, (-1.0 / __pmax))));
        __vbbtlim_s = (min(min(__vbibot2r, __vbisti2r), __vbigat2r) -  0.05);
        if (((__idsatbot_d * __ABDRAIN_i) >  0.0)) begin
          __vmaxbot = (__phitd * ln((( 0.0016551 / (__idsatbot_d * __ABDRAIN_i)) +  1.0)));
        end
        else begin
          __vmaxbot =  100.0e+6;
        end
        if (((__idsatsti_d * __LSDRAIN_i) >  0.0)) begin
          __vmaxsti = (__phitd * ln((( 0.0016551 / (__idsatsti_d * __LSDRAIN_i)) +  1.0)));
        end
        else begin
          __vmaxsti =  100.0e+6;
        end
        if (((__idsatgat_d * __LGDRAIN_i) >  0.0)) begin
          __vmaxgat = (__phitd * ln((( 0.0016551 / (__idsatgat_d * __LGDRAIN_i)) +  1.0)));
        end
        else begin
          __vmaxgat =  100.0e+6;
        end
        __VMAX_d = min(min(__vmaxbot, __vmaxsti), __vmaxgat);
        if ((abs((__VMAX_d * __phitdinv)) <  230.258509299405)) begin
          __exp_VMAX_over_phitd_d = exp((__VMAX_d * __phitdinv));
        end
        else begin
          if (((__VMAX_d * __phitdinv) <  0.0)) begin
            __exp_VMAX_over_phitd_d = ( 100.0e-102 / (((-230.258509299405 - (__VMAX_d * __phitdinv)) * ((((-230.258509299405 - (__VMAX_d * __phitdinv)) * (((-230.258509299405 - (__VMAX_d * __phitdinv)) *  0.333333333333333) +  1.0)) *  0.5) +  1.0)) +  1.0));
          end
          else begin
            __exp_VMAX_over_phitd_d = (((((__VMAX_d * __phitdinv) -  230.258509299405) * (((((__VMAX_d * __phitdinv) -  230.258509299405) * ((((__VMAX_d * __phitdinv) -  230.258509299405) *  0.333333333333333) +  1.0)) *  0.5) +  1.0)) +  1.0) *  10.0e+99);
          end
        end
        __vbibot2 = __vbibot_d;
        __vbisti2 = __vbisti_d;
        __vbigat2 = __vbigat_d;
        __pbot2 = __PBOTD_i;
        __psti2 = __PSTID_i;
        __pgat2 = __PGATD_i;
        __vbibot2r = __VBIRBOTD_i;
        __vbisti2r = __VBIRSTID_i;
        __vbigat2r = __VBIRGATD_i;
        if ((__ABDRAIN_i ==  0.0)) begin
          __vbibot2 = (__vbisti_d + __vbigat_d);
          __pbot2 = (min(__PSTID_i, __PGATD_i) *  0.9);
          __vbibot2r = (__VBIRSTID_i + __VBIRGATD_i);
        end
        if ((__LSDRAIN_i ==  0.0)) begin
          __vbisti2 = (__vbibot_d + __vbigat_d);
          __psti2 = (min(__PBOTD_i, __PGATD_i) *  0.9);
          __vbisti2r = (__VBIRBOTD_i + __VBIRGATD_i);
        end
        if ((__LGDRAIN_i ==  0.0)) begin
          __vbigat2 = (__vbibot_d + __vbisti_d);
          __pgat2 = (min(__PBOTD_i, __PSTID_i) *  0.9);
          __vbigat2r = (__VBIRBOTD_i + __VBIRSTID_i);
        end
        __vbimin_d = min(min(__vbibot2, __vbisti2), __vbigat2);
        __vch_d = (__vbimin_d *  0.1);
        __pmax = max(max(__pbot2, __psti2), __pgat2);
        __vfmin_d = (__vbimin_d * ( 1.0 - pow( 2.0, (-1.0 / __pmax))));
        __vbbtlim_d = (min(min(__vbibot2r, __vbisti2r), __vbigat2r) -  0.05);
        if ((__SWJUNEXP_i == 1)) begin : JUNCAPexpressInit
          real ysq, terfc, erfcpos;
          real h1, h2, h2d, h3, h4, h5;
          real idmult, vj, z, zinv, two_psistar, vjlim, vjsrh, vbbt, vav;
          real tmp, id;
          real isrh, vbi_minus_vjsrh, wsrhstep, dwsrh, wsrh, wdep, asrh;
          real itat, btat, twoatatoverthreebtat, umaxbeforelimiting, umax, sqrtumax, umaxpoweronepointfive;
          real wgamma, wtat, ktat, ltat, mtat, xerfc, erfctimesexpmtat, gammamax;
          real ibbt, Fmaxr;
          real fbreakdown;
          real ijunbot, ijunsti, ijungat, qjunbot, qjunsti, qjungat;
          ysq =  0.0;
          terfc =  0.0;
          erfcpos =  0.0;
          h1 =  0.0;
          h2 =  0.0;
          h2d =  0.0;
          h3 =  0.0;
          h4 =  0.0;
          h5 =  0.0;
          idmult =  0.0;
          vj =  0.0;
          z =  0.0;
          zinv =  0.0;
          two_psistar =  0.0;
          vjlim =  0.0;
          vjsrh =  0.0;
          vbbt =  0.0;
          vav =  0.0;
          tmp =  0.0;
          id =  0.0;
          isrh =  0.0;
          vbi_minus_vjsrh =  0.0;
          wsrhstep =  0.0;
          dwsrh =  0.0;
          wsrh =  0.0;
          wdep =  0.0;
          asrh =  0.0;
          itat =  0.0;
          btat =  0.0;
          twoatatoverthreebtat =  0.0;
          umaxbeforelimiting =  0.0;
          umax =  0.0;
          sqrtumax =  0.0;
          umaxpoweronepointfive =  0.0;
          wgamma =  0.0;
          wtat =  0.0;
          ktat =  0.0;
          ltat =  0.0;
          mtat =  0.0;
          xerfc =  0.0;
          erfctimesexpmtat =  0.0;
          gammamax =  0.0;
          ibbt =  0.0;
          Fmaxr =  0.0;
          fbreakdown =  0.0;
          __FRACNA =  0.4;
          __FRACNB =  0.65;
          __FRACI =  0.8;
          __V1 = ((- __FRACNA) *  2.5);
          __V2 = ((- __FRACNB) *  2.5);
          __V3 = ((- __FRACI) *  2.5);
          __V4 =  0.1;
          __V5 =  0.2;
          vbbt =  0.0;
          two_psistar =  0.0;
          if ((! (((__ABSOURCE_i ==  0.0) && (__LSSOURCE_i ==  0.0)) && (__LGSOURCE_i ==  0.0)))) begin
            h1 = ((__vch_s *  4.0) * __vch_s);
            h2 = (__vch_s / __vfmin_s);
            h2d = (__V1 + (__vch_s * h2));
            h3 = (__vfmin_s + h2d);
            h4 = (__vfmin_s - h2d);
            h5 = sqrt(((h4 * h4) + h1));
            vj = (((__V1 * __vfmin_s) / (h3 + h5)) *  2.0);
            if ((__V1 < __VMAX_s)) begin
              if ((abs(((__V1 * __phitdinv) *  0.5)) <  230.258509299405)) begin
                zinv = exp(((__V1 * __phitdinv) *  0.5));
              end
              else begin
                if ((((__V1 * __phitdinv) *  0.5) <  0.0)) begin
                  zinv = ( 100.0e-102 / (((-230.258509299405 - ((__V1 * __phitdinv) *  0.5)) * ((((-230.258509299405 - ((__V1 * __phitdinv) *  0.5)) * (((-230.258509299405 - ((__V1 * __phitdinv) *  0.5)) *  0.333333333333333) +  1.0)) *  0.5) +  1.0)) +  1.0));
                end
                else begin
                  zinv = ((((((__V1 * __phitdinv) *  0.5) -  230.258509299405) * ((((((__V1 * __phitdinv) *  0.5) -  230.258509299405) * (((((__V1 * __phitdinv) *  0.5) -  230.258509299405) *  0.333333333333333) +  1.0)) *  0.5) +  1.0)) +  1.0) *  10.0e+99);
                end
              end
              idmult = (zinv * zinv);
            end
            else begin
              idmult = ((((__V1 - __VMAX_s) * __phitdinv) +  1.0) * __exp_VMAX_over_phitd_s);
              zinv = sqrt(idmult);
            end
            idmult = (idmult -  1.0);
            z = ( 1.0 / zinv);
            if ((__V1 >  0.0)) begin
              two_psistar = ((__phitd * ln(((z +  2.0) + sqrt(((z +  1.0) * (z +  3.0)))))) *  2.0);
            end
            else begin
              two_psistar = ((- __V1) + ((__phitd * ln((((zinv *  2.0) +  1.0) + sqrt(((zinv +  1.0) * ((zinv *  3.0) +  1.0)))))) *  2.0));
            end
            vjlim = (__vbimin_s - two_psistar);
            vjsrh = (((__V1 + vjlim) - sqrt((((__V1 - vjlim) * (__V1 - vjlim)) + ((__phitd *  4.0) * __phitd)))) *  0.5);
            vbbt = (((__V1 + __vbbtlim_s) - sqrt((((__V1 - __vbbtlim_s) * (__V1 - __vbbtlim_s)) + ((__phitr *  4.0) * __phitr)))) *  0.5);
            vav = ((__V1 - sqrt(((__V1 * __V1) +  4.0e-12))) *  0.5);
          end
          if ((__ABSOURCE_i ==  0.0)) begin
            ijunbot =  0.0;
            qjunbot =  0.0;
          end
          else begin
            if ((__one_minus_PBOT ==  0.5)) begin
              tmp = sqrt(( 1.0 - (vj * __vbiinvbot)));
            end
            else begin
              tmp = pow(( 1.0 - (vj * __vbiinvbot)), __one_minus_PBOT);
            end
            qjunbot = ((__qprefbot * ( 1.0 - tmp)) + (__qpref2bot * (__V1 - vj)));
            id = (__idsatbot * idmult);
            if (0) begin
            end
            else begin
              vbi_minus_vjsrh = (__vbibot - vjsrh);
              wsrhstep = ( 1.0 - sqrt(( 1.0 - (two_psistar / vbi_minus_vjsrh))));
              if (0) begin
              end
              else begin
                dwsrh = (((((wsrhstep * wsrhstep) * ln(wsrhstep)) / ( 1.0 - wsrhstep)) + wsrhstep) *  0.2764);
              end
              wsrh = (wsrhstep + dwsrh);
              if (0) begin
              end
              else begin
                tmp = pow((vbi_minus_vjsrh * __VBIRBOTinv),  0.3618);
              end
              wdep = (__wdepnulrbot * tmp);
              asrh = (__ftdbot * ((zinv -  1.0) * wdep));
              isrh = ((asrh * wsrh) *  100.0);
            end
            if (0) begin
            end
            else begin
              btat = (__btatpartbot * ((wdep * __one_minus_PBOT) / vbi_minus_vjsrh));
              twoatatoverthreebtat = ((__atatbot *  0.666666666666667) / btat);
              umaxbeforelimiting = (twoatatoverthreebtat * twoatatoverthreebtat);
              umax = sqrt(((umaxbeforelimiting * umaxbeforelimiting) / ((umaxbeforelimiting * umaxbeforelimiting) +  1.0)));
              sqrtumax = sqrt(umax);
              umaxpoweronepointfive = (umax * sqrtumax);
              if (((__one_over_one_minus_PBOT * -0.3618) == -1.0)) begin
                wgamma = ( 1.0 / ((btat * umaxpoweronepointfive) +  1.0));
              end
              else begin
                wgamma = pow(((btat * umaxpoweronepointfive) +  1.0), (__one_over_one_minus_PBOT * -0.3618));
              end
              wtat = ((wsrh * wgamma) / (wsrh + wgamma));
              ktat = sqrt(((btat / sqrtumax) *  0.375));
              ltat = (((twoatatoverthreebtat * sqrtumax) *  2.0) - umax);
              mtat = ((((__atatbot * twoatatoverthreebtat) * sqrtumax) - (__atatbot * umax)) + ((btat * umaxpoweronepointfive) *  0.5));
              xerfc = ((ltat -  1.0) * ktat);
              ysq = (xerfc * xerfc);
              if ((xerfc >  0.0)) begin
                terfc = ( 1.0 / ((__perfc * xerfc) +  1.0));
              end
              else begin
                terfc = ( 1.0 / ( 1.0 - (__perfc * xerfc)));
              end
              if ((((- ysq) + mtat) > -230.258509299405)) begin
                tmp = exp(((- ysq) + mtat));
              end
              else begin
                tmp = ( 100.0e-102 / (((-230.258509299405 - ((- ysq) + mtat)) * ((((-230.258509299405 - ((- ysq) + mtat)) * (((-230.258509299405 - ((- ysq) + mtat)) *  0.333333333333333) +  1.0)) *  0.5) +  1.0)) +  1.0));
              end
              erfcpos = ((((terfc *  0.29214664) + (__berfc * (terfc * terfc))) + (__cerfc * ((terfc * terfc) * terfc))) * tmp);
              if ((xerfc >  0.0)) begin
                erfctimesexpmtat = erfcpos;
              end
              else begin
                if ((mtat > -230.258509299405)) begin
                  tmp = exp(mtat);
                end
                else begin
                  tmp = ( 100.0e-102 / (((-230.258509299405 - mtat) * ((((-230.258509299405 - mtat) * (((-230.258509299405 - mtat) *  0.333333333333333) +  1.0)) *  0.5) +  1.0)) +  1.0));
                end
                erfctimesexpmtat = ((tmp *  2.0) - erfcpos);
              end
              gammamax = (((__atatbot * erfctimesexpmtat) / ktat) *  0.886226925452758);
              itat = (((asrh * gammamax) * wtat) *  100.0);
            end
            if (0) begin
            end
            else begin
              if (0) begin
              end
              else begin
                tmp = pow((( 0.7686 - vbbt) * __VBIRBOTinv),  0.3618);
              end
              Fmaxr = (__one_over_one_minus_PBOT * ((( 0.7686 - vbbt) * __wdepnulrinvbot) / tmp));
              if ((abs(((- __fbbtbot) / Fmaxr)) <  230.258509299405)) begin
                tmp = exp(((- __fbbtbot) / Fmaxr));
              end
              else begin
                if ((((- __fbbtbot) / Fmaxr) <  0.0)) begin
                  tmp = ( 100.0e-102 / (((-230.258509299405 - ((- __fbbtbot) / Fmaxr)) * ((((-230.258509299405 - ((- __fbbtbot) / Fmaxr)) * (((-230.258509299405 - ((- __fbbtbot) / Fmaxr)) *  0.333333333333333) +  1.0)) *  0.5) +  1.0)) +  1.0));
                end
                else begin
                  tmp = ((((((- __fbbtbot) / Fmaxr) -  230.258509299405) * ((((((- __fbbtbot) / Fmaxr) -  230.258509299405) * (((((- __fbbtbot) / Fmaxr) -  230.258509299405) *  0.333333333333333) +  1.0)) *  0.5) +  1.0)) +  1.0) *  10.0e+99);
                end
              end
              ibbt = ((((__V1 * Fmaxr) * Fmaxr) * tmp) *  1.0e-12);
            end
            if (0) begin
            end
            else begin
              if ((vav > ((- __alphaav) *  10.0))) begin
                if (1) begin
                  tmp = ((((vav * __VBRinvbot) * (vav * __VBRinvbot)) * (vav * __VBRinvbot)) * (vav * __VBRinvbot));
                end
                else begin
                end
                fbreakdown = ( 1.0 / ( 1.0 - tmp));
              end
              else begin
                fbreakdown = (__fstopbot + ((vav + (__alphaav *  10.0)) * __slopebot));
              end
            end
            ijunbot = ((((id + isrh) + itat) + ibbt) * fbreakdown);
          end
          if ((__LSSOURCE_i ==  0.0)) begin
            ijunsti =  0.0;
            qjunsti =  0.0;
          end
          else begin
            if ((__one_minus_PSTI ==  0.5)) begin
              tmp = sqrt(( 1.0 - (vj * __vbiinvsti)));
            end
            else begin
              tmp = pow(( 1.0 - (vj * __vbiinvsti)), __one_minus_PSTI);
            end
            qjunsti = ((__qprefsti * ( 1.0 - tmp)) + (__qpref2sti * (__V1 - vj)));
            id = (__idsatsti * idmult);
            if (0) begin
            end
            else begin
              vbi_minus_vjsrh = (__vbisti - vjsrh);
              wsrhstep = ( 1.0 - sqrt(( 1.0 - (two_psistar / vbi_minus_vjsrh))));
              if (0) begin
              end
              else begin
                dwsrh = (((((wsrhstep * wsrhstep) * ln(wsrhstep)) / ( 1.0 - wsrhstep)) + wsrhstep) *  0.4904);
              end
              wsrh = (wsrhstep + dwsrh);
              if (0) begin
              end
              else begin
                tmp = pow((vbi_minus_vjsrh * __VBIRSTIinv),  0.2548);
              end
              wdep = (__wdepnulrsti * tmp);
              asrh = (__ftdsti * ((zinv -  1.0) * wdep));
              isrh = ((asrh * wsrh) *  100.0e-6);
            end
            if (0) begin
            end
            else begin
              btat = (__btatpartsti * ((wdep * __one_minus_PSTI) / vbi_minus_vjsrh));
              twoatatoverthreebtat = ((__atatsti *  0.666666666666667) / btat);
              umaxbeforelimiting = (twoatatoverthreebtat * twoatatoverthreebtat);
              umax = sqrt(((umaxbeforelimiting * umaxbeforelimiting) / ((umaxbeforelimiting * umaxbeforelimiting) +  1.0)));
              sqrtumax = sqrt(umax);
              umaxpoweronepointfive = (umax * sqrtumax);
              if (((__one_over_one_minus_PSTI * -0.2548) == -1.0)) begin
                wgamma = ( 1.0 / ((btat * umaxpoweronepointfive) +  1.0));
              end
              else begin
                wgamma = pow(((btat * umaxpoweronepointfive) +  1.0), (__one_over_one_minus_PSTI * -0.2548));
              end
              wtat = ((wsrh * wgamma) / (wsrh + wgamma));
              ktat = sqrt(((btat / sqrtumax) *  0.375));
              ltat = (((twoatatoverthreebtat * sqrtumax) *  2.0) - umax);
              mtat = ((((__atatsti * twoatatoverthreebtat) * sqrtumax) - (__atatsti * umax)) + ((btat * umaxpoweronepointfive) *  0.5));
              xerfc = ((ltat -  1.0) * ktat);
              ysq = (xerfc * xerfc);
              if ((xerfc >  0.0)) begin
                terfc = ( 1.0 / ((__perfc * xerfc) +  1.0));
              end
              else begin
                terfc = ( 1.0 / ( 1.0 - (__perfc * xerfc)));
              end
              if ((((- ysq) + mtat) > -230.258509299405)) begin
                tmp = exp(((- ysq) + mtat));
              end
              else begin
                tmp = ( 100.0e-102 / (((-230.258509299405 - ((- ysq) + mtat)) * ((((-230.258509299405 - ((- ysq) + mtat)) * (((-230.258509299405 - ((- ysq) + mtat)) *  0.333333333333333) +  1.0)) *  0.5) +  1.0)) +  1.0));
              end
              erfcpos = ((((terfc *  0.29214664) + (__berfc * (terfc * terfc))) + (__cerfc * ((terfc * terfc) * terfc))) * tmp);
              if ((xerfc >  0.0)) begin
                erfctimesexpmtat = erfcpos;
              end
              else begin
                if ((mtat > -230.258509299405)) begin
                  tmp = exp(mtat);
                end
                else begin
                  tmp = ( 100.0e-102 / (((-230.258509299405 - mtat) * ((((-230.258509299405 - mtat) * (((-230.258509299405 - mtat) *  0.333333333333333) +  1.0)) *  0.5) +  1.0)) +  1.0));
                end
                erfctimesexpmtat = ((tmp *  2.0) - erfcpos);
              end
              gammamax = (((__atatsti * erfctimesexpmtat) / ktat) *  0.886226925452758);
              itat = (((asrh * gammamax) * wtat) *  100.0e-6);
            end
            if (0) begin
            end
            else begin
              if (0) begin
              end
              else begin
                tmp = pow((( 1.7036 - vbbt) * __VBIRSTIinv),  0.2548);
              end
              Fmaxr = (__one_over_one_minus_PSTI * ((( 1.7036 - vbbt) * __wdepnulrinvsti) / tmp));
              if ((abs(((- __fbbtsti) / Fmaxr)) <  230.258509299405)) begin
                tmp = exp(((- __fbbtsti) / Fmaxr));
              end
              else begin
                if ((((- __fbbtsti) / Fmaxr) <  0.0)) begin
                  tmp = ( 100.0e-102 / (((-230.258509299405 - ((- __fbbtsti) / Fmaxr)) * ((((-230.258509299405 - ((- __fbbtsti) / Fmaxr)) * (((-230.258509299405 - ((- __fbbtsti) / Fmaxr)) *  0.333333333333333) +  1.0)) *  0.5) +  1.0)) +  1.0));
                end
                else begin
                  tmp = ((((((- __fbbtsti) / Fmaxr) -  230.258509299405) * ((((((- __fbbtsti) / Fmaxr) -  230.258509299405) * (((((- __fbbtsti) / Fmaxr) -  230.258509299405) *  0.333333333333333) +  1.0)) *  0.5) +  1.0)) +  1.0) *  10.0e+99);
                end
              end
              ibbt = ((((__V1 * Fmaxr) * Fmaxr) * tmp) *  1.0e-21);
            end
            if (0) begin
            end
            else begin
              if ((vav > ((- __alphaav) *  10.0))) begin
                if (1) begin
                  tmp = ((((vav * __VBRinvsti) * (vav * __VBRinvsti)) * (vav * __VBRinvsti)) * (vav * __VBRinvsti));
                end
                else begin
                end
                fbreakdown = ( 1.0 / ( 1.0 - tmp));
              end
              else begin
                fbreakdown = (__fstopsti + ((vav + (__alphaav *  10.0)) * __slopesti));
              end
            end
            ijunsti = ((((id + isrh) + itat) + ibbt) * fbreakdown);
          end
          if ((__LGSOURCE_i ==  0.0)) begin
            ijungat =  0.0;
            qjungat =  0.0;
          end
          else begin
            if ((__one_minus_PGAT ==  0.5)) begin
              tmp = sqrt(( 1.0 - (vj * __vbiinvgat)));
            end
            else begin
              tmp = pow(( 1.0 - (vj * __vbiinvgat)), __one_minus_PGAT);
            end
            qjungat = ((__qprefgat * ( 1.0 - tmp)) + (__qpref2gat * (__V1 - vj)));
            id = (__idsatgat * idmult);
            if (0) begin
            end
            else begin
              vbi_minus_vjsrh = (__vbigat - vjsrh);
              wsrhstep = ( 1.0 - sqrt(( 1.0 - (two_psistar / vbi_minus_vjsrh))));
              if (0) begin
              end
              else begin
                dwsrh = (((((wsrhstep * wsrhstep) * ln(wsrhstep)) / ( 1.0 - wsrhstep)) + wsrhstep) * -0.295);
              end
              wsrh = (wsrhstep + dwsrh);
              if (0) begin
              end
              else begin
                tmp = pow((vbi_minus_vjsrh * __VBIRGATinv),  0.6475);
              end
              wdep = (__wdepnulrgat * tmp);
              asrh = (__ftdgat * ((zinv -  1.0) * wdep));
              isrh = ((asrh * wsrh) *  100.0e-6);
            end
            if (0) begin
            end
            else begin
              btat = (__btatpartgat * ((wdep * __one_minus_PGAT) / vbi_minus_vjsrh));
              twoatatoverthreebtat = ((__atatgat *  0.666666666666667) / btat);
              umaxbeforelimiting = (twoatatoverthreebtat * twoatatoverthreebtat);
              umax = sqrt(((umaxbeforelimiting * umaxbeforelimiting) / ((umaxbeforelimiting * umaxbeforelimiting) +  1.0)));
              sqrtumax = sqrt(umax);
              umaxpoweronepointfive = (umax * sqrtumax);
              if (((__one_over_one_minus_PGAT * -0.6475) == -1.0)) begin
                wgamma = ( 1.0 / ((btat * umaxpoweronepointfive) +  1.0));
              end
              else begin
                wgamma = pow(((btat * umaxpoweronepointfive) +  1.0), (__one_over_one_minus_PGAT * -0.6475));
              end
              wtat = ((wsrh * wgamma) / (wsrh + wgamma));
              ktat = sqrt(((btat / sqrtumax) *  0.375));
              ltat = (((twoatatoverthreebtat * sqrtumax) *  2.0) - umax);
              mtat = ((((__atatgat * twoatatoverthreebtat) * sqrtumax) - (__atatgat * umax)) + ((btat * umaxpoweronepointfive) *  0.5));
              xerfc = ((ltat -  1.0) * ktat);
              ysq = (xerfc * xerfc);
              if ((xerfc >  0.0)) begin
                terfc = ( 1.0 / ((__perfc * xerfc) +  1.0));
              end
              else begin
                terfc = ( 1.0 / ( 1.0 - (__perfc * xerfc)));
              end
              if ((((- ysq) + mtat) > -230.258509299405)) begin
                tmp = exp(((- ysq) + mtat));
              end
              else begin
                tmp = ( 100.0e-102 / (((-230.258509299405 - ((- ysq) + mtat)) * ((((-230.258509299405 - ((- ysq) + mtat)) * (((-230.258509299405 - ((- ysq) + mtat)) *  0.333333333333333) +  1.0)) *  0.5) +  1.0)) +  1.0));
              end
              erfcpos = ((((terfc *  0.29214664) + (__berfc * (terfc * terfc))) + (__cerfc * ((terfc * terfc) * terfc))) * tmp);
              if ((xerfc >  0.0)) begin
                erfctimesexpmtat = erfcpos;
              end
              else begin
                if ((mtat > -230.258509299405)) begin
                  tmp = exp(mtat);
                end
                else begin
                  tmp = ( 100.0e-102 / (((-230.258509299405 - mtat) * ((((-230.258509299405 - mtat) * (((-230.258509299405 - mtat) *  0.333333333333333) +  1.0)) *  0.5) +  1.0)) +  1.0));
                end
                erfctimesexpmtat = ((tmp *  2.0) - erfcpos);
              end
              gammamax = (((__atatgat * erfctimesexpmtat) / ktat) *  0.886226925452758);
              itat = (((asrh * gammamax) * wtat) *  100.0e-6);
            end
            if (0) begin
            end
            else begin
              if (0) begin
              end
              else begin
                tmp = pow((( 1.399 - vbbt) * __VBIRGATinv),  0.6475);
              end
              Fmaxr = (__one_over_one_minus_PGAT * ((( 1.399 - vbbt) * __wdepnulrinvgat) / tmp));
              if ((abs(((- __fbbtgat) / Fmaxr)) <  230.258509299405)) begin
                tmp = exp(((- __fbbtgat) / Fmaxr));
              end
              else begin
                if ((((- __fbbtgat) / Fmaxr) <  0.0)) begin
                  tmp = ( 100.0e-102 / (((-230.258509299405 - ((- __fbbtgat) / Fmaxr)) * ((((-230.258509299405 - ((- __fbbtgat) / Fmaxr)) * (((-230.258509299405 - ((- __fbbtgat) / Fmaxr)) *  0.333333333333333) +  1.0)) *  0.5) +  1.0)) +  1.0));
                end
                else begin
                  tmp = ((((((- __fbbtgat) / Fmaxr) -  230.258509299405) * ((((((- __fbbtgat) / Fmaxr) -  230.258509299405) * (((((- __fbbtgat) / Fmaxr) -  230.258509299405) *  0.333333333333333) +  1.0)) *  0.5) +  1.0)) +  1.0) *  10.0e+99);
                end
              end
              ibbt = ((((__V1 * Fmaxr) * Fmaxr) * tmp) *  1.0e-18);
            end
            if (0) begin
            end
            else begin
              if ((vav > ((- __alphaav) *  10.0))) begin
                if (1) begin
                  tmp = ((((vav * __VBRinvgat) * (vav * __VBRinvgat)) * (vav * __VBRinvgat)) * (vav * __VBRinvgat));
                end
                else begin
                end
                fbreakdown = ( 1.0 / ( 1.0 - tmp));
              end
              else begin
                fbreakdown = (__fstopgat + ((vav + (__alphaav *  10.0)) * __slopegat));
              end
            end
            ijungat = ((((id + isrh) + itat) + ibbt) * fbreakdown);
          end
          __I1 = (((__ABSOURCE_i * ijunbot) + (__LSSOURCE_i * ijunsti)) + (__LGSOURCE_i * ijungat));
          vbbt =  0.0;
          two_psistar =  0.0;
          if ((! (((__ABSOURCE_i ==  0.0) && (__LSSOURCE_i ==  0.0)) && (__LGSOURCE_i ==  0.0)))) begin
            h1 = ((__vch_s *  4.0) * __vch_s);
            h2 = (__vch_s / __vfmin_s);
            h2d = (__V2 + (__vch_s * h2));
            h3 = (__vfmin_s + h2d);
            h4 = (__vfmin_s - h2d);
            h5 = sqrt(((h4 * h4) + h1));
            vj = (((__V2 * __vfmin_s) / (h3 + h5)) *  2.0);
            if ((__V2 < __VMAX_s)) begin
              if ((abs(((__V2 * __phitdinv) *  0.5)) <  230.258509299405)) begin
                zinv = exp(((__V2 * __phitdinv) *  0.5));
              end
              else begin
                if ((((__V2 * __phitdinv) *  0.5) <  0.0)) begin
                  zinv = ( 100.0e-102 / (((-230.258509299405 - ((__V2 * __phitdinv) *  0.5)) * ((((-230.258509299405 - ((__V2 * __phitdinv) *  0.5)) * (((-230.258509299405 - ((__V2 * __phitdinv) *  0.5)) *  0.333333333333333) +  1.0)) *  0.5) +  1.0)) +  1.0));
                end
                else begin
                  zinv = ((((((__V2 * __phitdinv) *  0.5) -  230.258509299405) * ((((((__V2 * __phitdinv) *  0.5) -  230.258509299405) * (((((__V2 * __phitdinv) *  0.5) -  230.258509299405) *  0.333333333333333) +  1.0)) *  0.5) +  1.0)) +  1.0) *  10.0e+99);
                end
              end
              idmult = (zinv * zinv);
            end
            else begin
              idmult = ((((__V2 - __VMAX_s) * __phitdinv) +  1.0) * __exp_VMAX_over_phitd_s);
              zinv = sqrt(idmult);
            end
            idmult = (idmult -  1.0);
            z = ( 1.0 / zinv);
            if ((__V2 >  0.0)) begin
              two_psistar = ((__phitd * ln(((z +  2.0) + sqrt(((z +  1.0) * (z +  3.0)))))) *  2.0);
            end
            else begin
              two_psistar = ((- __V2) + ((__phitd * ln((((zinv *  2.0) +  1.0) + sqrt(((zinv +  1.0) * ((zinv *  3.0) +  1.0)))))) *  2.0));
            end
            vjlim = (__vbimin_s - two_psistar);
            vjsrh = (((__V2 + vjlim) - sqrt((((__V2 - vjlim) * (__V2 - vjlim)) + ((__phitd *  4.0) * __phitd)))) *  0.5);
            vbbt = (((__V2 + __vbbtlim_s) - sqrt((((__V2 - __vbbtlim_s) * (__V2 - __vbbtlim_s)) + ((__phitr *  4.0) * __phitr)))) *  0.5);
            vav = ((__V2 - sqrt(((__V2 * __V2) +  4.0e-12))) *  0.5);
          end
          if ((__ABSOURCE_i ==  0.0)) begin
            ijunbot =  0.0;
            qjunbot =  0.0;
          end
          else begin
            if ((__one_minus_PBOT ==  0.5)) begin
              tmp = sqrt(( 1.0 - (vj * __vbiinvbot)));
            end
            else begin
              tmp = pow(( 1.0 - (vj * __vbiinvbot)), __one_minus_PBOT);
            end
            qjunbot = ((__qprefbot * ( 1.0 - tmp)) + (__qpref2bot * (__V2 - vj)));
            id = (__idsatbot * idmult);
            if (0) begin
            end
            else begin
              vbi_minus_vjsrh = (__vbibot - vjsrh);
              wsrhstep = ( 1.0 - sqrt(( 1.0 - (two_psistar / vbi_minus_vjsrh))));
              if (0) begin
              end
              else begin
                dwsrh = (((((wsrhstep * wsrhstep) * ln(wsrhstep)) / ( 1.0 - wsrhstep)) + wsrhstep) *  0.2764);
              end
              wsrh = (wsrhstep + dwsrh);
              if (0) begin
              end
              else begin
                tmp = pow((vbi_minus_vjsrh * __VBIRBOTinv),  0.3618);
              end
              wdep = (__wdepnulrbot * tmp);
              asrh = (__ftdbot * ((zinv -  1.0) * wdep));
              isrh = ((asrh * wsrh) *  100.0);
            end
            if (0) begin
            end
            else begin
              btat = (__btatpartbot * ((wdep * __one_minus_PBOT) / vbi_minus_vjsrh));
              twoatatoverthreebtat = ((__atatbot *  0.666666666666667) / btat);
              umaxbeforelimiting = (twoatatoverthreebtat * twoatatoverthreebtat);
              umax = sqrt(((umaxbeforelimiting * umaxbeforelimiting) / ((umaxbeforelimiting * umaxbeforelimiting) +  1.0)));
              sqrtumax = sqrt(umax);
              umaxpoweronepointfive = (umax * sqrtumax);
              if (((__one_over_one_minus_PBOT * -0.3618) == -1.0)) begin
                wgamma = ( 1.0 / ((btat * umaxpoweronepointfive) +  1.0));
              end
              else begin
                wgamma = pow(((btat * umaxpoweronepointfive) +  1.0), (__one_over_one_minus_PBOT * -0.3618));
              end
              wtat = ((wsrh * wgamma) / (wsrh + wgamma));
              ktat = sqrt(((btat / sqrtumax) *  0.375));
              ltat = (((twoatatoverthreebtat * sqrtumax) *  2.0) - umax);
              mtat = ((((__atatbot * twoatatoverthreebtat) * sqrtumax) - (__atatbot * umax)) + ((btat * umaxpoweronepointfive) *  0.5));
              xerfc = ((ltat -  1.0) * ktat);
              ysq = (xerfc * xerfc);
              if ((xerfc >  0.0)) begin
                terfc = ( 1.0 / ((__perfc * xerfc) +  1.0));
              end
              else begin
                terfc = ( 1.0 / ( 1.0 - (__perfc * xerfc)));
              end
              if ((((- ysq) + mtat) > -230.258509299405)) begin
                tmp = exp(((- ysq) + mtat));
              end
              else begin
                tmp = ( 100.0e-102 / (((-230.258509299405 - ((- ysq) + mtat)) * ((((-230.258509299405 - ((- ysq) + mtat)) * (((-230.258509299405 - ((- ysq) + mtat)) *  0.333333333333333) +  1.0)) *  0.5) +  1.0)) +  1.0));
              end
              erfcpos = ((((terfc *  0.29214664) + (__berfc * (terfc * terfc))) + (__cerfc * ((terfc * terfc) * terfc))) * tmp);
              if ((xerfc >  0.0)) begin
                erfctimesexpmtat = erfcpos;
              end
              else begin
                if ((mtat > -230.258509299405)) begin
                  tmp = exp(mtat);
                end
                else begin
                  tmp = ( 100.0e-102 / (((-230.258509299405 - mtat) * ((((-230.258509299405 - mtat) * (((-230.258509299405 - mtat) *  0.333333333333333) +  1.0)) *  0.5) +  1.0)) +  1.0));
                end
                erfctimesexpmtat = ((tmp *  2.0) - erfcpos);
              end
              gammamax = (((__atatbot * erfctimesexpmtat) / ktat) *  0.886226925452758);
              itat = (((asrh * gammamax) * wtat) *  100.0);
            end
            if (0) begin
            end
            else begin
              if (0) begin
              end
              else begin
                tmp = pow((( 0.7686 - vbbt) * __VBIRBOTinv),  0.3618);
              end
              Fmaxr = (__one_over_one_minus_PBOT * ((( 0.7686 - vbbt) * __wdepnulrinvbot) / tmp));
              if ((abs(((- __fbbtbot) / Fmaxr)) <  230.258509299405)) begin
                tmp = exp(((- __fbbtbot) / Fmaxr));
              end
              else begin
                if ((((- __fbbtbot) / Fmaxr) <  0.0)) begin
                  tmp = ( 100.0e-102 / (((-230.258509299405 - ((- __fbbtbot) / Fmaxr)) * ((((-230.258509299405 - ((- __fbbtbot) / Fmaxr)) * (((-230.258509299405 - ((- __fbbtbot) / Fmaxr)) *  0.333333333333333) +  1.0)) *  0.5) +  1.0)) +  1.0));
                end
                else begin
                  tmp = ((((((- __fbbtbot) / Fmaxr) -  230.258509299405) * ((((((- __fbbtbot) / Fmaxr) -  230.258509299405) * (((((- __fbbtbot) / Fmaxr) -  230.258509299405) *  0.333333333333333) +  1.0)) *  0.5) +  1.0)) +  1.0) *  10.0e+99);
                end
              end
              ibbt = ((((__V2 * Fmaxr) * Fmaxr) * tmp) *  1.0e-12);
            end
            if (0) begin
            end
            else begin
              if ((vav > ((- __alphaav) *  10.0))) begin
                if (1) begin
                  tmp = ((((vav * __VBRinvbot) * (vav * __VBRinvbot)) * (vav * __VBRinvbot)) * (vav * __VBRinvbot));
                end
                else begin
                end
                fbreakdown = ( 1.0 / ( 1.0 - tmp));
              end
              else begin
                fbreakdown = (__fstopbot + ((vav + (__alphaav *  10.0)) * __slopebot));
              end
            end
            ijunbot = ((((id + isrh) + itat) + ibbt) * fbreakdown);
          end
          if ((__LSSOURCE_i ==  0.0)) begin
            ijunsti =  0.0;
            qjunsti =  0.0;
          end
          else begin
            if ((__one_minus_PSTI ==  0.5)) begin
              tmp = sqrt(( 1.0 - (vj * __vbiinvsti)));
            end
            else begin
              tmp = pow(( 1.0 - (vj * __vbiinvsti)), __one_minus_PSTI);
            end
            qjunsti = ((__qprefsti * ( 1.0 - tmp)) + (__qpref2sti * (__V2 - vj)));
            id = (__idsatsti * idmult);
            if (0) begin
            end
            else begin
              vbi_minus_vjsrh = (__vbisti - vjsrh);
              wsrhstep = ( 1.0 - sqrt(( 1.0 - (two_psistar / vbi_minus_vjsrh))));
              if (0) begin
              end
              else begin
                dwsrh = (((((wsrhstep * wsrhstep) * ln(wsrhstep)) / ( 1.0 - wsrhstep)) + wsrhstep) *  0.4904);
              end
              wsrh = (wsrhstep + dwsrh);
              if (0) begin
              end
              else begin
                tmp = pow((vbi_minus_vjsrh * __VBIRSTIinv),  0.2548);
              end
              wdep = (__wdepnulrsti * tmp);
              asrh = (__ftdsti * ((zinv -  1.0) * wdep));
              isrh = ((asrh * wsrh) *  100.0e-6);
            end
            if (0) begin
            end
            else begin
              btat = (__btatpartsti * ((wdep * __one_minus_PSTI) / vbi_minus_vjsrh));
              twoatatoverthreebtat = ((__atatsti *  0.666666666666667) / btat);
              umaxbeforelimiting = (twoatatoverthreebtat * twoatatoverthreebtat);
              umax = sqrt(((umaxbeforelimiting * umaxbeforelimiting) / ((umaxbeforelimiting * umaxbeforelimiting) +  1.0)));
              sqrtumax = sqrt(umax);
              umaxpoweronepointfive = (umax * sqrtumax);
              if (((__one_over_one_minus_PSTI * -0.2548) == -1.0)) begin
                wgamma = ( 1.0 / ((btat * umaxpoweronepointfive) +  1.0));
              end
              else begin
                wgamma = pow(((btat * umaxpoweronepointfive) +  1.0), (__one_over_one_minus_PSTI * -0.2548));
              end
              wtat = ((wsrh * wgamma) / (wsrh + wgamma));
              ktat = sqrt(((btat / sqrtumax) *  0.375));
              ltat = (((twoatatoverthreebtat * sqrtumax) *  2.0) - umax);
              mtat = ((((__atatsti * twoatatoverthreebtat) * sqrtumax) - (__atatsti * umax)) + ((btat * umaxpoweronepointfive) *  0.5));
              xerfc = ((ltat -  1.0) * ktat);
              ysq = (xerfc * xerfc);
              if ((xerfc >  0.0)) begin
                terfc = ( 1.0 / ((__perfc * xerfc) +  1.0));
              end
              else begin
                terfc = ( 1.0 / ( 1.0 - (__perfc * xerfc)));
              end
              if ((((- ysq) + mtat) > -230.258509299405)) begin
                tmp = exp(((- ysq) + mtat));
              end
              else begin
                tmp = ( 100.0e-102 / (((-230.258509299405 - ((- ysq) + mtat)) * ((((-230.258509299405 - ((- ysq) + mtat)) * (((-230.258509299405 - ((- ysq) + mtat)) *  0.333333333333333) +  1.0)) *  0.5) +  1.0)) +  1.0));
              end
              erfcpos = ((((terfc *  0.29214664) + (__berfc * (terfc * terfc))) + (__cerfc * ((terfc * terfc) * terfc))) * tmp);
              if ((xerfc >  0.0)) begin
                erfctimesexpmtat = erfcpos;
              end
              else begin
                if ((mtat > -230.258509299405)) begin
                  tmp = exp(mtat);
                end
                else begin
                  tmp = ( 100.0e-102 / (((-230.258509299405 - mtat) * ((((-230.258509299405 - mtat) * (((-230.258509299405 - mtat) *  0.333333333333333) +  1.0)) *  0.5) +  1.0)) +  1.0));
                end
                erfctimesexpmtat = ((tmp *  2.0) - erfcpos);
              end
              gammamax = (((__atatsti * erfctimesexpmtat) / ktat) *  0.886226925452758);
              itat = (((asrh * gammamax) * wtat) *  100.0e-6);
            end
            if (0) begin
            end
            else begin
              if (0) begin
              end
              else begin
                tmp = pow((( 1.7036 - vbbt) * __VBIRSTIinv),  0.2548);
              end
              Fmaxr = (__one_over_one_minus_PSTI * ((( 1.7036 - vbbt) * __wdepnulrinvsti) / tmp));
              if ((abs(((- __fbbtsti) / Fmaxr)) <  230.258509299405)) begin
                tmp = exp(((- __fbbtsti) / Fmaxr));
              end
              else begin
                if ((((- __fbbtsti) / Fmaxr) <  0.0)) begin
                  tmp = ( 100.0e-102 / (((-230.258509299405 - ((- __fbbtsti) / Fmaxr)) * ((((-230.258509299405 - ((- __fbbtsti) / Fmaxr)) * (((-230.258509299405 - ((- __fbbtsti) / Fmaxr)) *  0.333333333333333) +  1.0)) *  0.5) +  1.0)) +  1.0));
                end
                else begin
                  tmp = ((((((- __fbbtsti) / Fmaxr) -  230.258509299405) * ((((((- __fbbtsti) / Fmaxr) -  230.258509299405) * (((((- __fbbtsti) / Fmaxr) -  230.258509299405) *  0.333333333333333) +  1.0)) *  0.5) +  1.0)) +  1.0) *  10.0e+99);
                end
              end
              ibbt = ((((__V2 * Fmaxr) * Fmaxr) * tmp) *  1.0e-21);
            end
            if (0) begin
            end
            else begin
              if ((vav > ((- __alphaav) *  10.0))) begin
                if (1) begin
                  tmp = ((((vav * __VBRinvsti) * (vav * __VBRinvsti)) * (vav * __VBRinvsti)) * (vav * __VBRinvsti));
                end
                else begin
                end
                fbreakdown = ( 1.0 / ( 1.0 - tmp));
              end
              else begin
                fbreakdown = (__fstopsti + ((vav + (__alphaav *  10.0)) * __slopesti));
              end
            end
            ijunsti = ((((id + isrh) + itat) + ibbt) * fbreakdown);
          end
          if ((__LGSOURCE_i ==  0.0)) begin
            ijungat =  0.0;
            qjungat =  0.0;
          end
          else begin
            if ((__one_minus_PGAT ==  0.5)) begin
              tmp = sqrt(( 1.0 - (vj * __vbiinvgat)));
            end
            else begin
              tmp = pow(( 1.0 - (vj * __vbiinvgat)), __one_minus_PGAT);
            end
            qjungat = ((__qprefgat * ( 1.0 - tmp)) + (__qpref2gat * (__V2 - vj)));
            id = (__idsatgat * idmult);
            if (0) begin
            end
            else begin
              vbi_minus_vjsrh = (__vbigat - vjsrh);
              wsrhstep = ( 1.0 - sqrt(( 1.0 - (two_psistar / vbi_minus_vjsrh))));
              if (0) begin
              end
              else begin
                dwsrh = (((((wsrhstep * wsrhstep) * ln(wsrhstep)) / ( 1.0 - wsrhstep)) + wsrhstep) * -0.295);
              end
              wsrh = (wsrhstep + dwsrh);
              if (0) begin
              end
              else begin
                tmp = pow((vbi_minus_vjsrh * __VBIRGATinv),  0.6475);
              end
              wdep = (__wdepnulrgat * tmp);
              asrh = (__ftdgat * ((zinv -  1.0) * wdep));
              isrh = ((asrh * wsrh) *  100.0e-6);
            end
            if (0) begin
            end
            else begin
              btat = (__btatpartgat * ((wdep * __one_minus_PGAT) / vbi_minus_vjsrh));
              twoatatoverthreebtat = ((__atatgat *  0.666666666666667) / btat);
              umaxbeforelimiting = (twoatatoverthreebtat * twoatatoverthreebtat);
              umax = sqrt(((umaxbeforelimiting * umaxbeforelimiting) / ((umaxbeforelimiting * umaxbeforelimiting) +  1.0)));
              sqrtumax = sqrt(umax);
              umaxpoweronepointfive = (umax * sqrtumax);
              if (((__one_over_one_minus_PGAT * -0.6475) == -1.0)) begin
                wgamma = ( 1.0 / ((btat * umaxpoweronepointfive) +  1.0));
              end
              else begin
                wgamma = pow(((btat * umaxpoweronepointfive) +  1.0), (__one_over_one_minus_PGAT * -0.6475));
              end
              wtat = ((wsrh * wgamma) / (wsrh + wgamma));
              ktat = sqrt(((btat / sqrtumax) *  0.375));
              ltat = (((twoatatoverthreebtat * sqrtumax) *  2.0) - umax);
              mtat = ((((__atatgat * twoatatoverthreebtat) * sqrtumax) - (__atatgat * umax)) + ((btat * umaxpoweronepointfive) *  0.5));
              xerfc = ((ltat -  1.0) * ktat);
              ysq = (xerfc * xerfc);
              if ((xerfc >  0.0)) begin
                terfc = ( 1.0 / ((__perfc * xerfc) +  1.0));
              end
              else begin
                terfc = ( 1.0 / ( 1.0 - (__perfc * xerfc)));
              end
              if ((((- ysq) + mtat) > -230.258509299405)) begin
                tmp = exp(((- ysq) + mtat));
              end
              else begin
                tmp = ( 100.0e-102 / (((-230.258509299405 - ((- ysq) + mtat)) * ((((-230.258509299405 - ((- ysq) + mtat)) * (((-230.258509299405 - ((- ysq) + mtat)) *  0.333333333333333) +  1.0)) *  0.5) +  1.0)) +  1.0));
              end
              erfcpos = ((((terfc *  0.29214664) + (__berfc * (terfc * terfc))) + (__cerfc * ((terfc * terfc) * terfc))) * tmp);
              if ((xerfc >  0.0)) begin
                erfctimesexpmtat = erfcpos;
              end
              else begin
                if ((mtat > -230.258509299405)) begin
                  tmp = exp(mtat);
                end
                else begin
                  tmp = ( 100.0e-102 / (((-230.258509299405 - mtat) * ((((-230.258509299405 - mtat) * (((-230.258509299405 - mtat) *  0.333333333333333) +  1.0)) *  0.5) +  1.0)) +  1.0));
                end
                erfctimesexpmtat = ((tmp *  2.0) - erfcpos);
              end
              gammamax = (((__atatgat * erfctimesexpmtat) / ktat) *  0.886226925452758);
              itat = (((asrh * gammamax) * wtat) *  100.0e-6);
            end
            if (0) begin
            end
            else begin
              if (0) begin
              end
              else begin
                tmp = pow((( 1.399 - vbbt) * __VBIRGATinv),  0.6475);
              end
              Fmaxr = (__one_over_one_minus_PGAT * ((( 1.399 - vbbt) * __wdepnulrinvgat) / tmp));
              if ((abs(((- __fbbtgat) / Fmaxr)) <  230.258509299405)) begin
                tmp = exp(((- __fbbtgat) / Fmaxr));
              end
              else begin
                if ((((- __fbbtgat) / Fmaxr) <  0.0)) begin
                  tmp = ( 100.0e-102 / (((-230.258509299405 - ((- __fbbtgat) / Fmaxr)) * ((((-230.258509299405 - ((- __fbbtgat) / Fmaxr)) * (((-230.258509299405 - ((- __fbbtgat) / Fmaxr)) *  0.333333333333333) +  1.0)) *  0.5) +  1.0)) +  1.0));
                end
                else begin
                  tmp = ((((((- __fbbtgat) / Fmaxr) -  230.258509299405) * ((((((- __fbbtgat) / Fmaxr) -  230.258509299405) * (((((- __fbbtgat) / Fmaxr) -  230.258509299405) *  0.333333333333333) +  1.0)) *  0.5) +  1.0)) +  1.0) *  10.0e+99);
                end
              end
              ibbt = ((((__V2 * Fmaxr) * Fmaxr) * tmp) *  1.0e-18);
            end
            if (0) begin
            end
            else begin
              if ((vav > ((- __alphaav) *  10.0))) begin
                if (1) begin
                  tmp = ((((vav * __VBRinvgat) * (vav * __VBRinvgat)) * (vav * __VBRinvgat)) * (vav * __VBRinvgat));
                end
                else begin
                end
                fbreakdown = ( 1.0 / ( 1.0 - tmp));
              end
              else begin
                fbreakdown = (__fstopgat + ((vav + (__alphaav *  10.0)) * __slopegat));
              end
            end
            ijungat = ((((id + isrh) + itat) + ibbt) * fbreakdown);
          end
          __I2 = (((__ABSOURCE_i * ijunbot) + (__LSSOURCE_i * ijunsti)) + (__LGSOURCE_i * ijungat));
          vbbt =  0.0;
          two_psistar =  0.0;
          if ((! (((__ABSOURCE_i ==  0.0) && (__LSSOURCE_i ==  0.0)) && (__LGSOURCE_i ==  0.0)))) begin
            h1 = ((__vch_s *  4.0) * __vch_s);
            h2 = (__vch_s / __vfmin_s);
            h2d = (__V3 + (__vch_s * h2));
            h3 = (__vfmin_s + h2d);
            h4 = (__vfmin_s - h2d);
            h5 = sqrt(((h4 * h4) + h1));
            vj = (((__V3 * __vfmin_s) / (h3 + h5)) *  2.0);
            if ((__V3 < __VMAX_s)) begin
              if ((abs(((__V3 * __phitdinv) *  0.5)) <  230.258509299405)) begin
                zinv = exp(((__V3 * __phitdinv) *  0.5));
              end
              else begin
                if ((((__V3 * __phitdinv) *  0.5) <  0.0)) begin
                  zinv = ( 100.0e-102 / (((-230.258509299405 - ((__V3 * __phitdinv) *  0.5)) * ((((-230.258509299405 - ((__V3 * __phitdinv) *  0.5)) * (((-230.258509299405 - ((__V3 * __phitdinv) *  0.5)) *  0.333333333333333) +  1.0)) *  0.5) +  1.0)) +  1.0));
                end
                else begin
                  zinv = ((((((__V3 * __phitdinv) *  0.5) -  230.258509299405) * ((((((__V3 * __phitdinv) *  0.5) -  230.258509299405) * (((((__V3 * __phitdinv) *  0.5) -  230.258509299405) *  0.333333333333333) +  1.0)) *  0.5) +  1.0)) +  1.0) *  10.0e+99);
                end
              end
              idmult = (zinv * zinv);
            end
            else begin
              idmult = ((((__V3 - __VMAX_s) * __phitdinv) +  1.0) * __exp_VMAX_over_phitd_s);
              zinv = sqrt(idmult);
            end
            idmult = (idmult -  1.0);
            z = ( 1.0 / zinv);
            if ((__V3 >  0.0)) begin
              two_psistar = ((__phitd * ln(((z +  2.0) + sqrt(((z +  1.0) * (z +  3.0)))))) *  2.0);
            end
            else begin
              two_psistar = ((- __V3) + ((__phitd * ln((((zinv *  2.0) +  1.0) + sqrt(((zinv +  1.0) * ((zinv *  3.0) +  1.0)))))) *  2.0));
            end
            vjlim = (__vbimin_s - two_psistar);
            vjsrh = (((__V3 + vjlim) - sqrt((((__V3 - vjlim) * (__V3 - vjlim)) + ((__phitd *  4.0) * __phitd)))) *  0.5);
            vbbt = (((__V3 + __vbbtlim_s) - sqrt((((__V3 - __vbbtlim_s) * (__V3 - __vbbtlim_s)) + ((__phitr *  4.0) * __phitr)))) *  0.5);
            vav = ((__V3 - sqrt(((__V3 * __V3) +  4.0e-12))) *  0.5);
          end
          if ((__ABSOURCE_i ==  0.0)) begin
            ijunbot =  0.0;
            qjunbot =  0.0;
          end
          else begin
            if ((__one_minus_PBOT ==  0.5)) begin
              tmp = sqrt(( 1.0 - (vj * __vbiinvbot)));
            end
            else begin
              tmp = pow(( 1.0 - (vj * __vbiinvbot)), __one_minus_PBOT);
            end
            qjunbot = ((__qprefbot * ( 1.0 - tmp)) + (__qpref2bot * (__V3 - vj)));
            id = (__idsatbot * idmult);
            if (0) begin
            end
            else begin
              vbi_minus_vjsrh = (__vbibot - vjsrh);
              wsrhstep = ( 1.0 - sqrt(( 1.0 - (two_psistar / vbi_minus_vjsrh))));
              if (0) begin
              end
              else begin
                dwsrh = (((((wsrhstep * wsrhstep) * ln(wsrhstep)) / ( 1.0 - wsrhstep)) + wsrhstep) *  0.2764);
              end
              wsrh = (wsrhstep + dwsrh);
              if (0) begin
              end
              else begin
                tmp = pow((vbi_minus_vjsrh * __VBIRBOTinv),  0.3618);
              end
              wdep = (__wdepnulrbot * tmp);
              asrh = (__ftdbot * ((zinv -  1.0) * wdep));
              isrh = ((asrh * wsrh) *  100.0);
            end
            if (0) begin
            end
            else begin
              btat = (__btatpartbot * ((wdep * __one_minus_PBOT) / vbi_minus_vjsrh));
              twoatatoverthreebtat = ((__atatbot *  0.666666666666667) / btat);
              umaxbeforelimiting = (twoatatoverthreebtat * twoatatoverthreebtat);
              umax = sqrt(((umaxbeforelimiting * umaxbeforelimiting) / ((umaxbeforelimiting * umaxbeforelimiting) +  1.0)));
              sqrtumax = sqrt(umax);
              umaxpoweronepointfive = (umax * sqrtumax);
              if (((__one_over_one_minus_PBOT * -0.3618) == -1.0)) begin
                wgamma = ( 1.0 / ((btat * umaxpoweronepointfive) +  1.0));
              end
              else begin
                wgamma = pow(((btat * umaxpoweronepointfive) +  1.0), (__one_over_one_minus_PBOT * -0.3618));
              end
              wtat = ((wsrh * wgamma) / (wsrh + wgamma));
              ktat = sqrt(((btat / sqrtumax) *  0.375));
              ltat = (((twoatatoverthreebtat * sqrtumax) *  2.0) - umax);
              mtat = ((((__atatbot * twoatatoverthreebtat) * sqrtumax) - (__atatbot * umax)) + ((btat * umaxpoweronepointfive) *  0.5));
              xerfc = ((ltat -  1.0) * ktat);
              ysq = (xerfc * xerfc);
              if ((xerfc >  0.0)) begin
                terfc = ( 1.0 / ((__perfc * xerfc) +  1.0));
              end
              else begin
                terfc = ( 1.0 / ( 1.0 - (__perfc * xerfc)));
              end
              if ((((- ysq) + mtat) > -230.258509299405)) begin
                tmp = exp(((- ysq) + mtat));
              end
              else begin
                tmp = ( 100.0e-102 / (((-230.258509299405 - ((- ysq) + mtat)) * ((((-230.258509299405 - ((- ysq) + mtat)) * (((-230.258509299405 - ((- ysq) + mtat)) *  0.333333333333333) +  1.0)) *  0.5) +  1.0)) +  1.0));
              end
              erfcpos = ((((terfc *  0.29214664) + (__berfc * (terfc * terfc))) + (__cerfc * ((terfc * terfc) * terfc))) * tmp);
              if ((xerfc >  0.0)) begin
                erfctimesexpmtat = erfcpos;
              end
              else begin
                if ((mtat > -230.258509299405)) begin
                  tmp = exp(mtat);
                end
                else begin
                  tmp = ( 100.0e-102 / (((-230.258509299405 - mtat) * ((((-230.258509299405 - mtat) * (((-230.258509299405 - mtat) *  0.333333333333333) +  1.0)) *  0.5) +  1.0)) +  1.0));
                end
                erfctimesexpmtat = ((tmp *  2.0) - erfcpos);
              end
              gammamax = (((__atatbot * erfctimesexpmtat) / ktat) *  0.886226925452758);
              itat = (((asrh * gammamax) * wtat) *  100.0);
            end
            if (0) begin
            end
            else begin
              if (0) begin
              end
              else begin
                tmp = pow((( 0.7686 - vbbt) * __VBIRBOTinv),  0.3618);
              end
              Fmaxr = (__one_over_one_minus_PBOT * ((( 0.7686 - vbbt) * __wdepnulrinvbot) / tmp));
              if ((abs(((- __fbbtbot) / Fmaxr)) <  230.258509299405)) begin
                tmp = exp(((- __fbbtbot) / Fmaxr));
              end
              else begin
                if ((((- __fbbtbot) / Fmaxr) <  0.0)) begin
                  tmp = ( 100.0e-102 / (((-230.258509299405 - ((- __fbbtbot) / Fmaxr)) * ((((-230.258509299405 - ((- __fbbtbot) / Fmaxr)) * (((-230.258509299405 - ((- __fbbtbot) / Fmaxr)) *  0.333333333333333) +  1.0)) *  0.5) +  1.0)) +  1.0));
                end
                else begin
                  tmp = ((((((- __fbbtbot) / Fmaxr) -  230.258509299405) * ((((((- __fbbtbot) / Fmaxr) -  230.258509299405) * (((((- __fbbtbot) / Fmaxr) -  230.258509299405) *  0.333333333333333) +  1.0)) *  0.5) +  1.0)) +  1.0) *  10.0e+99);
                end
              end
              ibbt = ((((__V3 * Fmaxr) * Fmaxr) * tmp) *  1.0e-12);
            end
            if (0) begin
            end
            else begin
              if ((vav > ((- __alphaav) *  10.0))) begin
                if (1) begin
                  tmp = ((((vav * __VBRinvbot) * (vav * __VBRinvbot)) * (vav * __VBRinvbot)) * (vav * __VBRinvbot));
                end
                else begin
                end
                fbreakdown = ( 1.0 / ( 1.0 - tmp));
              end
              else begin
                fbreakdown = (__fstopbot + ((vav + (__alphaav *  10.0)) * __slopebot));
              end
            end
            ijunbot = ((((id + isrh) + itat) + ibbt) * fbreakdown);
          end
          if ((__LSSOURCE_i ==  0.0)) begin
            ijunsti =  0.0;
            qjunsti =  0.0;
          end
          else begin
            if ((__one_minus_PSTI ==  0.5)) begin
              tmp = sqrt(( 1.0 - (vj * __vbiinvsti)));
            end
            else begin
              tmp = pow(( 1.0 - (vj * __vbiinvsti)), __one_minus_PSTI);
            end
            qjunsti = ((__qprefsti * ( 1.0 - tmp)) + (__qpref2sti * (__V3 - vj)));
            id = (__idsatsti * idmult);
            if (0) begin
            end
            else begin
              vbi_minus_vjsrh = (__vbisti - vjsrh);
              wsrhstep = ( 1.0 - sqrt(( 1.0 - (two_psistar / vbi_minus_vjsrh))));
              if (0) begin
              end
              else begin
                dwsrh = (((((wsrhstep * wsrhstep) * ln(wsrhstep)) / ( 1.0 - wsrhstep)) + wsrhstep) *  0.4904);
              end
              wsrh = (wsrhstep + dwsrh);
              if (0) begin
              end
              else begin
                tmp = pow((vbi_minus_vjsrh * __VBIRSTIinv),  0.2548);
              end
              wdep = (__wdepnulrsti * tmp);
              asrh = (__ftdsti * ((zinv -  1.0) * wdep));
              isrh = ((asrh * wsrh) *  100.0e-6);
            end
            if (0) begin
            end
            else begin
              btat = (__btatpartsti * ((wdep * __one_minus_PSTI) / vbi_minus_vjsrh));
              twoatatoverthreebtat = ((__atatsti *  0.666666666666667) / btat);
              umaxbeforelimiting = (twoatatoverthreebtat * twoatatoverthreebtat);
              umax = sqrt(((umaxbeforelimiting * umaxbeforelimiting) / ((umaxbeforelimiting * umaxbeforelimiting) +  1.0)));
              sqrtumax = sqrt(umax);
              umaxpoweronepointfive = (umax * sqrtumax);
              if (((__one_over_one_minus_PSTI * -0.2548) == -1.0)) begin
                wgamma = ( 1.0 / ((btat * umaxpoweronepointfive) +  1.0));
              end
              else begin
                wgamma = pow(((btat * umaxpoweronepointfive) +  1.0), (__one_over_one_minus_PSTI * -0.2548));
              end
              wtat = ((wsrh * wgamma) / (wsrh + wgamma));
              ktat = sqrt(((btat / sqrtumax) *  0.375));
              ltat = (((twoatatoverthreebtat * sqrtumax) *  2.0) - umax);
              mtat = ((((__atatsti * twoatatoverthreebtat) * sqrtumax) - (__atatsti * umax)) + ((btat * umaxpoweronepointfive) *  0.5));
              xerfc = ((ltat -  1.0) * ktat);
              ysq = (xerfc * xerfc);
              if ((xerfc >  0.0)) begin
                terfc = ( 1.0 / ((__perfc * xerfc) +  1.0));
              end
              else begin
                terfc = ( 1.0 / ( 1.0 - (__perfc * xerfc)));
              end
              if ((((- ysq) + mtat) > -230.258509299405)) begin
                tmp = exp(((- ysq) + mtat));
              end
              else begin
                tmp = ( 100.0e-102 / (((-230.258509299405 - ((- ysq) + mtat)) * ((((-230.258509299405 - ((- ysq) + mtat)) * (((-230.258509299405 - ((- ysq) + mtat)) *  0.333333333333333) +  1.0)) *  0.5) +  1.0)) +  1.0));
              end
              erfcpos = ((((terfc *  0.29214664) + (__berfc * (terfc * terfc))) + (__cerfc * ((terfc * terfc) * terfc))) * tmp);
              if ((xerfc >  0.0)) begin
                erfctimesexpmtat = erfcpos;
              end
              else begin
                if ((mtat > -230.258509299405)) begin
                  tmp = exp(mtat);
                end
                else begin
                  tmp = ( 100.0e-102 / (((-230.258509299405 - mtat) * ((((-230.258509299405 - mtat) * (((-230.258509299405 - mtat) *  0.333333333333333) +  1.0)) *  0.5) +  1.0)) +  1.0));
                end
                erfctimesexpmtat = ((tmp *  2.0) - erfcpos);
              end
              gammamax = (((__atatsti * erfctimesexpmtat) / ktat) *  0.886226925452758);
              itat = (((asrh * gammamax) * wtat) *  100.0e-6);
            end
            if (0) begin
            end
            else begin
              if (0) begin
              end
              else begin
                tmp = pow((( 1.7036 - vbbt) * __VBIRSTIinv),  0.2548);
              end
              Fmaxr = (__one_over_one_minus_PSTI * ((( 1.7036 - vbbt) * __wdepnulrinvsti) / tmp));
              if ((abs(((- __fbbtsti) / Fmaxr)) <  230.258509299405)) begin
                tmp = exp(((- __fbbtsti) / Fmaxr));
              end
              else begin
                if ((((- __fbbtsti) / Fmaxr) <  0.0)) begin
                  tmp = ( 100.0e-102 / (((-230.258509299405 - ((- __fbbtsti) / Fmaxr)) * ((((-230.258509299405 - ((- __fbbtsti) / Fmaxr)) * (((-230.258509299405 - ((- __fbbtsti) / Fmaxr)) *  0.333333333333333) +  1.0)) *  0.5) +  1.0)) +  1.0));
                end
                else begin
                  tmp = ((((((- __fbbtsti) / Fmaxr) -  230.258509299405) * ((((((- __fbbtsti) / Fmaxr) -  230.258509299405) * (((((- __fbbtsti) / Fmaxr) -  230.258509299405) *  0.333333333333333) +  1.0)) *  0.5) +  1.0)) +  1.0) *  10.0e+99);
                end
              end
              ibbt = ((((__V3 * Fmaxr) * Fmaxr) * tmp) *  1.0e-21);
            end
            if (0) begin
            end
            else begin
              if ((vav > ((- __alphaav) *  10.0))) begin
                if (1) begin
                  tmp = ((((vav * __VBRinvsti) * (vav * __VBRinvsti)) * (vav * __VBRinvsti)) * (vav * __VBRinvsti));
                end
                else begin
                end
                fbreakdown = ( 1.0 / ( 1.0 - tmp));
              end
              else begin
                fbreakdown = (__fstopsti + ((vav + (__alphaav *  10.0)) * __slopesti));
              end
            end
            ijunsti = ((((id + isrh) + itat) + ibbt) * fbreakdown);
          end
          if ((__LGSOURCE_i ==  0.0)) begin
            ijungat =  0.0;
            qjungat =  0.0;
          end
          else begin
            if ((__one_minus_PGAT ==  0.5)) begin
              tmp = sqrt(( 1.0 - (vj * __vbiinvgat)));
            end
            else begin
              tmp = pow(( 1.0 - (vj * __vbiinvgat)), __one_minus_PGAT);
            end
            qjungat = ((__qprefgat * ( 1.0 - tmp)) + (__qpref2gat * (__V3 - vj)));
            id = (__idsatgat * idmult);
            if (0) begin
            end
            else begin
              vbi_minus_vjsrh = (__vbigat - vjsrh);
              wsrhstep = ( 1.0 - sqrt(( 1.0 - (two_psistar / vbi_minus_vjsrh))));
              if (0) begin
              end
              else begin
                dwsrh = (((((wsrhstep * wsrhstep) * ln(wsrhstep)) / ( 1.0 - wsrhstep)) + wsrhstep) * -0.295);
              end
              wsrh = (wsrhstep + dwsrh);
              if (0) begin
              end
              else begin
                tmp = pow((vbi_minus_vjsrh * __VBIRGATinv),  0.6475);
              end
              wdep = (__wdepnulrgat * tmp);
              asrh = (__ftdgat * ((zinv -  1.0) * wdep));
              isrh = ((asrh * wsrh) *  100.0e-6);
            end
            if (0) begin
            end
            else begin
              btat = (__btatpartgat * ((wdep * __one_minus_PGAT) / vbi_minus_vjsrh));
              twoatatoverthreebtat = ((__atatgat *  0.666666666666667) / btat);
              umaxbeforelimiting = (twoatatoverthreebtat * twoatatoverthreebtat);
              umax = sqrt(((umaxbeforelimiting * umaxbeforelimiting) / ((umaxbeforelimiting * umaxbeforelimiting) +  1.0)));
              sqrtumax = sqrt(umax);
              umaxpoweronepointfive = (umax * sqrtumax);
              if (((__one_over_one_minus_PGAT * -0.6475) == -1.0)) begin
                wgamma = ( 1.0 / ((btat * umaxpoweronepointfive) +  1.0));
              end
              else begin
                wgamma = pow(((btat * umaxpoweronepointfive) +  1.0), (__one_over_one_minus_PGAT * -0.6475));
              end
              wtat = ((wsrh * wgamma) / (wsrh + wgamma));
              ktat = sqrt(((btat / sqrtumax) *  0.375));
              ltat = (((twoatatoverthreebtat * sqrtumax) *  2.0) - umax);
              mtat = ((((__atatgat * twoatatoverthreebtat) * sqrtumax) - (__atatgat * umax)) + ((btat * umaxpoweronepointfive) *  0.5));
              xerfc = ((ltat -  1.0) * ktat);
              ysq = (xerfc * xerfc);
              if ((xerfc >  0.0)) begin
                terfc = ( 1.0 / ((__perfc * xerfc) +  1.0));
              end
              else begin
                terfc = ( 1.0 / ( 1.0 - (__perfc * xerfc)));
              end
              if ((((- ysq) + mtat) > -230.258509299405)) begin
                tmp = exp(((- ysq) + mtat));
              end
              else begin
                tmp = ( 100.0e-102 / (((-230.258509299405 - ((- ysq) + mtat)) * ((((-230.258509299405 - ((- ysq) + mtat)) * (((-230.258509299405 - ((- ysq) + mtat)) *  0.333333333333333) +  1.0)) *  0.5) +  1.0)) +  1.0));
              end
              erfcpos = ((((terfc *  0.29214664) + (__berfc * (terfc * terfc))) + (__cerfc * ((terfc * terfc) * terfc))) * tmp);
              if ((xerfc >  0.0)) begin
                erfctimesexpmtat = erfcpos;
              end
              else begin
                if ((mtat > -230.258509299405)) begin
                  tmp = exp(mtat);
                end
                else begin
                  tmp = ( 100.0e-102 / (((-230.258509299405 - mtat) * ((((-230.258509299405 - mtat) * (((-230.258509299405 - mtat) *  0.333333333333333) +  1.0)) *  0.5) +  1.0)) +  1.0));
                end
                erfctimesexpmtat = ((tmp *  2.0) - erfcpos);
              end
              gammamax = (((__atatgat * erfctimesexpmtat) / ktat) *  0.886226925452758);
              itat = (((asrh * gammamax) * wtat) *  100.0e-6);
            end
            if (0) begin
            end
            else begin
              if (0) begin
              end
              else begin
                tmp = pow((( 1.399 - vbbt) * __VBIRGATinv),  0.6475);
              end
              Fmaxr = (__one_over_one_minus_PGAT * ((( 1.399 - vbbt) * __wdepnulrinvgat) / tmp));
              if ((abs(((- __fbbtgat) / Fmaxr)) <  230.258509299405)) begin
                tmp = exp(((- __fbbtgat) / Fmaxr));
              end
              else begin
                if ((((- __fbbtgat) / Fmaxr) <  0.0)) begin
                  tmp = ( 100.0e-102 / (((-230.258509299405 - ((- __fbbtgat) / Fmaxr)) * ((((-230.258509299405 - ((- __fbbtgat) / Fmaxr)) * (((-230.258509299405 - ((- __fbbtgat) / Fmaxr)) *  0.333333333333333) +  1.0)) *  0.5) +  1.0)) +  1.0));
                end
                else begin
                  tmp = ((((((- __fbbtgat) / Fmaxr) -  230.258509299405) * ((((((- __fbbtgat) / Fmaxr) -  230.258509299405) * (((((- __fbbtgat) / Fmaxr) -  230.258509299405) *  0.333333333333333) +  1.0)) *  0.5) +  1.0)) +  1.0) *  10.0e+99);
                end
              end
              ibbt = ((((__V3 * Fmaxr) * Fmaxr) * tmp) *  1.0e-18);
            end
            if (0) begin
            end
            else begin
              if ((vav > ((- __alphaav) *  10.0))) begin
                if (1) begin
                  tmp = ((((vav * __VBRinvgat) * (vav * __VBRinvgat)) * (vav * __VBRinvgat)) * (vav * __VBRinvgat));
                end
                else begin
                end
                fbreakdown = ( 1.0 / ( 1.0 - tmp));
              end
              else begin
                fbreakdown = (__fstopgat + ((vav + (__alphaav *  10.0)) * __slopegat));
              end
            end
            ijungat = ((((id + isrh) + itat) + ibbt) * fbreakdown);
          end
          __I3 = (((__ABSOURCE_i * ijunbot) + (__LSSOURCE_i * ijunsti)) + (__LGSOURCE_i * ijungat));
          vbbt =  0.0;
          two_psistar =  0.0;
          if ((! (((__ABSOURCE_i ==  0.0) && (__LSSOURCE_i ==  0.0)) && (__LGSOURCE_i ==  0.0)))) begin
            h1 = ((__vch_s *  4.0) * __vch_s);
            h2 = (__vch_s / __vfmin_s);
            h2d = (__V4 + (__vch_s * h2));
            h3 = (__vfmin_s + h2d);
            h4 = (__vfmin_s - h2d);
            h5 = sqrt(((h4 * h4) + h1));
            vj = (((__V4 * __vfmin_s) / (h3 + h5)) *  2.0);
            if ((__V4 < __VMAX_s)) begin
              if ((abs(((__V4 * __phitdinv) *  0.5)) <  230.258509299405)) begin
                zinv = exp(((__V4 * __phitdinv) *  0.5));
              end
              else begin
                if ((((__V4 * __phitdinv) *  0.5) <  0.0)) begin
                  zinv = ( 100.0e-102 / (((-230.258509299405 - ((__V4 * __phitdinv) *  0.5)) * ((((-230.258509299405 - ((__V4 * __phitdinv) *  0.5)) * (((-230.258509299405 - ((__V4 * __phitdinv) *  0.5)) *  0.333333333333333) +  1.0)) *  0.5) +  1.0)) +  1.0));
                end
                else begin
                  zinv = ((((((__V4 * __phitdinv) *  0.5) -  230.258509299405) * ((((((__V4 * __phitdinv) *  0.5) -  230.258509299405) * (((((__V4 * __phitdinv) *  0.5) -  230.258509299405) *  0.333333333333333) +  1.0)) *  0.5) +  1.0)) +  1.0) *  10.0e+99);
                end
              end
              idmult = (zinv * zinv);
            end
            else begin
              idmult = ((((__V4 - __VMAX_s) * __phitdinv) +  1.0) * __exp_VMAX_over_phitd_s);
              zinv = sqrt(idmult);
            end
            idmult = (idmult -  1.0);
            z = ( 1.0 / zinv);
            if ((__V4 >  0.0)) begin
              two_psistar = ((__phitd * ln(((z +  2.0) + sqrt(((z +  1.0) * (z +  3.0)))))) *  2.0);
            end
            else begin
              two_psistar = ((- __V4) + ((__phitd * ln((((zinv *  2.0) +  1.0) + sqrt(((zinv +  1.0) * ((zinv *  3.0) +  1.0)))))) *  2.0));
            end
            vjlim = (__vbimin_s - two_psistar);
            vjsrh = (((__V4 + vjlim) - sqrt((((__V4 - vjlim) * (__V4 - vjlim)) + ((__phitd *  4.0) * __phitd)))) *  0.5);
            vbbt = (((__V4 + __vbbtlim_s) - sqrt((((__V4 - __vbbtlim_s) * (__V4 - __vbbtlim_s)) + ((__phitr *  4.0) * __phitr)))) *  0.5);
            vav = ((__V4 - sqrt(((__V4 * __V4) +  4.0e-12))) *  0.5);
          end
          if ((__ABSOURCE_i ==  0.0)) begin
            ijunbot =  0.0;
            qjunbot =  0.0;
          end
          else begin
            if ((__one_minus_PBOT ==  0.5)) begin
              tmp = sqrt(( 1.0 - (vj * __vbiinvbot)));
            end
            else begin
              tmp = pow(( 1.0 - (vj * __vbiinvbot)), __one_minus_PBOT);
            end
            qjunbot = ((__qprefbot * ( 1.0 - tmp)) + (__qpref2bot * (__V4 - vj)));
            id = (__idsatbot * idmult);
            if (0) begin
            end
            else begin
              vbi_minus_vjsrh = (__vbibot - vjsrh);
              wsrhstep = ( 1.0 - sqrt(( 1.0 - (two_psistar / vbi_minus_vjsrh))));
              if (0) begin
              end
              else begin
                dwsrh = (((((wsrhstep * wsrhstep) * ln(wsrhstep)) / ( 1.0 - wsrhstep)) + wsrhstep) *  0.2764);
              end
              wsrh = (wsrhstep + dwsrh);
              if (0) begin
              end
              else begin
                tmp = pow((vbi_minus_vjsrh * __VBIRBOTinv),  0.3618);
              end
              wdep = (__wdepnulrbot * tmp);
              asrh = (__ftdbot * ((zinv -  1.0) * wdep));
              isrh = ((asrh * wsrh) *  100.0);
            end
            if (0) begin
            end
            else begin
              btat = (__btatpartbot * ((wdep * __one_minus_PBOT) / vbi_minus_vjsrh));
              twoatatoverthreebtat = ((__atatbot *  0.666666666666667) / btat);
              umaxbeforelimiting = (twoatatoverthreebtat * twoatatoverthreebtat);
              umax = sqrt(((umaxbeforelimiting * umaxbeforelimiting) / ((umaxbeforelimiting * umaxbeforelimiting) +  1.0)));
              sqrtumax = sqrt(umax);
              umaxpoweronepointfive = (umax * sqrtumax);
              if (((__one_over_one_minus_PBOT * -0.3618) == -1.0)) begin
                wgamma = ( 1.0 / ((btat * umaxpoweronepointfive) +  1.0));
              end
              else begin
                wgamma = pow(((btat * umaxpoweronepointfive) +  1.0), (__one_over_one_minus_PBOT * -0.3618));
              end
              wtat = ((wsrh * wgamma) / (wsrh + wgamma));
              ktat = sqrt(((btat / sqrtumax) *  0.375));
              ltat = (((twoatatoverthreebtat * sqrtumax) *  2.0) - umax);
              mtat = ((((__atatbot * twoatatoverthreebtat) * sqrtumax) - (__atatbot * umax)) + ((btat * umaxpoweronepointfive) *  0.5));
              xerfc = ((ltat -  1.0) * ktat);
              ysq = (xerfc * xerfc);
              if ((xerfc >  0.0)) begin
                terfc = ( 1.0 / ((__perfc * xerfc) +  1.0));
              end
              else begin
                terfc = ( 1.0 / ( 1.0 - (__perfc * xerfc)));
              end
              if ((((- ysq) + mtat) > -230.258509299405)) begin
                tmp = exp(((- ysq) + mtat));
              end
              else begin
                tmp = ( 100.0e-102 / (((-230.258509299405 - ((- ysq) + mtat)) * ((((-230.258509299405 - ((- ysq) + mtat)) * (((-230.258509299405 - ((- ysq) + mtat)) *  0.333333333333333) +  1.0)) *  0.5) +  1.0)) +  1.0));
              end
              erfcpos = ((((terfc *  0.29214664) + (__berfc * (terfc * terfc))) + (__cerfc * ((terfc * terfc) * terfc))) * tmp);
              if ((xerfc >  0.0)) begin
                erfctimesexpmtat = erfcpos;
              end
              else begin
                if ((mtat > -230.258509299405)) begin
                  tmp = exp(mtat);
                end
                else begin
                  tmp = ( 100.0e-102 / (((-230.258509299405 - mtat) * ((((-230.258509299405 - mtat) * (((-230.258509299405 - mtat) *  0.333333333333333) +  1.0)) *  0.5) +  1.0)) +  1.0));
                end
                erfctimesexpmtat = ((tmp *  2.0) - erfcpos);
              end
              gammamax = (((__atatbot * erfctimesexpmtat) / ktat) *  0.886226925452758);
              itat = (((asrh * gammamax) * wtat) *  100.0);
            end
            if (0) begin
            end
            else begin
              if (0) begin
              end
              else begin
                tmp = pow((( 0.7686 - vbbt) * __VBIRBOTinv),  0.3618);
              end
              Fmaxr = (__one_over_one_minus_PBOT * ((( 0.7686 - vbbt) * __wdepnulrinvbot) / tmp));
              if ((abs(((- __fbbtbot) / Fmaxr)) <  230.258509299405)) begin
                tmp = exp(((- __fbbtbot) / Fmaxr));
              end
              else begin
                if ((((- __fbbtbot) / Fmaxr) <  0.0)) begin
                  tmp = ( 100.0e-102 / (((-230.258509299405 - ((- __fbbtbot) / Fmaxr)) * ((((-230.258509299405 - ((- __fbbtbot) / Fmaxr)) * (((-230.258509299405 - ((- __fbbtbot) / Fmaxr)) *  0.333333333333333) +  1.0)) *  0.5) +  1.0)) +  1.0));
                end
                else begin
                  tmp = ((((((- __fbbtbot) / Fmaxr) -  230.258509299405) * ((((((- __fbbtbot) / Fmaxr) -  230.258509299405) * (((((- __fbbtbot) / Fmaxr) -  230.258509299405) *  0.333333333333333) +  1.0)) *  0.5) +  1.0)) +  1.0) *  10.0e+99);
                end
              end
              ibbt = ((((__V4 * Fmaxr) * Fmaxr) * tmp) *  1.0e-12);
            end
            if (0) begin
            end
            else begin
              if ((vav > ((- __alphaav) *  10.0))) begin
                if (1) begin
                  tmp = ((((vav * __VBRinvbot) * (vav * __VBRinvbot)) * (vav * __VBRinvbot)) * (vav * __VBRinvbot));
                end
                else begin
                end
                fbreakdown = ( 1.0 / ( 1.0 - tmp));
              end
              else begin
                fbreakdown = (__fstopbot + ((vav + (__alphaav *  10.0)) * __slopebot));
              end
            end
            ijunbot = ((((id + isrh) + itat) + ibbt) * fbreakdown);
          end
          if ((__LSSOURCE_i ==  0.0)) begin
            ijunsti =  0.0;
            qjunsti =  0.0;
          end
          else begin
            if ((__one_minus_PSTI ==  0.5)) begin
              tmp = sqrt(( 1.0 - (vj * __vbiinvsti)));
            end
            else begin
              tmp = pow(( 1.0 - (vj * __vbiinvsti)), __one_minus_PSTI);
            end
            qjunsti = ((__qprefsti * ( 1.0 - tmp)) + (__qpref2sti * (__V4 - vj)));
            id = (__idsatsti * idmult);
            if (0) begin
            end
            else begin
              vbi_minus_vjsrh = (__vbisti - vjsrh);
              wsrhstep = ( 1.0 - sqrt(( 1.0 - (two_psistar / vbi_minus_vjsrh))));
              if (0) begin
              end
              else begin
                dwsrh = (((((wsrhstep * wsrhstep) * ln(wsrhstep)) / ( 1.0 - wsrhstep)) + wsrhstep) *  0.4904);
              end
              wsrh = (wsrhstep + dwsrh);
              if (0) begin
              end
              else begin
                tmp = pow((vbi_minus_vjsrh * __VBIRSTIinv),  0.2548);
              end
              wdep = (__wdepnulrsti * tmp);
              asrh = (__ftdsti * ((zinv -  1.0) * wdep));
              isrh = ((asrh * wsrh) *  100.0e-6);
            end
            if (0) begin
            end
            else begin
              btat = (__btatpartsti * ((wdep * __one_minus_PSTI) / vbi_minus_vjsrh));
              twoatatoverthreebtat = ((__atatsti *  0.666666666666667) / btat);
              umaxbeforelimiting = (twoatatoverthreebtat * twoatatoverthreebtat);
              umax = sqrt(((umaxbeforelimiting * umaxbeforelimiting) / ((umaxbeforelimiting * umaxbeforelimiting) +  1.0)));
              sqrtumax = sqrt(umax);
              umaxpoweronepointfive = (umax * sqrtumax);
              if (((__one_over_one_minus_PSTI * -0.2548) == -1.0)) begin
                wgamma = ( 1.0 / ((btat * umaxpoweronepointfive) +  1.0));
              end
              else begin
                wgamma = pow(((btat * umaxpoweronepointfive) +  1.0), (__one_over_one_minus_PSTI * -0.2548));
              end
              wtat = ((wsrh * wgamma) / (wsrh + wgamma));
              ktat = sqrt(((btat / sqrtumax) *  0.375));
              ltat = (((twoatatoverthreebtat * sqrtumax) *  2.0) - umax);
              mtat = ((((__atatsti * twoatatoverthreebtat) * sqrtumax) - (__atatsti * umax)) + ((btat * umaxpoweronepointfive) *  0.5));
              xerfc = ((ltat -  1.0) * ktat);
              ysq = (xerfc * xerfc);
              if ((xerfc >  0.0)) begin
                terfc = ( 1.0 / ((__perfc * xerfc) +  1.0));
              end
              else begin
                terfc = ( 1.0 / ( 1.0 - (__perfc * xerfc)));
              end
              if ((((- ysq) + mtat) > -230.258509299405)) begin
                tmp = exp(((- ysq) + mtat));
              end
              else begin
                tmp = ( 100.0e-102 / (((-230.258509299405 - ((- ysq) + mtat)) * ((((-230.258509299405 - ((- ysq) + mtat)) * (((-230.258509299405 - ((- ysq) + mtat)) *  0.333333333333333) +  1.0)) *  0.5) +  1.0)) +  1.0));
              end
              erfcpos = ((((terfc *  0.29214664) + (__berfc * (terfc * terfc))) + (__cerfc * ((terfc * terfc) * terfc))) * tmp);
              if ((xerfc >  0.0)) begin
                erfctimesexpmtat = erfcpos;
              end
              else begin
                if ((mtat > -230.258509299405)) begin
                  tmp = exp(mtat);
                end
                else begin
                  tmp = ( 100.0e-102 / (((-230.258509299405 - mtat) * ((((-230.258509299405 - mtat) * (((-230.258509299405 - mtat) *  0.333333333333333) +  1.0)) *  0.5) +  1.0)) +  1.0));
                end
                erfctimesexpmtat = ((tmp *  2.0) - erfcpos);
              end
              gammamax = (((__atatsti * erfctimesexpmtat) / ktat) *  0.886226925452758);
              itat = (((asrh * gammamax) * wtat) *  100.0e-6);
            end
            if (0) begin
            end
            else begin
              if (0) begin
              end
              else begin
                tmp = pow((( 1.7036 - vbbt) * __VBIRSTIinv),  0.2548);
              end
              Fmaxr = (__one_over_one_minus_PSTI * ((( 1.7036 - vbbt) * __wdepnulrinvsti) / tmp));
              if ((abs(((- __fbbtsti) / Fmaxr)) <  230.258509299405)) begin
                tmp = exp(((- __fbbtsti) / Fmaxr));
              end
              else begin
                if ((((- __fbbtsti) / Fmaxr) <  0.0)) begin
                  tmp = ( 100.0e-102 / (((-230.258509299405 - ((- __fbbtsti) / Fmaxr)) * ((((-230.258509299405 - ((- __fbbtsti) / Fmaxr)) * (((-230.258509299405 - ((- __fbbtsti) / Fmaxr)) *  0.333333333333333) +  1.0)) *  0.5) +  1.0)) +  1.0));
                end
                else begin
                  tmp = ((((((- __fbbtsti) / Fmaxr) -  230.258509299405) * ((((((- __fbbtsti) / Fmaxr) -  230.258509299405) * (((((- __fbbtsti) / Fmaxr) -  230.258509299405) *  0.333333333333333) +  1.0)) *  0.5) +  1.0)) +  1.0) *  10.0e+99);
                end
              end
              ibbt = ((((__V4 * Fmaxr) * Fmaxr) * tmp) *  1.0e-21);
            end
            if (0) begin
            end
            else begin
              if ((vav > ((- __alphaav) *  10.0))) begin
                if (1) begin
                  tmp = ((((vav * __VBRinvsti) * (vav * __VBRinvsti)) * (vav * __VBRinvsti)) * (vav * __VBRinvsti));
                end
                else begin
                end
                fbreakdown = ( 1.0 / ( 1.0 - tmp));
              end
              else begin
                fbreakdown = (__fstopsti + ((vav + (__alphaav *  10.0)) * __slopesti));
              end
            end
            ijunsti = ((((id + isrh) + itat) + ibbt) * fbreakdown);
          end
          if ((__LGSOURCE_i ==  0.0)) begin
            ijungat =  0.0;
            qjungat =  0.0;
          end
          else begin
            if ((__one_minus_PGAT ==  0.5)) begin
              tmp = sqrt(( 1.0 - (vj * __vbiinvgat)));
            end
            else begin
              tmp = pow(( 1.0 - (vj * __vbiinvgat)), __one_minus_PGAT);
            end
            qjungat = ((__qprefgat * ( 1.0 - tmp)) + (__qpref2gat * (__V4 - vj)));
            id = (__idsatgat * idmult);
            if (0) begin
            end
            else begin
              vbi_minus_vjsrh = (__vbigat - vjsrh);
              wsrhstep = ( 1.0 - sqrt(( 1.0 - (two_psistar / vbi_minus_vjsrh))));
              if (0) begin
              end
              else begin
                dwsrh = (((((wsrhstep * wsrhstep) * ln(wsrhstep)) / ( 1.0 - wsrhstep)) + wsrhstep) * -0.295);
              end
              wsrh = (wsrhstep + dwsrh);
              if (0) begin
              end
              else begin
                tmp = pow((vbi_minus_vjsrh * __VBIRGATinv),  0.6475);
              end
              wdep = (__wdepnulrgat * tmp);
              asrh = (__ftdgat * ((zinv -  1.0) * wdep));
              isrh = ((asrh * wsrh) *  100.0e-6);
            end
            if (0) begin
            end
            else begin
              btat = (__btatpartgat * ((wdep * __one_minus_PGAT) / vbi_minus_vjsrh));
              twoatatoverthreebtat = ((__atatgat *  0.666666666666667) / btat);
              umaxbeforelimiting = (twoatatoverthreebtat * twoatatoverthreebtat);
              umax = sqrt(((umaxbeforelimiting * umaxbeforelimiting) / ((umaxbeforelimiting * umaxbeforelimiting) +  1.0)));
              sqrtumax = sqrt(umax);
              umaxpoweronepointfive = (umax * sqrtumax);
              if (((__one_over_one_minus_PGAT * -0.6475) == -1.0)) begin
                wgamma = ( 1.0 / ((btat * umaxpoweronepointfive) +  1.0));
              end
              else begin
                wgamma = pow(((btat * umaxpoweronepointfive) +  1.0), (__one_over_one_minus_PGAT * -0.6475));
              end
              wtat = ((wsrh * wgamma) / (wsrh + wgamma));
              ktat = sqrt(((btat / sqrtumax) *  0.375));
              ltat = (((twoatatoverthreebtat * sqrtumax) *  2.0) - umax);
              mtat = ((((__atatgat * twoatatoverthreebtat) * sqrtumax) - (__atatgat * umax)) + ((btat * umaxpoweronepointfive) *  0.5));
              xerfc = ((ltat -  1.0) * ktat);
              ysq = (xerfc * xerfc);
              if ((xerfc >  0.0)) begin
                terfc = ( 1.0 / ((__perfc * xerfc) +  1.0));
              end
              else begin
                terfc = ( 1.0 / ( 1.0 - (__perfc * xerfc)));
              end
              if ((((- ysq) + mtat) > -230.258509299405)) begin
                tmp = exp(((- ysq) + mtat));
              end
              else begin
                tmp = ( 100.0e-102 / (((-230.258509299405 - ((- ysq) + mtat)) * ((((-230.258509299405 - ((- ysq) + mtat)) * (((-230.258509299405 - ((- ysq) + mtat)) *  0.333333333333333) +  1.0)) *  0.5) +  1.0)) +  1.0));
              end
              erfcpos = ((((terfc *  0.29214664) + (__berfc * (terfc * terfc))) + (__cerfc * ((terfc * terfc) * terfc))) * tmp);
              if ((xerfc >  0.0)) begin
                erfctimesexpmtat = erfcpos;
              end
              else begin
                if ((mtat > -230.258509299405)) begin
                  tmp = exp(mtat);
                end
                else begin
                  tmp = ( 100.0e-102 / (((-230.258509299405 - mtat) * ((((-230.258509299405 - mtat) * (((-230.258509299405 - mtat) *  0.333333333333333) +  1.0)) *  0.5) +  1.0)) +  1.0));
                end
                erfctimesexpmtat = ((tmp *  2.0) - erfcpos);
              end
              gammamax = (((__atatgat * erfctimesexpmtat) / ktat) *  0.886226925452758);
              itat = (((asrh * gammamax) * wtat) *  100.0e-6);
            end
            if (0) begin
            end
            else begin
              if (0) begin
              end
              else begin
                tmp = pow((( 1.399 - vbbt) * __VBIRGATinv),  0.6475);
              end
              Fmaxr = (__one_over_one_minus_PGAT * ((( 1.399 - vbbt) * __wdepnulrinvgat) / tmp));
              if ((abs(((- __fbbtgat) / Fmaxr)) <  230.258509299405)) begin
                tmp = exp(((- __fbbtgat) / Fmaxr));
              end
              else begin
                if ((((- __fbbtgat) / Fmaxr) <  0.0)) begin
                  tmp = ( 100.0e-102 / (((-230.258509299405 - ((- __fbbtgat) / Fmaxr)) * ((((-230.258509299405 - ((- __fbbtgat) / Fmaxr)) * (((-230.258509299405 - ((- __fbbtgat) / Fmaxr)) *  0.333333333333333) +  1.0)) *  0.5) +  1.0)) +  1.0));
                end
                else begin
                  tmp = ((((((- __fbbtgat) / Fmaxr) -  230.258509299405) * ((((((- __fbbtgat) / Fmaxr) -  230.258509299405) * (((((- __fbbtgat) / Fmaxr) -  230.258509299405) *  0.333333333333333) +  1.0)) *  0.5) +  1.0)) +  1.0) *  10.0e+99);
                end
              end
              ibbt = ((((__V4 * Fmaxr) * Fmaxr) * tmp) *  1.0e-18);
            end
            if (0) begin
            end
            else begin
              if ((vav > ((- __alphaav) *  10.0))) begin
                if (1) begin
                  tmp = ((((vav * __VBRinvgat) * (vav * __VBRinvgat)) * (vav * __VBRinvgat)) * (vav * __VBRinvgat));
                end
                else begin
                end
                fbreakdown = ( 1.0 / ( 1.0 - tmp));
              end
              else begin
                fbreakdown = (__fstopgat + ((vav + (__alphaav *  10.0)) * __slopegat));
              end
            end
            ijungat = ((((id + isrh) + itat) + ibbt) * fbreakdown);
          end
          __I4 = (((__ABSOURCE_i * ijunbot) + (__LSSOURCE_i * ijunsti)) + (__LGSOURCE_i * ijungat));
          vbbt =  0.0;
          two_psistar =  0.0;
          if ((! (((__ABSOURCE_i ==  0.0) && (__LSSOURCE_i ==  0.0)) && (__LGSOURCE_i ==  0.0)))) begin
            h1 = ((__vch_s *  4.0) * __vch_s);
            h2 = (__vch_s / __vfmin_s);
            h2d = (__V5 + (__vch_s * h2));
            h3 = (__vfmin_s + h2d);
            h4 = (__vfmin_s - h2d);
            h5 = sqrt(((h4 * h4) + h1));
            vj = (((__V5 * __vfmin_s) / (h3 + h5)) *  2.0);
            if ((__V5 < __VMAX_s)) begin
              if ((abs(((__V5 * __phitdinv) *  0.5)) <  230.258509299405)) begin
                zinv = exp(((__V5 * __phitdinv) *  0.5));
              end
              else begin
                if ((((__V5 * __phitdinv) *  0.5) <  0.0)) begin
                  zinv = ( 100.0e-102 / (((-230.258509299405 - ((__V5 * __phitdinv) *  0.5)) * ((((-230.258509299405 - ((__V5 * __phitdinv) *  0.5)) * (((-230.258509299405 - ((__V5 * __phitdinv) *  0.5)) *  0.333333333333333) +  1.0)) *  0.5) +  1.0)) +  1.0));
                end
                else begin
                  zinv = ((((((__V5 * __phitdinv) *  0.5) -  230.258509299405) * ((((((__V5 * __phitdinv) *  0.5) -  230.258509299405) * (((((__V5 * __phitdinv) *  0.5) -  230.258509299405) *  0.333333333333333) +  1.0)) *  0.5) +  1.0)) +  1.0) *  10.0e+99);
                end
              end
              idmult = (zinv * zinv);
            end
            else begin
              idmult = ((((__V5 - __VMAX_s) * __phitdinv) +  1.0) * __exp_VMAX_over_phitd_s);
              zinv = sqrt(idmult);
            end
            idmult = (idmult -  1.0);
            z = ( 1.0 / zinv);
            if ((__V5 >  0.0)) begin
              two_psistar = ((__phitd * ln(((z +  2.0) + sqrt(((z +  1.0) * (z +  3.0)))))) *  2.0);
            end
            else begin
              two_psistar = ((- __V5) + ((__phitd * ln((((zinv *  2.0) +  1.0) + sqrt(((zinv +  1.0) * ((zinv *  3.0) +  1.0)))))) *  2.0));
            end
            vjlim = (__vbimin_s - two_psistar);
            vjsrh = (((__V5 + vjlim) - sqrt((((__V5 - vjlim) * (__V5 - vjlim)) + ((__phitd *  4.0) * __phitd)))) *  0.5);
            vbbt = (((__V5 + __vbbtlim_s) - sqrt((((__V5 - __vbbtlim_s) * (__V5 - __vbbtlim_s)) + ((__phitr *  4.0) * __phitr)))) *  0.5);
            vav = ((__V5 - sqrt(((__V5 * __V5) +  4.0e-12))) *  0.5);
          end
          if ((__ABSOURCE_i ==  0.0)) begin
            ijunbot =  0.0;
            qjunbot =  0.0;
          end
          else begin
            if ((__one_minus_PBOT ==  0.5)) begin
              tmp = sqrt(( 1.0 - (vj * __vbiinvbot)));
            end
            else begin
              tmp = pow(( 1.0 - (vj * __vbiinvbot)), __one_minus_PBOT);
            end
            qjunbot = ((__qprefbot * ( 1.0 - tmp)) + (__qpref2bot * (__V5 - vj)));
            id = (__idsatbot * idmult);
            if (0) begin
            end
            else begin
              vbi_minus_vjsrh = (__vbibot - vjsrh);
              wsrhstep = ( 1.0 - sqrt(( 1.0 - (two_psistar / vbi_minus_vjsrh))));
              if (0) begin
              end
              else begin
                dwsrh = (((((wsrhstep * wsrhstep) * ln(wsrhstep)) / ( 1.0 - wsrhstep)) + wsrhstep) *  0.2764);
              end
              wsrh = (wsrhstep + dwsrh);
              if (0) begin
              end
              else begin
                tmp = pow((vbi_minus_vjsrh * __VBIRBOTinv),  0.3618);
              end
              wdep = (__wdepnulrbot * tmp);
              asrh = (__ftdbot * ((zinv -  1.0) * wdep));
              isrh = ((asrh * wsrh) *  100.0);
            end
            if (0) begin
            end
            else begin
              btat = (__btatpartbot * ((wdep * __one_minus_PBOT) / vbi_minus_vjsrh));
              twoatatoverthreebtat = ((__atatbot *  0.666666666666667) / btat);
              umaxbeforelimiting = (twoatatoverthreebtat * twoatatoverthreebtat);
              umax = sqrt(((umaxbeforelimiting * umaxbeforelimiting) / ((umaxbeforelimiting * umaxbeforelimiting) +  1.0)));
              sqrtumax = sqrt(umax);
              umaxpoweronepointfive = (umax * sqrtumax);
              if (((__one_over_one_minus_PBOT * -0.3618) == -1.0)) begin
                wgamma = ( 1.0 / ((btat * umaxpoweronepointfive) +  1.0));
              end
              else begin
                wgamma = pow(((btat * umaxpoweronepointfive) +  1.0), (__one_over_one_minus_PBOT * -0.3618));
              end
              wtat = ((wsrh * wgamma) / (wsrh + wgamma));
              ktat = sqrt(((btat / sqrtumax) *  0.375));
              ltat = (((twoatatoverthreebtat * sqrtumax) *  2.0) - umax);
              mtat = ((((__atatbot * twoatatoverthreebtat) * sqrtumax) - (__atatbot * umax)) + ((btat * umaxpoweronepointfive) *  0.5));
              xerfc = ((ltat -  1.0) * ktat);
              ysq = (xerfc * xerfc);
              if ((xerfc >  0.0)) begin
                terfc = ( 1.0 / ((__perfc * xerfc) +  1.0));
              end
              else begin
                terfc = ( 1.0 / ( 1.0 - (__perfc * xerfc)));
              end
              if ((((- ysq) + mtat) > -230.258509299405)) begin
                tmp = exp(((- ysq) + mtat));
              end
              else begin
                tmp = ( 100.0e-102 / (((-230.258509299405 - ((- ysq) + mtat)) * ((((-230.258509299405 - ((- ysq) + mtat)) * (((-230.258509299405 - ((- ysq) + mtat)) *  0.333333333333333) +  1.0)) *  0.5) +  1.0)) +  1.0));
              end
              erfcpos = ((((terfc *  0.29214664) + (__berfc * (terfc * terfc))) + (__cerfc * ((terfc * terfc) * terfc))) * tmp);
              if ((xerfc >  0.0)) begin
                erfctimesexpmtat = erfcpos;
              end
              else begin
                if ((mtat > -230.258509299405)) begin
                  tmp = exp(mtat);
                end
                else begin
                  tmp = ( 100.0e-102 / (((-230.258509299405 - mtat) * ((((-230.258509299405 - mtat) * (((-230.258509299405 - mtat) *  0.333333333333333) +  1.0)) *  0.5) +  1.0)) +  1.0));
                end
                erfctimesexpmtat = ((tmp *  2.0) - erfcpos);
              end
              gammamax = (((__atatbot * erfctimesexpmtat) / ktat) *  0.886226925452758);
              itat = (((asrh * gammamax) * wtat) *  100.0);
            end
            if (0) begin
            end
            else begin
              if (0) begin
              end
              else begin
                tmp = pow((( 0.7686 - vbbt) * __VBIRBOTinv),  0.3618);
              end
              Fmaxr = (__one_over_one_minus_PBOT * ((( 0.7686 - vbbt) * __wdepnulrinvbot) / tmp));
              if ((abs(((- __fbbtbot) / Fmaxr)) <  230.258509299405)) begin
                tmp = exp(((- __fbbtbot) / Fmaxr));
              end
              else begin
                if ((((- __fbbtbot) / Fmaxr) <  0.0)) begin
                  tmp = ( 100.0e-102 / (((-230.258509299405 - ((- __fbbtbot) / Fmaxr)) * ((((-230.258509299405 - ((- __fbbtbot) / Fmaxr)) * (((-230.258509299405 - ((- __fbbtbot) / Fmaxr)) *  0.333333333333333) +  1.0)) *  0.5) +  1.0)) +  1.0));
                end
                else begin
                  tmp = ((((((- __fbbtbot) / Fmaxr) -  230.258509299405) * ((((((- __fbbtbot) / Fmaxr) -  230.258509299405) * (((((- __fbbtbot) / Fmaxr) -  230.258509299405) *  0.333333333333333) +  1.0)) *  0.5) +  1.0)) +  1.0) *  10.0e+99);
                end
              end
              ibbt = ((((__V5 * Fmaxr) * Fmaxr) * tmp) *  1.0e-12);
            end
            if (0) begin
            end
            else begin
              if ((vav > ((- __alphaav) *  10.0))) begin
                if (1) begin
                  tmp = ((((vav * __VBRinvbot) * (vav * __VBRinvbot)) * (vav * __VBRinvbot)) * (vav * __VBRinvbot));
                end
                else begin
                end
                fbreakdown = ( 1.0 / ( 1.0 - tmp));
              end
              else begin
                fbreakdown = (__fstopbot + ((vav + (__alphaav *  10.0)) * __slopebot));
              end
            end
            ijunbot = ((((id + isrh) + itat) + ibbt) * fbreakdown);
          end
          if ((__LSSOURCE_i ==  0.0)) begin
            ijunsti =  0.0;
            qjunsti =  0.0;
          end
          else begin
            if ((__one_minus_PSTI ==  0.5)) begin
              tmp = sqrt(( 1.0 - (vj * __vbiinvsti)));
            end
            else begin
              tmp = pow(( 1.0 - (vj * __vbiinvsti)), __one_minus_PSTI);
            end
            qjunsti = ((__qprefsti * ( 1.0 - tmp)) + (__qpref2sti * (__V5 - vj)));
            id = (__idsatsti * idmult);
            if (0) begin
            end
            else begin
              vbi_minus_vjsrh = (__vbisti - vjsrh);
              wsrhstep = ( 1.0 - sqrt(( 1.0 - (two_psistar / vbi_minus_vjsrh))));
              if (0) begin
              end
              else begin
                dwsrh = (((((wsrhstep * wsrhstep) * ln(wsrhstep)) / ( 1.0 - wsrhstep)) + wsrhstep) *  0.4904);
              end
              wsrh = (wsrhstep + dwsrh);
              if (0) begin
              end
              else begin
                tmp = pow((vbi_minus_vjsrh * __VBIRSTIinv),  0.2548);
              end
              wdep = (__wdepnulrsti * tmp);
              asrh = (__ftdsti * ((zinv -  1.0) * wdep));
              isrh = ((asrh * wsrh) *  100.0e-6);
            end
            if (0) begin
            end
            else begin
              btat = (__btatpartsti * ((wdep * __one_minus_PSTI) / vbi_minus_vjsrh));
              twoatatoverthreebtat = ((__atatsti *  0.666666666666667) / btat);
              umaxbeforelimiting = (twoatatoverthreebtat * twoatatoverthreebtat);
              umax = sqrt(((umaxbeforelimiting * umaxbeforelimiting) / ((umaxbeforelimiting * umaxbeforelimiting) +  1.0)));
              sqrtumax = sqrt(umax);
              umaxpoweronepointfive = (umax * sqrtumax);
              if (((__one_over_one_minus_PSTI * -0.2548) == -1.0)) begin
                wgamma = ( 1.0 / ((btat * umaxpoweronepointfive) +  1.0));
              end
              else begin
                wgamma = pow(((btat * umaxpoweronepointfive) +  1.0), (__one_over_one_minus_PSTI * -0.2548));
              end
              wtat = ((wsrh * wgamma) / (wsrh + wgamma));
              ktat = sqrt(((btat / sqrtumax) *  0.375));
              ltat = (((twoatatoverthreebtat * sqrtumax) *  2.0) - umax);
              mtat = ((((__atatsti * twoatatoverthreebtat) * sqrtumax) - (__atatsti * umax)) + ((btat * umaxpoweronepointfive) *  0.5));
              xerfc = ((ltat -  1.0) * ktat);
              ysq = (xerfc * xerfc);
              if ((xerfc >  0.0)) begin
                terfc = ( 1.0 / ((__perfc * xerfc) +  1.0));
              end
              else begin
                terfc = ( 1.0 / ( 1.0 - (__perfc * xerfc)));
              end
              if ((((- ysq) + mtat) > -230.258509299405)) begin
                tmp = exp(((- ysq) + mtat));
              end
              else begin
                tmp = ( 100.0e-102 / (((-230.258509299405 - ((- ysq) + mtat)) * ((((-230.258509299405 - ((- ysq) + mtat)) * (((-230.258509299405 - ((- ysq) + mtat)) *  0.333333333333333) +  1.0)) *  0.5) +  1.0)) +  1.0));
              end
              erfcpos = ((((terfc *  0.29214664) + (__berfc * (terfc * terfc))) + (__cerfc * ((terfc * terfc) * terfc))) * tmp);
              if ((xerfc >  0.0)) begin
                erfctimesexpmtat = erfcpos;
              end
              else begin
                if ((mtat > -230.258509299405)) begin
                  tmp = exp(mtat);
                end
                else begin
                  tmp = ( 100.0e-102 / (((-230.258509299405 - mtat) * ((((-230.258509299405 - mtat) * (((-230.258509299405 - mtat) *  0.333333333333333) +  1.0)) *  0.5) +  1.0)) +  1.0));
                end
                erfctimesexpmtat = ((tmp *  2.0) - erfcpos);
              end
              gammamax = (((__atatsti * erfctimesexpmtat) / ktat) *  0.886226925452758);
              itat = (((asrh * gammamax) * wtat) *  100.0e-6);
            end
            if (0) begin
            end
            else begin
              if (0) begin
              end
              else begin
                tmp = pow((( 1.7036 - vbbt) * __VBIRSTIinv),  0.2548);
              end
              Fmaxr = (__one_over_one_minus_PSTI * ((( 1.7036 - vbbt) * __wdepnulrinvsti) / tmp));
              if ((abs(((- __fbbtsti) / Fmaxr)) <  230.258509299405)) begin
                tmp = exp(((- __fbbtsti) / Fmaxr));
              end
              else begin
                if ((((- __fbbtsti) / Fmaxr) <  0.0)) begin
                  tmp = ( 100.0e-102 / (((-230.258509299405 - ((- __fbbtsti) / Fmaxr)) * ((((-230.258509299405 - ((- __fbbtsti) / Fmaxr)) * (((-230.258509299405 - ((- __fbbtsti) / Fmaxr)) *  0.333333333333333) +  1.0)) *  0.5) +  1.0)) +  1.0));
                end
                else begin
                  tmp = ((((((- __fbbtsti) / Fmaxr) -  230.258509299405) * ((((((- __fbbtsti) / Fmaxr) -  230.258509299405) * (((((- __fbbtsti) / Fmaxr) -  230.258509299405) *  0.333333333333333) +  1.0)) *  0.5) +  1.0)) +  1.0) *  10.0e+99);
                end
              end
              ibbt = ((((__V5 * Fmaxr) * Fmaxr) * tmp) *  1.0e-21);
            end
            if (0) begin
            end
            else begin
              if ((vav > ((- __alphaav) *  10.0))) begin
                if (1) begin
                  tmp = ((((vav * __VBRinvsti) * (vav * __VBRinvsti)) * (vav * __VBRinvsti)) * (vav * __VBRinvsti));
                end
                else begin
                end
                fbreakdown = ( 1.0 / ( 1.0 - tmp));
              end
              else begin
                fbreakdown = (__fstopsti + ((vav + (__alphaav *  10.0)) * __slopesti));
              end
            end
            ijunsti = ((((id + isrh) + itat) + ibbt) * fbreakdown);
          end
          if ((__LGSOURCE_i ==  0.0)) begin
            ijungat =  0.0;
            qjungat =  0.0;
          end
          else begin
            if ((__one_minus_PGAT ==  0.5)) begin
              tmp = sqrt(( 1.0 - (vj * __vbiinvgat)));
            end
            else begin
              tmp = pow(( 1.0 - (vj * __vbiinvgat)), __one_minus_PGAT);
            end
            qjungat = ((__qprefgat * ( 1.0 - tmp)) + (__qpref2gat * (__V5 - vj)));
            id = (__idsatgat * idmult);
            if (0) begin
            end
            else begin
              vbi_minus_vjsrh = (__vbigat - vjsrh);
              wsrhstep = ( 1.0 - sqrt(( 1.0 - (two_psistar / vbi_minus_vjsrh))));
              if (0) begin
              end
              else begin
                dwsrh = (((((wsrhstep * wsrhstep) * ln(wsrhstep)) / ( 1.0 - wsrhstep)) + wsrhstep) * -0.295);
              end
              wsrh = (wsrhstep + dwsrh);
              if (0) begin
              end
              else begin
                tmp = pow((vbi_minus_vjsrh * __VBIRGATinv),  0.6475);
              end
              wdep = (__wdepnulrgat * tmp);
              asrh = (__ftdgat * ((zinv -  1.0) * wdep));
              isrh = ((asrh * wsrh) *  100.0e-6);
            end
            if (0) begin
            end
            else begin
              btat = (__btatpartgat * ((wdep * __one_minus_PGAT) / vbi_minus_vjsrh));
              twoatatoverthreebtat = ((__atatgat *  0.666666666666667) / btat);
              umaxbeforelimiting = (twoatatoverthreebtat * twoatatoverthreebtat);
              umax = sqrt(((umaxbeforelimiting * umaxbeforelimiting) / ((umaxbeforelimiting * umaxbeforelimiting) +  1.0)));
              sqrtumax = sqrt(umax);
              umaxpoweronepointfive = (umax * sqrtumax);
              if (((__one_over_one_minus_PGAT * -0.6475) == -1.0)) begin
                wgamma = ( 1.0 / ((btat * umaxpoweronepointfive) +  1.0));
              end
              else begin
                wgamma = pow(((btat * umaxpoweronepointfive) +  1.0), (__one_over_one_minus_PGAT * -0.6475));
              end
              wtat = ((wsrh * wgamma) / (wsrh + wgamma));
              ktat = sqrt(((btat / sqrtumax) *  0.375));
              ltat = (((twoatatoverthreebtat * sqrtumax) *  2.0) - umax);
              mtat = ((((__atatgat * twoatatoverthreebtat) * sqrtumax) - (__atatgat * umax)) + ((btat * umaxpoweronepointfive) *  0.5));
              xerfc = ((ltat -  1.0) * ktat);
              ysq = (xerfc * xerfc);
              if ((xerfc >  0.0)) begin
                terfc = ( 1.0 / ((__perfc * xerfc) +  1.0));
              end
              else begin
                terfc = ( 1.0 / ( 1.0 - (__perfc * xerfc)));
              end
              if ((((- ysq) + mtat) > -230.258509299405)) begin
                tmp = exp(((- ysq) + mtat));
              end
              else begin
                tmp = ( 100.0e-102 / (((-230.258509299405 - ((- ysq) + mtat)) * ((((-230.258509299405 - ((- ysq) + mtat)) * (((-230.258509299405 - ((- ysq) + mtat)) *  0.333333333333333) +  1.0)) *  0.5) +  1.0)) +  1.0));
              end
              erfcpos = ((((terfc *  0.29214664) + (__berfc * (terfc * terfc))) + (__cerfc * ((terfc * terfc) * terfc))) * tmp);
              if ((xerfc >  0.0)) begin
                erfctimesexpmtat = erfcpos;
              end
              else begin
                if ((mtat > -230.258509299405)) begin
                  tmp = exp(mtat);
                end
                else begin
                  tmp = ( 100.0e-102 / (((-230.258509299405 - mtat) * ((((-230.258509299405 - mtat) * (((-230.258509299405 - mtat) *  0.333333333333333) +  1.0)) *  0.5) +  1.0)) +  1.0));
                end
                erfctimesexpmtat = ((tmp *  2.0) - erfcpos);
              end
              gammamax = (((__atatgat * erfctimesexpmtat) / ktat) *  0.886226925452758);
              itat = (((asrh * gammamax) * wtat) *  100.0e-6);
            end
            if (0) begin
            end
            else begin
              if (0) begin
              end
              else begin
                tmp = pow((( 1.399 - vbbt) * __VBIRGATinv),  0.6475);
              end
              Fmaxr = (__one_over_one_minus_PGAT * ((( 1.399 - vbbt) * __wdepnulrinvgat) / tmp));
              if ((abs(((- __fbbtgat) / Fmaxr)) <  230.258509299405)) begin
                tmp = exp(((- __fbbtgat) / Fmaxr));
              end
              else begin
                if ((((- __fbbtgat) / Fmaxr) <  0.0)) begin
                  tmp = ( 100.0e-102 / (((-230.258509299405 - ((- __fbbtgat) / Fmaxr)) * ((((-230.258509299405 - ((- __fbbtgat) / Fmaxr)) * (((-230.258509299405 - ((- __fbbtgat) / Fmaxr)) *  0.333333333333333) +  1.0)) *  0.5) +  1.0)) +  1.0));
                end
                else begin
                  tmp = ((((((- __fbbtgat) / Fmaxr) -  230.258509299405) * ((((((- __fbbtgat) / Fmaxr) -  230.258509299405) * (((((- __fbbtgat) / Fmaxr) -  230.258509299405) *  0.333333333333333) +  1.0)) *  0.5) +  1.0)) +  1.0) *  10.0e+99);
                end
              end
              ibbt = ((((__V5 * Fmaxr) * Fmaxr) * tmp) *  1.0e-18);
            end
            if (0) begin
            end
            else begin
              if ((vav > ((- __alphaav) *  10.0))) begin
                if (1) begin
                  tmp = ((((vav * __VBRinvgat) * (vav * __VBRinvgat)) * (vav * __VBRinvgat)) * (vav * __VBRinvgat));
                end
                else begin
                end
                fbreakdown = ( 1.0 / ( 1.0 - tmp));
              end
              else begin
                fbreakdown = (__fstopgat + ((vav + (__alphaav *  10.0)) * __slopegat));
              end
            end
            ijungat = ((((id + isrh) + itat) + ibbt) * fbreakdown);
          end
          __I5 = (((__ABSOURCE_i * ijunbot) + (__LSSOURCE_i * ijunsti)) + (__LGSOURCE_i * ijungat));
          __ISATFOR1_s = (((__ABSOURCE_i * __idsatbot) + (__LSSOURCE_i * __idsatsti)) + (__LGSOURCE_i * __idsatgat));
          __I4_cor = (__I4 - (__ISATFOR1_s * (exp(((__V4 * __phitdinv) * __MFOR1_s)) -  1.0)));
          __I5_cor = (__I5 - (__ISATFOR1_s * (exp(((__V5 * __phitdinv) * __MFOR1_s)) -  1.0)));
          if ((! (((__ABSOURCE_i ==  0.0) && (__LSSOURCE_i ==  0.0)) && (__LGSOURCE_i ==  0.0)))) begin
            if (((__I4 >  0.0) && (__I5 >  0.0))) begin
              if (((((((__I4_cor / __I4) >  0.001) || ((__I5_cor / __I5) >  0.001)) && (__I4_cor >  0.0)) && (__I5_cor >  0.0)) && (__I5_cor > __I4_cor))) begin
                __alphaje = (__I4_cor / __I5_cor);
                __MFOR2_s = ((__phitd * ln(__alphaje)) / (__V4 - __V5));
                __ISATFOR2_s = (__I4_cor / (exp(((__V4 * __phitdinv) * __MFOR2_s)) -  1.0));
              end
            end
            __I1_cor = ((__I1 - (__ISATFOR1_s * (exp(((__V1 * __phitdinv) * __MFOR1_s)) -  1.0))) - (__ISATFOR2_s * (exp(((__V1 * __phitdinv) * __MFOR2_s)) -  1.0)));
            __I2_cor = ((__I2 - (__ISATFOR1_s * (exp(((__V2 * __phitdinv) * __MFOR1_s)) -  1.0))) - (__ISATFOR2_s * (exp(((__V2 * __phitdinv) * __MFOR2_s)) -  1.0)));
            __I3_cor = ((__I3 - (__ISATFOR1_s * (exp(((__V3 * __phitdinv) * __MFOR1_s)) -  1.0))) - (__ISATFOR2_s * (exp(((__V3 * __phitdinv) * __MFOR2_s)) -  1.0)));
            if ((((__I1 <  0.0) && (__I2 <  0.0)) && (__I3 <  0.0))) begin
              if ((((((((__I1_cor / __I1) >  0.001) || ((__I2_cor / __I2) >  0.001)) || ((__I3_cor / __I3) >  0.001)) && (__I1_cor <  0.0)) && (__I2_cor <  0.0)) && (__I3_cor <  0.0))) begin
                __alphaje = (__I1_cor / __I2_cor);
                __m0_rev = (((- __phitd) * ln(__alphaje)) / (__V1 - __V2));
                __tt0 = (__V2 / (__V2 - __V1));
                __tt1 = ((__phitd * (__alphaje -  1.0)) * (pow(__alphaje, __tt0) -  1.0));
                __tt0 = (__V1 / (__V1 - __V2));
                __tt2 = (((pow(__alphaje, __tt0) * (__V2 - __V1)) + (__alphaje * __V1)) - __V2);
                __mcor_rev = (__tt1 / __tt2);
                __MREV_s = (__m0_rev + __mcor_rev);
                if ((abs(((__V3 * __phitdinv) * __MREV_s)) <  1.0e-6)) begin
                  __m0flag_s =  1.0;
                  __ISATREV_s = (__I3_cor * (( 1.0 / __V3) + ((__phitdinv *  0.5) * __MREV_s)));
                  __MREV_s = ((((__I3_cor * -0.5) * __MREV_s) * __phitdinv) / __V3);
                end
                else begin
                  __m0flag_s =  0.0;
                  __ISATREV_s = ((- __I3_cor) / (exp((((- __V3) * __phitdinv) * __MREV_s)) -  1.0));
                end
              end
            end
          end
          __zfrac = ((((__ABSOURCE_i * __cjobot) + (__LSSOURCE_i * __cjosti)) + (__LGSOURCE_i * __cjogat)) *  0.03);
          if (((__ABSOURCE_i * __cjobot) <= __zfrac)) begin
            __zflagbot_s =  0.0;
          end
          if (((__LSSOURCE_i * __cjosti) <= __zfrac)) begin
            __zflagsti_s =  0.0;
          end
          if (((__LGSOURCE_i * __cjogat) <= __zfrac)) begin
            __zflaggat_s =  0.0;
          end
          if ((! (((__ABSOURCE_i ==  0.0) && (__LSSOURCE_i ==  0.0)) && (__LGSOURCE_i ==  0.0)))) begin
            __xhighf1_s = ln(( 827.55e-6 / (__ISATFOR1_s +  1.0e-21)));
            __xhighf2_s = ln(( 827.55e-6 / (__ISATFOR2_s +  1.0e-21)));
            __xhighr_s = ln(( 827.55e-6 / (abs(__ISATREV_s) +  1.0e-21)));
          end
          __xhighf1_s = min(__xhighf1_s,  230.258509299405);
          __expxhf1_s = exp(__xhighf1_s);
          __xhighf2_s = min(__xhighf2_s,  230.258509299405);
          __expxhf2_s = exp(__xhighf2_s);
          __xhighr_s = min(__xhighr_s,  230.258509299405);
          __expxhr_s = exp(__xhighr_s);
          __FRACNA =  0.4;
          __FRACNB =  0.65;
          __FRACI =  0.8;
          __V1 = ((- __FRACNA) * __VJUNREFD_i);
          __V2 = ((- __FRACNB) * __VJUNREFD_i);
          __V3 = ((- __FRACI) * __VJUNREFD_i);
          __V4 =  0.1;
          __V5 =  0.2;
          vbbt =  0.0;
          two_psistar =  0.0;
          if ((! (((__ABDRAIN_i ==  0.0) && (__LSDRAIN_i ==  0.0)) && (__LGDRAIN_i ==  0.0)))) begin
            h1 = ((__vch_d *  4.0) * __vch_d);
            h2 = (__vch_d / __vfmin_d);
            h2d = (__V1 + (__vch_d * h2));
            h3 = (__vfmin_d + h2d);
            h4 = (__vfmin_d - h2d);
            h5 = sqrt(((h4 * h4) + h1));
            vj = (((__V1 * __vfmin_d) / (h3 + h5)) *  2.0);
            if ((__V1 < __VMAX_d)) begin
              if ((abs(((__V1 * __phitdinv) *  0.5)) <  230.258509299405)) begin
                zinv = exp(((__V1 * __phitdinv) *  0.5));
              end
              else begin
                if ((((__V1 * __phitdinv) *  0.5) <  0.0)) begin
                  zinv = ( 100.0e-102 / (((-230.258509299405 - ((__V1 * __phitdinv) *  0.5)) * ((((-230.258509299405 - ((__V1 * __phitdinv) *  0.5)) * (((-230.258509299405 - ((__V1 * __phitdinv) *  0.5)) *  0.333333333333333) +  1.0)) *  0.5) +  1.0)) +  1.0));
                end
                else begin
                  zinv = ((((((__V1 * __phitdinv) *  0.5) -  230.258509299405) * ((((((__V1 * __phitdinv) *  0.5) -  230.258509299405) * (((((__V1 * __phitdinv) *  0.5) -  230.258509299405) *  0.333333333333333) +  1.0)) *  0.5) +  1.0)) +  1.0) *  10.0e+99);
                end
              end
              idmult = (zinv * zinv);
            end
            else begin
              idmult = ((((__V1 - __VMAX_d) * __phitdinv) +  1.0) * __exp_VMAX_over_phitd_d);
              zinv = sqrt(idmult);
            end
            idmult = (idmult -  1.0);
            z = ( 1.0 / zinv);
            if ((__V1 >  0.0)) begin
              two_psistar = ((__phitd * ln(((z +  2.0) + sqrt(((z +  1.0) * (z +  3.0)))))) *  2.0);
            end
            else begin
              two_psistar = ((- __V1) + ((__phitd * ln((((zinv *  2.0) +  1.0) + sqrt(((zinv +  1.0) * ((zinv *  3.0) +  1.0)))))) *  2.0));
            end
            vjlim = (__vbimin_d - two_psistar);
            vjsrh = (((__V1 + vjlim) - sqrt((((__V1 - vjlim) * (__V1 - vjlim)) + ((__phitd *  4.0) * __phitd)))) *  0.5);
            vbbt = (((__V1 + __vbbtlim_d) - sqrt((((__V1 - __vbbtlim_d) * (__V1 - __vbbtlim_d)) + ((__phitr *  4.0) * __phitr)))) *  0.5);
            vav = ((__V1 - sqrt(((__V1 * __V1) +  4.0e-12))) *  0.5);
          end
          if ((__ABDRAIN_i ==  0.0)) begin
            ijunbot =  0.0;
            qjunbot =  0.0;
          end
          else begin
            if ((__one_minus_PBOT_d ==  0.5)) begin
              tmp = sqrt(( 1.0 - (vj * __vbiinvbot_d)));
            end
            else begin
              tmp = pow(( 1.0 - (vj * __vbiinvbot_d)), __one_minus_PBOT_d);
            end
            qjunbot = ((__qprefbot_d * ( 1.0 - tmp)) + (__qpref2bot_d * (__V1 - vj)));
            id = (__idsatbot_d * idmult);
            if (((__CSRHBOTD_i ==  0.0) && (__CTATBOTD_i ==  0.0))) begin
              isrh =  0.0;
            end
            else begin
              vbi_minus_vjsrh = (__vbibot_d - vjsrh);
              wsrhstep = ( 1.0 - sqrt(( 1.0 - (two_psistar / vbi_minus_vjsrh))));
              if ((__PBOTD_i ==  0.5)) begin
                dwsrh =  0.0;
              end
              else begin
                dwsrh = (((((wsrhstep * wsrhstep) * ln(wsrhstep)) / ( 1.0 - wsrhstep)) + wsrhstep) * ( 1.0 - (__PBOTD_i *  2.0)));
              end
              wsrh = (wsrhstep + dwsrh);
              if ((__PBOTD_i ==  0.5)) begin
                tmp = sqrt((vbi_minus_vjsrh * __VBIRBOTinv_d));
              end
              else begin
                tmp = pow((vbi_minus_vjsrh * __VBIRBOTinv_d), __PBOTD_i);
              end
              wdep = (__wdepnulrbot_d * tmp);
              asrh = (__ftdbot_d * ((zinv -  1.0) * wdep));
              isrh = (__CSRHBOTD_i * (asrh * wsrh));
            end
            if ((__CTATBOTD_i ==  0.0)) begin
              itat =  0.0;
            end
            else begin
              btat = (__btatpartbot_d * ((wdep * __one_minus_PBOT_d) / vbi_minus_vjsrh));
              twoatatoverthreebtat = ((__atatbot_d *  0.666666666666667) / btat);
              umaxbeforelimiting = (twoatatoverthreebtat * twoatatoverthreebtat);
              umax = sqrt(((umaxbeforelimiting * umaxbeforelimiting) / ((umaxbeforelimiting * umaxbeforelimiting) +  1.0)));
              sqrtumax = sqrt(umax);
              umaxpoweronepointfive = (umax * sqrtumax);
              if ((((- __PBOTD_i) * __one_over_one_minus_PBOT_d) == -1.0)) begin
                wgamma = ( 1.0 / ((btat * umaxpoweronepointfive) +  1.0));
              end
              else begin
                wgamma = pow(((btat * umaxpoweronepointfive) +  1.0), ((- __PBOTD_i) * __one_over_one_minus_PBOT_d));
              end
              wtat = ((wsrh * wgamma) / (wsrh + wgamma));
              ktat = sqrt(((btat / sqrtumax) *  0.375));
              ltat = (((twoatatoverthreebtat * sqrtumax) *  2.0) - umax);
              mtat = ((((__atatbot_d * twoatatoverthreebtat) * sqrtumax) - (__atatbot_d * umax)) + ((btat * umaxpoweronepointfive) *  0.5));
              xerfc = ((ltat -  1.0) * ktat);
              ysq = (xerfc * xerfc);
              if ((xerfc >  0.0)) begin
                terfc = ( 1.0 / ((__perfc * xerfc) +  1.0));
              end
              else begin
                terfc = ( 1.0 / ( 1.0 - (__perfc * xerfc)));
              end
              if ((((- ysq) + mtat) > -230.258509299405)) begin
                tmp = exp(((- ysq) + mtat));
              end
              else begin
                tmp = ( 100.0e-102 / (((-230.258509299405 - ((- ysq) + mtat)) * ((((-230.258509299405 - ((- ysq) + mtat)) * (((-230.258509299405 - ((- ysq) + mtat)) *  0.333333333333333) +  1.0)) *  0.5) +  1.0)) +  1.0));
              end
              erfcpos = ((((terfc *  0.29214664) + (__berfc * (terfc * terfc))) + (__cerfc * ((terfc * terfc) * terfc))) * tmp);
              if ((xerfc >  0.0)) begin
                erfctimesexpmtat = erfcpos;
              end
              else begin
                if ((mtat > -230.258509299405)) begin
                  tmp = exp(mtat);
                end
                else begin
                  tmp = ( 100.0e-102 / (((-230.258509299405 - mtat) * ((((-230.258509299405 - mtat) * (((-230.258509299405 - mtat) *  0.333333333333333) +  1.0)) *  0.5) +  1.0)) +  1.0));
                end
                erfctimesexpmtat = ((tmp *  2.0) - erfcpos);
              end
              gammamax = (((__atatbot_d * erfctimesexpmtat) / ktat) *  0.886226925452758);
              itat = (__CTATBOTD_i * ((asrh * gammamax) * wtat));
            end
            if ((__CBBTBOTD_i ==  0.0)) begin
              ibbt =  0.0;
            end
            else begin
              if ((__PBOTD_i ==  0.5)) begin
                tmp = sqrt(((__VBIRBOTD_i - vbbt) * __VBIRBOTinv_d));
              end
              else begin
                tmp = pow(((__VBIRBOTD_i - vbbt) * __VBIRBOTinv_d), __PBOTD_i);
              end
              Fmaxr = (__one_over_one_minus_PBOT_d * (((__VBIRBOTD_i - vbbt) * __wdepnulrinvbot_d) / tmp));
              if ((abs(((- __fbbtbot_d) / Fmaxr)) <  230.258509299405)) begin
                tmp = exp(((- __fbbtbot_d) / Fmaxr));
              end
              else begin
                if ((((- __fbbtbot_d) / Fmaxr) <  0.0)) begin
                  tmp = ( 100.0e-102 / (((-230.258509299405 - ((- __fbbtbot_d) / Fmaxr)) * ((((-230.258509299405 - ((- __fbbtbot_d) / Fmaxr)) * (((-230.258509299405 - ((- __fbbtbot_d) / Fmaxr)) *  0.333333333333333) +  1.0)) *  0.5) +  1.0)) +  1.0));
                end
                else begin
                  tmp = ((((((- __fbbtbot_d) / Fmaxr) -  230.258509299405) * ((((((- __fbbtbot_d) / Fmaxr) -  230.258509299405) * (((((- __fbbtbot_d) / Fmaxr) -  230.258509299405) *  0.333333333333333) +  1.0)) *  0.5) +  1.0)) +  1.0) *  10.0e+99);
                end
              end
              ibbt = (__CBBTBOTD_i * (((__V1 * Fmaxr) * Fmaxr) * tmp));
            end
            if ((__VBRBOTD_i >  1.0e+3)) begin
              fbreakdown =  1.0;
            end
            else begin
              if ((vav > ((- __alphaav) * __VBRBOTD_i))) begin
                if ((__PBRBOTD_i ==  4.0)) begin
                  tmp = ((((vav * __VBRinvbot_d) * (vav * __VBRinvbot_d)) * (vav * __VBRinvbot_d)) * (vav * __VBRinvbot_d));
                end
                else begin
                  tmp = pow(abs((vav * __VBRinvbot_d)), __PBRBOTD_i);
                end
                fbreakdown = ( 1.0 / ( 1.0 - tmp));
              end
              else begin
                fbreakdown = (__fstopbot_d + ((vav + (__alphaav * __VBRBOTD_i)) * __slopebot_d));
              end
            end
            ijunbot = ((((id + isrh) + itat) + ibbt) * fbreakdown);
          end
          if ((__LSDRAIN_i ==  0.0)) begin
            ijunsti =  0.0;
            qjunsti =  0.0;
          end
          else begin
            if ((__one_minus_PSTI_d ==  0.5)) begin
              tmp = sqrt(( 1.0 - (vj * __vbiinvsti_d)));
            end
            else begin
              tmp = pow(( 1.0 - (vj * __vbiinvsti_d)), __one_minus_PSTI_d);
            end
            qjunsti = ((__qprefsti_d * ( 1.0 - tmp)) + (__qpref2sti_d * (__V1 - vj)));
            id = (__idsatsti_d * idmult);
            if (((__CSRHSTID_i ==  0.0) && (__CTATSTID_i ==  0.0))) begin
              isrh =  0.0;
            end
            else begin
              vbi_minus_vjsrh = (__vbisti_d - vjsrh);
              wsrhstep = ( 1.0 - sqrt(( 1.0 - (two_psistar / vbi_minus_vjsrh))));
              if ((__PSTID_i ==  0.5)) begin
                dwsrh =  0.0;
              end
              else begin
                dwsrh = (((((wsrhstep * wsrhstep) * ln(wsrhstep)) / ( 1.0 - wsrhstep)) + wsrhstep) * ( 1.0 - (__PSTID_i *  2.0)));
              end
              wsrh = (wsrhstep + dwsrh);
              if ((__PSTID_i ==  0.5)) begin
                tmp = sqrt((vbi_minus_vjsrh * __VBIRSTIinv_d));
              end
              else begin
                tmp = pow((vbi_minus_vjsrh * __VBIRSTIinv_d), __PSTID_i);
              end
              wdep = (__wdepnulrsti_d * tmp);
              asrh = (__ftdsti_d * ((zinv -  1.0) * wdep));
              isrh = (__CSRHSTID_i * (asrh * wsrh));
            end
            if ((__CTATSTID_i ==  0.0)) begin
              itat =  0.0;
            end
            else begin
              btat = (__btatpartsti_d * ((wdep * __one_minus_PSTI_d) / vbi_minus_vjsrh));
              twoatatoverthreebtat = ((__atatsti_d *  0.666666666666667) / btat);
              umaxbeforelimiting = (twoatatoverthreebtat * twoatatoverthreebtat);
              umax = sqrt(((umaxbeforelimiting * umaxbeforelimiting) / ((umaxbeforelimiting * umaxbeforelimiting) +  1.0)));
              sqrtumax = sqrt(umax);
              umaxpoweronepointfive = (umax * sqrtumax);
              if ((((- __PSTID_i) * __one_over_one_minus_PSTI_d) == -1.0)) begin
                wgamma = ( 1.0 / ((btat * umaxpoweronepointfive) +  1.0));
              end
              else begin
                wgamma = pow(((btat * umaxpoweronepointfive) +  1.0), ((- __PSTID_i) * __one_over_one_minus_PSTI_d));
              end
              wtat = ((wsrh * wgamma) / (wsrh + wgamma));
              ktat = sqrt(((btat / sqrtumax) *  0.375));
              ltat = (((twoatatoverthreebtat * sqrtumax) *  2.0) - umax);
              mtat = ((((__atatsti_d * twoatatoverthreebtat) * sqrtumax) - (__atatsti_d * umax)) + ((btat * umaxpoweronepointfive) *  0.5));
              xerfc = ((ltat -  1.0) * ktat);
              ysq = (xerfc * xerfc);
              if ((xerfc >  0.0)) begin
                terfc = ( 1.0 / ((__perfc * xerfc) +  1.0));
              end
              else begin
                terfc = ( 1.0 / ( 1.0 - (__perfc * xerfc)));
              end
              if ((((- ysq) + mtat) > -230.258509299405)) begin
                tmp = exp(((- ysq) + mtat));
              end
              else begin
                tmp = ( 100.0e-102 / (((-230.258509299405 - ((- ysq) + mtat)) * ((((-230.258509299405 - ((- ysq) + mtat)) * (((-230.258509299405 - ((- ysq) + mtat)) *  0.333333333333333) +  1.0)) *  0.5) +  1.0)) +  1.0));
              end
              erfcpos = ((((terfc *  0.29214664) + (__berfc * (terfc * terfc))) + (__cerfc * ((terfc * terfc) * terfc))) * tmp);
              if ((xerfc >  0.0)) begin
                erfctimesexpmtat = erfcpos;
              end
              else begin
                if ((mtat > -230.258509299405)) begin
                  tmp = exp(mtat);
                end
                else begin
                  tmp = ( 100.0e-102 / (((-230.258509299405 - mtat) * ((((-230.258509299405 - mtat) * (((-230.258509299405 - mtat) *  0.333333333333333) +  1.0)) *  0.5) +  1.0)) +  1.0));
                end
                erfctimesexpmtat = ((tmp *  2.0) - erfcpos);
              end
              gammamax = (((__atatsti_d * erfctimesexpmtat) / ktat) *  0.886226925452758);
              itat = (__CTATSTID_i * ((asrh * gammamax) * wtat));
            end
            if ((__CBBTSTID_i ==  0.0)) begin
              ibbt =  0.0;
            end
            else begin
              if ((__PSTID_i ==  0.5)) begin
                tmp = sqrt(((__VBIRSTID_i - vbbt) * __VBIRSTIinv_d));
              end
              else begin
                tmp = pow(((__VBIRSTID_i - vbbt) * __VBIRSTIinv_d), __PSTID_i);
              end
              Fmaxr = (__one_over_one_minus_PSTI_d * (((__VBIRSTID_i - vbbt) * __wdepnulrinvsti_d) / tmp));
              if ((abs(((- __fbbtsti_d) / Fmaxr)) <  230.258509299405)) begin
                tmp = exp(((- __fbbtsti_d) / Fmaxr));
              end
              else begin
                if ((((- __fbbtsti_d) / Fmaxr) <  0.0)) begin
                  tmp = ( 100.0e-102 / (((-230.258509299405 - ((- __fbbtsti_d) / Fmaxr)) * ((((-230.258509299405 - ((- __fbbtsti_d) / Fmaxr)) * (((-230.258509299405 - ((- __fbbtsti_d) / Fmaxr)) *  0.333333333333333) +  1.0)) *  0.5) +  1.0)) +  1.0));
                end
                else begin
                  tmp = ((((((- __fbbtsti_d) / Fmaxr) -  230.258509299405) * ((((((- __fbbtsti_d) / Fmaxr) -  230.258509299405) * (((((- __fbbtsti_d) / Fmaxr) -  230.258509299405) *  0.333333333333333) +  1.0)) *  0.5) +  1.0)) +  1.0) *  10.0e+99);
                end
              end
              ibbt = (__CBBTSTID_i * (((__V1 * Fmaxr) * Fmaxr) * tmp));
            end
            if ((__VBRSTID_i >  1.0e+3)) begin
              fbreakdown =  1.0;
            end
            else begin
              if ((vav > ((- __alphaav) * __VBRSTID_i))) begin
                if ((__PBRSTID_i ==  4.0)) begin
                  tmp = ((((vav * __VBRinvsti_d) * (vav * __VBRinvsti_d)) * (vav * __VBRinvsti_d)) * (vav * __VBRinvsti_d));
                end
                else begin
                  tmp = pow(abs((vav * __VBRinvsti_d)), __PBRSTID_i);
                end
                fbreakdown = ( 1.0 / ( 1.0 - tmp));
              end
              else begin
                fbreakdown = (__fstopsti_d + ((vav + (__alphaav * __VBRSTID_i)) * __slopesti_d));
              end
            end
            ijunsti = ((((id + isrh) + itat) + ibbt) * fbreakdown);
          end
          if ((__LGDRAIN_i ==  0.0)) begin
            ijungat =  0.0;
            qjungat =  0.0;
          end
          else begin
            if ((__one_minus_PGAT_d ==  0.5)) begin
              tmp = sqrt(( 1.0 - (vj * __vbiinvgat_d)));
            end
            else begin
              tmp = pow(( 1.0 - (vj * __vbiinvgat_d)), __one_minus_PGAT_d);
            end
            qjungat = ((__qprefgat_d * ( 1.0 - tmp)) + (__qpref2gat_d * (__V1 - vj)));
            id = (__idsatgat_d * idmult);
            if (((__CSRHGATD_i ==  0.0) && (__CTATGATD_i ==  0.0))) begin
              isrh =  0.0;
            end
            else begin
              vbi_minus_vjsrh = (__vbigat_d - vjsrh);
              wsrhstep = ( 1.0 - sqrt(( 1.0 - (two_psistar / vbi_minus_vjsrh))));
              if ((__PGATD_i ==  0.5)) begin
                dwsrh =  0.0;
              end
              else begin
                dwsrh = (((((wsrhstep * wsrhstep) * ln(wsrhstep)) / ( 1.0 - wsrhstep)) + wsrhstep) * ( 1.0 - (__PGATD_i *  2.0)));
              end
              wsrh = (wsrhstep + dwsrh);
              if ((__PGATD_i ==  0.5)) begin
                tmp = sqrt((vbi_minus_vjsrh * __VBIRGATinv_d));
              end
              else begin
                tmp = pow((vbi_minus_vjsrh * __VBIRGATinv_d), __PGATD_i);
              end
              wdep = (__wdepnulrgat_d * tmp);
              asrh = (__ftdgat_d * ((zinv -  1.0) * wdep));
              isrh = (__CSRHGATD_i * (asrh * wsrh));
            end
            if ((__CTATGATD_i ==  0.0)) begin
              itat =  0.0;
            end
            else begin
              btat = (__btatpartgat_d * ((wdep * __one_minus_PGAT_d) / vbi_minus_vjsrh));
              twoatatoverthreebtat = ((__atatgat_d *  0.666666666666667) / btat);
              umaxbeforelimiting = (twoatatoverthreebtat * twoatatoverthreebtat);
              umax = sqrt(((umaxbeforelimiting * umaxbeforelimiting) / ((umaxbeforelimiting * umaxbeforelimiting) +  1.0)));
              sqrtumax = sqrt(umax);
              umaxpoweronepointfive = (umax * sqrtumax);
              if ((((- __PGATD_i) * __one_over_one_minus_PGAT_d) == -1.0)) begin
                wgamma = ( 1.0 / ((btat * umaxpoweronepointfive) +  1.0));
              end
              else begin
                wgamma = pow(((btat * umaxpoweronepointfive) +  1.0), ((- __PGATD_i) * __one_over_one_minus_PGAT_d));
              end
              wtat = ((wsrh * wgamma) / (wsrh + wgamma));
              ktat = sqrt(((btat / sqrtumax) *  0.375));
              ltat = (((twoatatoverthreebtat * sqrtumax) *  2.0) - umax);
              mtat = ((((__atatgat_d * twoatatoverthreebtat) * sqrtumax) - (__atatgat_d * umax)) + ((btat * umaxpoweronepointfive) *  0.5));
              xerfc = ((ltat -  1.0) * ktat);
              ysq = (xerfc * xerfc);
              if ((xerfc >  0.0)) begin
                terfc = ( 1.0 / ((__perfc * xerfc) +  1.0));
              end
              else begin
                terfc = ( 1.0 / ( 1.0 - (__perfc * xerfc)));
              end
              if ((((- ysq) + mtat) > -230.258509299405)) begin
                tmp = exp(((- ysq) + mtat));
              end
              else begin
                tmp = ( 100.0e-102 / (((-230.258509299405 - ((- ysq) + mtat)) * ((((-230.258509299405 - ((- ysq) + mtat)) * (((-230.258509299405 - ((- ysq) + mtat)) *  0.333333333333333) +  1.0)) *  0.5) +  1.0)) +  1.0));
              end
              erfcpos = ((((terfc *  0.29214664) + (__berfc * (terfc * terfc))) + (__cerfc * ((terfc * terfc) * terfc))) * tmp);
              if ((xerfc >  0.0)) begin
                erfctimesexpmtat = erfcpos;
              end
              else begin
                if ((mtat > -230.258509299405)) begin
                  tmp = exp(mtat);
                end
                else begin
                  tmp = ( 100.0e-102 / (((-230.258509299405 - mtat) * ((((-230.258509299405 - mtat) * (((-230.258509299405 - mtat) *  0.333333333333333) +  1.0)) *  0.5) +  1.0)) +  1.0));
                end
                erfctimesexpmtat = ((tmp *  2.0) - erfcpos);
              end
              gammamax = (((__atatgat_d * erfctimesexpmtat) / ktat) *  0.886226925452758);
              itat = (__CTATGATD_i * ((asrh * gammamax) * wtat));
            end
            if ((__CBBTGATD_i ==  0.0)) begin
              ibbt =  0.0;
            end
            else begin
              if ((__PGATD_i ==  0.5)) begin
                tmp = sqrt(((__VBIRGATD_i - vbbt) * __VBIRGATinv_d));
              end
              else begin
                tmp = pow(((__VBIRGATD_i - vbbt) * __VBIRGATinv_d), __PGATD_i);
              end
              Fmaxr = (__one_over_one_minus_PGAT_d * (((__VBIRGATD_i - vbbt) * __wdepnulrinvgat_d) / tmp));
              if ((abs(((- __fbbtgat_d) / Fmaxr)) <  230.258509299405)) begin
                tmp = exp(((- __fbbtgat_d) / Fmaxr));
              end
              else begin
                if ((((- __fbbtgat_d) / Fmaxr) <  0.0)) begin
                  tmp = ( 100.0e-102 / (((-230.258509299405 - ((- __fbbtgat_d) / Fmaxr)) * ((((-230.258509299405 - ((- __fbbtgat_d) / Fmaxr)) * (((-230.258509299405 - ((- __fbbtgat_d) / Fmaxr)) *  0.333333333333333) +  1.0)) *  0.5) +  1.0)) +  1.0));
                end
                else begin
                  tmp = ((((((- __fbbtgat_d) / Fmaxr) -  230.258509299405) * ((((((- __fbbtgat_d) / Fmaxr) -  230.258509299405) * (((((- __fbbtgat_d) / Fmaxr) -  230.258509299405) *  0.333333333333333) +  1.0)) *  0.5) +  1.0)) +  1.0) *  10.0e+99);
                end
              end
              ibbt = (__CBBTGATD_i * (((__V1 * Fmaxr) * Fmaxr) * tmp));
            end
            if ((__VBRGATD_i >  1.0e+3)) begin
              fbreakdown =  1.0;
            end
            else begin
              if ((vav > ((- __alphaav) * __VBRGATD_i))) begin
                if ((__PBRGATD_i ==  4.0)) begin
                  tmp = ((((vav * __VBRinvgat_d) * (vav * __VBRinvgat_d)) * (vav * __VBRinvgat_d)) * (vav * __VBRinvgat_d));
                end
                else begin
                  tmp = pow(abs((vav * __VBRinvgat_d)), __PBRGATD_i);
                end
                fbreakdown = ( 1.0 / ( 1.0 - tmp));
              end
              else begin
                fbreakdown = (__fstopgat_d + ((vav + (__alphaav * __VBRGATD_i)) * __slopegat_d));
              end
            end
            ijungat = ((((id + isrh) + itat) + ibbt) * fbreakdown);
          end
          __I1 = (((__ABDRAIN_i * ijunbot) + (__LSDRAIN_i * ijunsti)) + (__LGDRAIN_i * ijungat));
          vbbt =  0.0;
          two_psistar =  0.0;
          if ((! (((__ABDRAIN_i ==  0.0) && (__LSDRAIN_i ==  0.0)) && (__LGDRAIN_i ==  0.0)))) begin
            h1 = ((__vch_d *  4.0) * __vch_d);
            h2 = (__vch_d / __vfmin_d);
            h2d = (__V2 + (__vch_d * h2));
            h3 = (__vfmin_d + h2d);
            h4 = (__vfmin_d - h2d);
            h5 = sqrt(((h4 * h4) + h1));
            vj = (((__V2 * __vfmin_d) / (h3 + h5)) *  2.0);
            if ((__V2 < __VMAX_d)) begin
              if ((abs(((__V2 * __phitdinv) *  0.5)) <  230.258509299405)) begin
                zinv = exp(((__V2 * __phitdinv) *  0.5));
              end
              else begin
                if ((((__V2 * __phitdinv) *  0.5) <  0.0)) begin
                  zinv = ( 100.0e-102 / (((-230.258509299405 - ((__V2 * __phitdinv) *  0.5)) * ((((-230.258509299405 - ((__V2 * __phitdinv) *  0.5)) * (((-230.258509299405 - ((__V2 * __phitdinv) *  0.5)) *  0.333333333333333) +  1.0)) *  0.5) +  1.0)) +  1.0));
                end
                else begin
                  zinv = ((((((__V2 * __phitdinv) *  0.5) -  230.258509299405) * ((((((__V2 * __phitdinv) *  0.5) -  230.258509299405) * (((((__V2 * __phitdinv) *  0.5) -  230.258509299405) *  0.333333333333333) +  1.0)) *  0.5) +  1.0)) +  1.0) *  10.0e+99);
                end
              end
              idmult = (zinv * zinv);
            end
            else begin
              idmult = ((((__V2 - __VMAX_d) * __phitdinv) +  1.0) * __exp_VMAX_over_phitd_d);
              zinv = sqrt(idmult);
            end
            idmult = (idmult -  1.0);
            z = ( 1.0 / zinv);
            if ((__V2 >  0.0)) begin
              two_psistar = ((__phitd * ln(((z +  2.0) + sqrt(((z +  1.0) * (z +  3.0)))))) *  2.0);
            end
            else begin
              two_psistar = ((- __V2) + ((__phitd * ln((((zinv *  2.0) +  1.0) + sqrt(((zinv +  1.0) * ((zinv *  3.0) +  1.0)))))) *  2.0));
            end
            vjlim = (__vbimin_d - two_psistar);
            vjsrh = (((__V2 + vjlim) - sqrt((((__V2 - vjlim) * (__V2 - vjlim)) + ((__phitd *  4.0) * __phitd)))) *  0.5);
            vbbt = (((__V2 + __vbbtlim_d) - sqrt((((__V2 - __vbbtlim_d) * (__V2 - __vbbtlim_d)) + ((__phitr *  4.0) * __phitr)))) *  0.5);
            vav = ((__V2 - sqrt(((__V2 * __V2) +  4.0e-12))) *  0.5);
          end
          if ((__ABDRAIN_i ==  0.0)) begin
            ijunbot =  0.0;
            qjunbot =  0.0;
          end
          else begin
            if ((__one_minus_PBOT_d ==  0.5)) begin
              tmp = sqrt(( 1.0 - (vj * __vbiinvbot_d)));
            end
            else begin
              tmp = pow(( 1.0 - (vj * __vbiinvbot_d)), __one_minus_PBOT_d);
            end
            qjunbot = ((__qprefbot_d * ( 1.0 - tmp)) + (__qpref2bot_d * (__V2 - vj)));
            id = (__idsatbot_d * idmult);
            if (((__CSRHBOTD_i ==  0.0) && (__CTATBOTD_i ==  0.0))) begin
              isrh =  0.0;
            end
            else begin
              vbi_minus_vjsrh = (__vbibot_d - vjsrh);
              wsrhstep = ( 1.0 - sqrt(( 1.0 - (two_psistar / vbi_minus_vjsrh))));
              if ((__PBOTD_i ==  0.5)) begin
                dwsrh =  0.0;
              end
              else begin
                dwsrh = (((((wsrhstep * wsrhstep) * ln(wsrhstep)) / ( 1.0 - wsrhstep)) + wsrhstep) * ( 1.0 - (__PBOTD_i *  2.0)));
              end
              wsrh = (wsrhstep + dwsrh);
              if ((__PBOTD_i ==  0.5)) begin
                tmp = sqrt((vbi_minus_vjsrh * __VBIRBOTinv_d));
              end
              else begin
                tmp = pow((vbi_minus_vjsrh * __VBIRBOTinv_d), __PBOTD_i);
              end
              wdep = (__wdepnulrbot_d * tmp);
              asrh = (__ftdbot_d * ((zinv -  1.0) * wdep));
              isrh = (__CSRHBOTD_i * (asrh * wsrh));
            end
            if ((__CTATBOTD_i ==  0.0)) begin
              itat =  0.0;
            end
            else begin
              btat = (__btatpartbot_d * ((wdep * __one_minus_PBOT_d) / vbi_minus_vjsrh));
              twoatatoverthreebtat = ((__atatbot_d *  0.666666666666667) / btat);
              umaxbeforelimiting = (twoatatoverthreebtat * twoatatoverthreebtat);
              umax = sqrt(((umaxbeforelimiting * umaxbeforelimiting) / ((umaxbeforelimiting * umaxbeforelimiting) +  1.0)));
              sqrtumax = sqrt(umax);
              umaxpoweronepointfive = (umax * sqrtumax);
              if ((((- __PBOTD_i) * __one_over_one_minus_PBOT_d) == -1.0)) begin
                wgamma = ( 1.0 / ((btat * umaxpoweronepointfive) +  1.0));
              end
              else begin
                wgamma = pow(((btat * umaxpoweronepointfive) +  1.0), ((- __PBOTD_i) * __one_over_one_minus_PBOT_d));
              end
              wtat = ((wsrh * wgamma) / (wsrh + wgamma));
              ktat = sqrt(((btat / sqrtumax) *  0.375));
              ltat = (((twoatatoverthreebtat * sqrtumax) *  2.0) - umax);
              mtat = ((((__atatbot_d * twoatatoverthreebtat) * sqrtumax) - (__atatbot_d * umax)) + ((btat * umaxpoweronepointfive) *  0.5));
              xerfc = ((ltat -  1.0) * ktat);
              ysq = (xerfc * xerfc);
              if ((xerfc >  0.0)) begin
                terfc = ( 1.0 / ((__perfc * xerfc) +  1.0));
              end
              else begin
                terfc = ( 1.0 / ( 1.0 - (__perfc * xerfc)));
              end
              if ((((- ysq) + mtat) > -230.258509299405)) begin
                tmp = exp(((- ysq) + mtat));
              end
              else begin
                tmp = ( 100.0e-102 / (((-230.258509299405 - ((- ysq) + mtat)) * ((((-230.258509299405 - ((- ysq) + mtat)) * (((-230.258509299405 - ((- ysq) + mtat)) *  0.333333333333333) +  1.0)) *  0.5) +  1.0)) +  1.0));
              end
              erfcpos = ((((terfc *  0.29214664) + (__berfc * (terfc * terfc))) + (__cerfc * ((terfc * terfc) * terfc))) * tmp);
              if ((xerfc >  0.0)) begin
                erfctimesexpmtat = erfcpos;
              end
              else begin
                if ((mtat > -230.258509299405)) begin
                  tmp = exp(mtat);
                end
                else begin
                  tmp = ( 100.0e-102 / (((-230.258509299405 - mtat) * ((((-230.258509299405 - mtat) * (((-230.258509299405 - mtat) *  0.333333333333333) +  1.0)) *  0.5) +  1.0)) +  1.0));
                end
                erfctimesexpmtat = ((tmp *  2.0) - erfcpos);
              end
              gammamax = (((__atatbot_d * erfctimesexpmtat) / ktat) *  0.886226925452758);
              itat = (__CTATBOTD_i * ((asrh * gammamax) * wtat));
            end
            if ((__CBBTBOTD_i ==  0.0)) begin
              ibbt =  0.0;
            end
            else begin
              if ((__PBOTD_i ==  0.5)) begin
                tmp = sqrt(((__VBIRBOTD_i - vbbt) * __VBIRBOTinv_d));
              end
              else begin
                tmp = pow(((__VBIRBOTD_i - vbbt) * __VBIRBOTinv_d), __PBOTD_i);
              end
              Fmaxr = (__one_over_one_minus_PBOT_d * (((__VBIRBOTD_i - vbbt) * __wdepnulrinvbot_d) / tmp));
              if ((abs(((- __fbbtbot_d) / Fmaxr)) <  230.258509299405)) begin
                tmp = exp(((- __fbbtbot_d) / Fmaxr));
              end
              else begin
                if ((((- __fbbtbot_d) / Fmaxr) <  0.0)) begin
                  tmp = ( 100.0e-102 / (((-230.258509299405 - ((- __fbbtbot_d) / Fmaxr)) * ((((-230.258509299405 - ((- __fbbtbot_d) / Fmaxr)) * (((-230.258509299405 - ((- __fbbtbot_d) / Fmaxr)) *  0.333333333333333) +  1.0)) *  0.5) +  1.0)) +  1.0));
                end
                else begin
                  tmp = ((((((- __fbbtbot_d) / Fmaxr) -  230.258509299405) * ((((((- __fbbtbot_d) / Fmaxr) -  230.258509299405) * (((((- __fbbtbot_d) / Fmaxr) -  230.258509299405) *  0.333333333333333) +  1.0)) *  0.5) +  1.0)) +  1.0) *  10.0e+99);
                end
              end
              ibbt = (__CBBTBOTD_i * (((__V2 * Fmaxr) * Fmaxr) * tmp));
            end
            if ((__VBRBOTD_i >  1.0e+3)) begin
              fbreakdown =  1.0;
            end
            else begin
              if ((vav > ((- __alphaav) * __VBRBOTD_i))) begin
                if ((__PBRBOTD_i ==  4.0)) begin
                  tmp = ((((vav * __VBRinvbot_d) * (vav * __VBRinvbot_d)) * (vav * __VBRinvbot_d)) * (vav * __VBRinvbot_d));
                end
                else begin
                  tmp = pow(abs((vav * __VBRinvbot_d)), __PBRBOTD_i);
                end
                fbreakdown = ( 1.0 / ( 1.0 - tmp));
              end
              else begin
                fbreakdown = (__fstopbot_d + ((vav + (__alphaav * __VBRBOTD_i)) * __slopebot_d));
              end
            end
            ijunbot = ((((id + isrh) + itat) + ibbt) * fbreakdown);
          end
          if ((__LSDRAIN_i ==  0.0)) begin
            ijunsti =  0.0;
            qjunsti =  0.0;
          end
          else begin
            if ((__one_minus_PSTI_d ==  0.5)) begin
              tmp = sqrt(( 1.0 - (vj * __vbiinvsti_d)));
            end
            else begin
              tmp = pow(( 1.0 - (vj * __vbiinvsti_d)), __one_minus_PSTI_d);
            end
            qjunsti = ((__qprefsti_d * ( 1.0 - tmp)) + (__qpref2sti_d * (__V2 - vj)));
            id = (__idsatsti_d * idmult);
            if (((__CSRHSTID_i ==  0.0) && (__CTATSTID_i ==  0.0))) begin
              isrh =  0.0;
            end
            else begin
              vbi_minus_vjsrh = (__vbisti_d - vjsrh);
              wsrhstep = ( 1.0 - sqrt(( 1.0 - (two_psistar / vbi_minus_vjsrh))));
              if ((__PSTID_i ==  0.5)) begin
                dwsrh =  0.0;
              end
              else begin
                dwsrh = (((((wsrhstep * wsrhstep) * ln(wsrhstep)) / ( 1.0 - wsrhstep)) + wsrhstep) * ( 1.0 - (__PSTID_i *  2.0)));
              end
              wsrh = (wsrhstep + dwsrh);
              if ((__PSTID_i ==  0.5)) begin
                tmp = sqrt((vbi_minus_vjsrh * __VBIRSTIinv_d));
              end
              else begin
                tmp = pow((vbi_minus_vjsrh * __VBIRSTIinv_d), __PSTID_i);
              end
              wdep = (__wdepnulrsti_d * tmp);
              asrh = (__ftdsti_d * ((zinv -  1.0) * wdep));
              isrh = (__CSRHSTID_i * (asrh * wsrh));
            end
            if ((__CTATSTID_i ==  0.0)) begin
              itat =  0.0;
            end
            else begin
              btat = (__btatpartsti_d * ((wdep * __one_minus_PSTI_d) / vbi_minus_vjsrh));
              twoatatoverthreebtat = ((__atatsti_d *  0.666666666666667) / btat);
              umaxbeforelimiting = (twoatatoverthreebtat * twoatatoverthreebtat);
              umax = sqrt(((umaxbeforelimiting * umaxbeforelimiting) / ((umaxbeforelimiting * umaxbeforelimiting) +  1.0)));
              sqrtumax = sqrt(umax);
              umaxpoweronepointfive = (umax * sqrtumax);
              if ((((- __PSTID_i) * __one_over_one_minus_PSTI_d) == -1.0)) begin
                wgamma = ( 1.0 / ((btat * umaxpoweronepointfive) +  1.0));
              end
              else begin
                wgamma = pow(((btat * umaxpoweronepointfive) +  1.0), ((- __PSTID_i) * __one_over_one_minus_PSTI_d));
              end
              wtat = ((wsrh * wgamma) / (wsrh + wgamma));
              ktat = sqrt(((btat / sqrtumax) *  0.375));
              ltat = (((twoatatoverthreebtat * sqrtumax) *  2.0) - umax);
              mtat = ((((__atatsti_d * twoatatoverthreebtat) * sqrtumax) - (__atatsti_d * umax)) + ((btat * umaxpoweronepointfive) *  0.5));
              xerfc = ((ltat -  1.0) * ktat);
              ysq = (xerfc * xerfc);
              if ((xerfc >  0.0)) begin
                terfc = ( 1.0 / ((__perfc * xerfc) +  1.0));
              end
              else begin
                terfc = ( 1.0 / ( 1.0 - (__perfc * xerfc)));
              end
              if ((((- ysq) + mtat) > -230.258509299405)) begin
                tmp = exp(((- ysq) + mtat));
              end
              else begin
                tmp = ( 100.0e-102 / (((-230.258509299405 - ((- ysq) + mtat)) * ((((-230.258509299405 - ((- ysq) + mtat)) * (((-230.258509299405 - ((- ysq) + mtat)) *  0.333333333333333) +  1.0)) *  0.5) +  1.0)) +  1.0));
              end
              erfcpos = ((((terfc *  0.29214664) + (__berfc * (terfc * terfc))) + (__cerfc * ((terfc * terfc) * terfc))) * tmp);
              if ((xerfc >  0.0)) begin
                erfctimesexpmtat = erfcpos;
              end
              else begin
                if ((mtat > -230.258509299405)) begin
                  tmp = exp(mtat);
                end
                else begin
                  tmp = ( 100.0e-102 / (((-230.258509299405 - mtat) * ((((-230.258509299405 - mtat) * (((-230.258509299405 - mtat) *  0.333333333333333) +  1.0)) *  0.5) +  1.0)) +  1.0));
                end
                erfctimesexpmtat = ((tmp *  2.0) - erfcpos);
              end
              gammamax = (((__atatsti_d * erfctimesexpmtat) / ktat) *  0.886226925452758);
              itat = (__CTATSTID_i * ((asrh * gammamax) * wtat));
            end
            if ((__CBBTSTID_i ==  0.0)) begin
              ibbt =  0.0;
            end
            else begin
              if ((__PSTID_i ==  0.5)) begin
                tmp = sqrt(((__VBIRSTID_i - vbbt) * __VBIRSTIinv_d));
              end
              else begin
                tmp = pow(((__VBIRSTID_i - vbbt) * __VBIRSTIinv_d), __PSTID_i);
              end
              Fmaxr = (__one_over_one_minus_PSTI_d * (((__VBIRSTID_i - vbbt) * __wdepnulrinvsti_d) / tmp));
              if ((abs(((- __fbbtsti_d) / Fmaxr)) <  230.258509299405)) begin
                tmp = exp(((- __fbbtsti_d) / Fmaxr));
              end
              else begin
                if ((((- __fbbtsti_d) / Fmaxr) <  0.0)) begin
                  tmp = ( 100.0e-102 / (((-230.258509299405 - ((- __fbbtsti_d) / Fmaxr)) * ((((-230.258509299405 - ((- __fbbtsti_d) / Fmaxr)) * (((-230.258509299405 - ((- __fbbtsti_d) / Fmaxr)) *  0.333333333333333) +  1.0)) *  0.5) +  1.0)) +  1.0));
                end
                else begin
                  tmp = ((((((- __fbbtsti_d) / Fmaxr) -  230.258509299405) * ((((((- __fbbtsti_d) / Fmaxr) -  230.258509299405) * (((((- __fbbtsti_d) / Fmaxr) -  230.258509299405) *  0.333333333333333) +  1.0)) *  0.5) +  1.0)) +  1.0) *  10.0e+99);
                end
              end
              ibbt = (__CBBTSTID_i * (((__V2 * Fmaxr) * Fmaxr) * tmp));
            end
            if ((__VBRSTID_i >  1.0e+3)) begin
              fbreakdown =  1.0;
            end
            else begin
              if ((vav > ((- __alphaav) * __VBRSTID_i))) begin
                if ((__PBRSTID_i ==  4.0)) begin
                  tmp = ((((vav * __VBRinvsti_d) * (vav * __VBRinvsti_d)) * (vav * __VBRinvsti_d)) * (vav * __VBRinvsti_d));
                end
                else begin
                  tmp = pow(abs((vav * __VBRinvsti_d)), __PBRSTID_i);
                end
                fbreakdown = ( 1.0 / ( 1.0 - tmp));
              end
              else begin
                fbreakdown = (__fstopsti_d + ((vav + (__alphaav * __VBRSTID_i)) * __slopesti_d));
              end
            end
            ijunsti = ((((id + isrh) + itat) + ibbt) * fbreakdown);
          end
          if ((__LGDRAIN_i ==  0.0)) begin
            ijungat =  0.0;
            qjungat =  0.0;
          end
          else begin
            if ((__one_minus_PGAT_d ==  0.5)) begin
              tmp = sqrt(( 1.0 - (vj * __vbiinvgat_d)));
            end
            else begin
              tmp = pow(( 1.0 - (vj * __vbiinvgat_d)), __one_minus_PGAT_d);
            end
            qjungat = ((__qprefgat_d * ( 1.0 - tmp)) + (__qpref2gat_d * (__V2 - vj)));
            id = (__idsatgat_d * idmult);
            if (((__CSRHGATD_i ==  0.0) && (__CTATGATD_i ==  0.0))) begin
              isrh =  0.0;
            end
            else begin
              vbi_minus_vjsrh = (__vbigat_d - vjsrh);
              wsrhstep = ( 1.0 - sqrt(( 1.0 - (two_psistar / vbi_minus_vjsrh))));
              if ((__PGATD_i ==  0.5)) begin
                dwsrh =  0.0;
              end
              else begin
                dwsrh = (((((wsrhstep * wsrhstep) * ln(wsrhstep)) / ( 1.0 - wsrhstep)) + wsrhstep) * ( 1.0 - (__PGATD_i *  2.0)));
              end
              wsrh = (wsrhstep + dwsrh);
              if ((__PGATD_i ==  0.5)) begin
                tmp = sqrt((vbi_minus_vjsrh * __VBIRGATinv_d));
              end
              else begin
                tmp = pow((vbi_minus_vjsrh * __VBIRGATinv_d), __PGATD_i);
              end
              wdep = (__wdepnulrgat_d * tmp);
              asrh = (__ftdgat_d * ((zinv -  1.0) * wdep));
              isrh = (__CSRHGATD_i * (asrh * wsrh));
            end
            if ((__CTATGATD_i ==  0.0)) begin
              itat =  0.0;
            end
            else begin
              btat = (__btatpartgat_d * ((wdep * __one_minus_PGAT_d) / vbi_minus_vjsrh));
              twoatatoverthreebtat = ((__atatgat_d *  0.666666666666667) / btat);
              umaxbeforelimiting = (twoatatoverthreebtat * twoatatoverthreebtat);
              umax = sqrt(((umaxbeforelimiting * umaxbeforelimiting) / ((umaxbeforelimiting * umaxbeforelimiting) +  1.0)));
              sqrtumax = sqrt(umax);
              umaxpoweronepointfive = (umax * sqrtumax);
              if ((((- __PGATD_i) * __one_over_one_minus_PGAT_d) == -1.0)) begin
                wgamma = ( 1.0 / ((btat * umaxpoweronepointfive) +  1.0));
              end
              else begin
                wgamma = pow(((btat * umaxpoweronepointfive) +  1.0), ((- __PGATD_i) * __one_over_one_minus_PGAT_d));
              end
              wtat = ((wsrh * wgamma) / (wsrh + wgamma));
              ktat = sqrt(((btat / sqrtumax) *  0.375));
              ltat = (((twoatatoverthreebtat * sqrtumax) *  2.0) - umax);
              mtat = ((((__atatgat_d * twoatatoverthreebtat) * sqrtumax) - (__atatgat_d * umax)) + ((btat * umaxpoweronepointfive) *  0.5));
              xerfc = ((ltat -  1.0) * ktat);
              ysq = (xerfc * xerfc);
              if ((xerfc >  0.0)) begin
                terfc = ( 1.0 / ((__perfc * xerfc) +  1.0));
              end
              else begin
                terfc = ( 1.0 / ( 1.0 - (__perfc * xerfc)));
              end
              if ((((- ysq) + mtat) > -230.258509299405)) begin
                tmp = exp(((- ysq) + mtat));
              end
              else begin
                tmp = ( 100.0e-102 / (((-230.258509299405 - ((- ysq) + mtat)) * ((((-230.258509299405 - ((- ysq) + mtat)) * (((-230.258509299405 - ((- ysq) + mtat)) *  0.333333333333333) +  1.0)) *  0.5) +  1.0)) +  1.0));
              end
              erfcpos = ((((terfc *  0.29214664) + (__berfc * (terfc * terfc))) + (__cerfc * ((terfc * terfc) * terfc))) * tmp);
              if ((xerfc >  0.0)) begin
                erfctimesexpmtat = erfcpos;
              end
              else begin
                if ((mtat > -230.258509299405)) begin
                  tmp = exp(mtat);
                end
                else begin
                  tmp = ( 100.0e-102 / (((-230.258509299405 - mtat) * ((((-230.258509299405 - mtat) * (((-230.258509299405 - mtat) *  0.333333333333333) +  1.0)) *  0.5) +  1.0)) +  1.0));
                end
                erfctimesexpmtat = ((tmp *  2.0) - erfcpos);
              end
              gammamax = (((__atatgat_d * erfctimesexpmtat) / ktat) *  0.886226925452758);
              itat = (__CTATGATD_i * ((asrh * gammamax) * wtat));
            end
            if ((__CBBTGATD_i ==  0.0)) begin
              ibbt =  0.0;
            end
            else begin
              if ((__PGATD_i ==  0.5)) begin
                tmp = sqrt(((__VBIRGATD_i - vbbt) * __VBIRGATinv_d));
              end
              else begin
                tmp = pow(((__VBIRGATD_i - vbbt) * __VBIRGATinv_d), __PGATD_i);
              end
              Fmaxr = (__one_over_one_minus_PGAT_d * (((__VBIRGATD_i - vbbt) * __wdepnulrinvgat_d) / tmp));
              if ((abs(((- __fbbtgat_d) / Fmaxr)) <  230.258509299405)) begin
                tmp = exp(((- __fbbtgat_d) / Fmaxr));
              end
              else begin
                if ((((- __fbbtgat_d) / Fmaxr) <  0.0)) begin
                  tmp = ( 100.0e-102 / (((-230.258509299405 - ((- __fbbtgat_d) / Fmaxr)) * ((((-230.258509299405 - ((- __fbbtgat_d) / Fmaxr)) * (((-230.258509299405 - ((- __fbbtgat_d) / Fmaxr)) *  0.333333333333333) +  1.0)) *  0.5) +  1.0)) +  1.0));
                end
                else begin
                  tmp = ((((((- __fbbtgat_d) / Fmaxr) -  230.258509299405) * ((((((- __fbbtgat_d) / Fmaxr) -  230.258509299405) * (((((- __fbbtgat_d) / Fmaxr) -  230.258509299405) *  0.333333333333333) +  1.0)) *  0.5) +  1.0)) +  1.0) *  10.0e+99);
                end
              end
              ibbt = (__CBBTGATD_i * (((__V2 * Fmaxr) * Fmaxr) * tmp));
            end
            if ((__VBRGATD_i >  1.0e+3)) begin
              fbreakdown =  1.0;
            end
            else begin
              if ((vav > ((- __alphaav) * __VBRGATD_i))) begin
                if ((__PBRGATD_i ==  4.0)) begin
                  tmp = ((((vav * __VBRinvgat_d) * (vav * __VBRinvgat_d)) * (vav * __VBRinvgat_d)) * (vav * __VBRinvgat_d));
                end
                else begin
                  tmp = pow(abs((vav * __VBRinvgat_d)), __PBRGATD_i);
                end
                fbreakdown = ( 1.0 / ( 1.0 - tmp));
              end
              else begin
                fbreakdown = (__fstopgat_d + ((vav + (__alphaav * __VBRGATD_i)) * __slopegat_d));
              end
            end
            ijungat = ((((id + isrh) + itat) + ibbt) * fbreakdown);
          end
          __I2 = (((__ABDRAIN_i * ijunbot) + (__LSDRAIN_i * ijunsti)) + (__LGDRAIN_i * ijungat));
          vbbt =  0.0;
          two_psistar =  0.0;
          if ((! (((__ABDRAIN_i ==  0.0) && (__LSDRAIN_i ==  0.0)) && (__LGDRAIN_i ==  0.0)))) begin
            h1 = ((__vch_d *  4.0) * __vch_d);
            h2 = (__vch_d / __vfmin_d);
            h2d = (__V3 + (__vch_d * h2));
            h3 = (__vfmin_d + h2d);
            h4 = (__vfmin_d - h2d);
            h5 = sqrt(((h4 * h4) + h1));
            vj = (((__V3 * __vfmin_d) / (h3 + h5)) *  2.0);
            if ((__V3 < __VMAX_d)) begin
              if ((abs(((__V3 * __phitdinv) *  0.5)) <  230.258509299405)) begin
                zinv = exp(((__V3 * __phitdinv) *  0.5));
              end
              else begin
                if ((((__V3 * __phitdinv) *  0.5) <  0.0)) begin
                  zinv = ( 100.0e-102 / (((-230.258509299405 - ((__V3 * __phitdinv) *  0.5)) * ((((-230.258509299405 - ((__V3 * __phitdinv) *  0.5)) * (((-230.258509299405 - ((__V3 * __phitdinv) *  0.5)) *  0.333333333333333) +  1.0)) *  0.5) +  1.0)) +  1.0));
                end
                else begin
                  zinv = ((((((__V3 * __phitdinv) *  0.5) -  230.258509299405) * ((((((__V3 * __phitdinv) *  0.5) -  230.258509299405) * (((((__V3 * __phitdinv) *  0.5) -  230.258509299405) *  0.333333333333333) +  1.0)) *  0.5) +  1.0)) +  1.0) *  10.0e+99);
                end
              end
              idmult = (zinv * zinv);
            end
            else begin
              idmult = ((((__V3 - __VMAX_d) * __phitdinv) +  1.0) * __exp_VMAX_over_phitd_d);
              zinv = sqrt(idmult);
            end
            idmult = (idmult -  1.0);
            z = ( 1.0 / zinv);
            if ((__V3 >  0.0)) begin
              two_psistar = ((__phitd * ln(((z +  2.0) + sqrt(((z +  1.0) * (z +  3.0)))))) *  2.0);
            end
            else begin
              two_psistar = ((- __V3) + ((__phitd * ln((((zinv *  2.0) +  1.0) + sqrt(((zinv +  1.0) * ((zinv *  3.0) +  1.0)))))) *  2.0));
            end
            vjlim = (__vbimin_d - two_psistar);
            vjsrh = (((__V3 + vjlim) - sqrt((((__V3 - vjlim) * (__V3 - vjlim)) + ((__phitd *  4.0) * __phitd)))) *  0.5);
            vbbt = (((__V3 + __vbbtlim_d) - sqrt((((__V3 - __vbbtlim_d) * (__V3 - __vbbtlim_d)) + ((__phitr *  4.0) * __phitr)))) *  0.5);
            vav = ((__V3 - sqrt(((__V3 * __V3) +  4.0e-12))) *  0.5);
          end
          if ((__ABDRAIN_i ==  0.0)) begin
            ijunbot =  0.0;
            qjunbot =  0.0;
          end
          else begin
            if ((__one_minus_PBOT_d ==  0.5)) begin
              tmp = sqrt(( 1.0 - (vj * __vbiinvbot_d)));
            end
            else begin
              tmp = pow(( 1.0 - (vj * __vbiinvbot_d)), __one_minus_PBOT_d);
            end
            qjunbot = ((__qprefbot_d * ( 1.0 - tmp)) + (__qpref2bot_d * (__V3 - vj)));
            id = (__idsatbot_d * idmult);
            if (((__CSRHBOTD_i ==  0.0) && (__CTATBOTD_i ==  0.0))) begin
              isrh =  0.0;
            end
            else begin
              vbi_minus_vjsrh = (__vbibot_d - vjsrh);
              wsrhstep = ( 1.0 - sqrt(( 1.0 - (two_psistar / vbi_minus_vjsrh))));
              if ((__PBOTD_i ==  0.5)) begin
                dwsrh =  0.0;
              end
              else begin
                dwsrh = (((((wsrhstep * wsrhstep) * ln(wsrhstep)) / ( 1.0 - wsrhstep)) + wsrhstep) * ( 1.0 - (__PBOTD_i *  2.0)));
              end
              wsrh = (wsrhstep + dwsrh);
              if ((__PBOTD_i ==  0.5)) begin
                tmp = sqrt((vbi_minus_vjsrh * __VBIRBOTinv_d));
              end
              else begin
                tmp = pow((vbi_minus_vjsrh * __VBIRBOTinv_d), __PBOTD_i);
              end
              wdep = (__wdepnulrbot_d * tmp);
              asrh = (__ftdbot_d * ((zinv -  1.0) * wdep));
              isrh = (__CSRHBOTD_i * (asrh * wsrh));
            end
            if ((__CTATBOTD_i ==  0.0)) begin
              itat =  0.0;
            end
            else begin
              btat = (__btatpartbot_d * ((wdep * __one_minus_PBOT_d) / vbi_minus_vjsrh));
              twoatatoverthreebtat = ((__atatbot_d *  0.666666666666667) / btat);
              umaxbeforelimiting = (twoatatoverthreebtat * twoatatoverthreebtat);
              umax = sqrt(((umaxbeforelimiting * umaxbeforelimiting) / ((umaxbeforelimiting * umaxbeforelimiting) +  1.0)));
              sqrtumax = sqrt(umax);
              umaxpoweronepointfive = (umax * sqrtumax);
              if ((((- __PBOTD_i) * __one_over_one_minus_PBOT_d) == -1.0)) begin
                wgamma = ( 1.0 / ((btat * umaxpoweronepointfive) +  1.0));
              end
              else begin
                wgamma = pow(((btat * umaxpoweronepointfive) +  1.0), ((- __PBOTD_i) * __one_over_one_minus_PBOT_d));
              end
              wtat = ((wsrh * wgamma) / (wsrh + wgamma));
              ktat = sqrt(((btat / sqrtumax) *  0.375));
              ltat = (((twoatatoverthreebtat * sqrtumax) *  2.0) - umax);
              mtat = ((((__atatbot_d * twoatatoverthreebtat) * sqrtumax) - (__atatbot_d * umax)) + ((btat * umaxpoweronepointfive) *  0.5));
              xerfc = ((ltat -  1.0) * ktat);
              ysq = (xerfc * xerfc);
              if ((xerfc >  0.0)) begin
                terfc = ( 1.0 / ((__perfc * xerfc) +  1.0));
              end
              else begin
                terfc = ( 1.0 / ( 1.0 - (__perfc * xerfc)));
              end
              if ((((- ysq) + mtat) > -230.258509299405)) begin
                tmp = exp(((- ysq) + mtat));
              end
              else begin
                tmp = ( 100.0e-102 / (((-230.258509299405 - ((- ysq) + mtat)) * ((((-230.258509299405 - ((- ysq) + mtat)) * (((-230.258509299405 - ((- ysq) + mtat)) *  0.333333333333333) +  1.0)) *  0.5) +  1.0)) +  1.0));
              end
              erfcpos = ((((terfc *  0.29214664) + (__berfc * (terfc * terfc))) + (__cerfc * ((terfc * terfc) * terfc))) * tmp);
              if ((xerfc >  0.0)) begin
                erfctimesexpmtat = erfcpos;
              end
              else begin
                if ((mtat > -230.258509299405)) begin
                  tmp = exp(mtat);
                end
                else begin
                  tmp = ( 100.0e-102 / (((-230.258509299405 - mtat) * ((((-230.258509299405 - mtat) * (((-230.258509299405 - mtat) *  0.333333333333333) +  1.0)) *  0.5) +  1.0)) +  1.0));
                end
                erfctimesexpmtat = ((tmp *  2.0) - erfcpos);
              end
              gammamax = (((__atatbot_d * erfctimesexpmtat) / ktat) *  0.886226925452758);
              itat = (__CTATBOTD_i * ((asrh * gammamax) * wtat));
            end
            if ((__CBBTBOTD_i ==  0.0)) begin
              ibbt =  0.0;
            end
            else begin
              if ((__PBOTD_i ==  0.5)) begin
                tmp = sqrt(((__VBIRBOTD_i - vbbt) * __VBIRBOTinv_d));
              end
              else begin
                tmp = pow(((__VBIRBOTD_i - vbbt) * __VBIRBOTinv_d), __PBOTD_i);
              end
              Fmaxr = (__one_over_one_minus_PBOT_d * (((__VBIRBOTD_i - vbbt) * __wdepnulrinvbot_d) / tmp));
              if ((abs(((- __fbbtbot_d) / Fmaxr)) <  230.258509299405)) begin
                tmp = exp(((- __fbbtbot_d) / Fmaxr));
              end
              else begin
                if ((((- __fbbtbot_d) / Fmaxr) <  0.0)) begin
                  tmp = ( 100.0e-102 / (((-230.258509299405 - ((- __fbbtbot_d) / Fmaxr)) * ((((-230.258509299405 - ((- __fbbtbot_d) / Fmaxr)) * (((-230.258509299405 - ((- __fbbtbot_d) / Fmaxr)) *  0.333333333333333) +  1.0)) *  0.5) +  1.0)) +  1.0));
                end
                else begin
                  tmp = ((((((- __fbbtbot_d) / Fmaxr) -  230.258509299405) * ((((((- __fbbtbot_d) / Fmaxr) -  230.258509299405) * (((((- __fbbtbot_d) / Fmaxr) -  230.258509299405) *  0.333333333333333) +  1.0)) *  0.5) +  1.0)) +  1.0) *  10.0e+99);
                end
              end
              ibbt = (__CBBTBOTD_i * (((__V3 * Fmaxr) * Fmaxr) * tmp));
            end
            if ((__VBRBOTD_i >  1.0e+3)) begin
              fbreakdown =  1.0;
            end
            else begin
              if ((vav > ((- __alphaav) * __VBRBOTD_i))) begin
                if ((__PBRBOTD_i ==  4.0)) begin
                  tmp = ((((vav * __VBRinvbot_d) * (vav * __VBRinvbot_d)) * (vav * __VBRinvbot_d)) * (vav * __VBRinvbot_d));
                end
                else begin
                  tmp = pow(abs((vav * __VBRinvbot_d)), __PBRBOTD_i);
                end
                fbreakdown = ( 1.0 / ( 1.0 - tmp));
              end
              else begin
                fbreakdown = (__fstopbot_d + ((vav + (__alphaav * __VBRBOTD_i)) * __slopebot_d));
              end
            end
            ijunbot = ((((id + isrh) + itat) + ibbt) * fbreakdown);
          end
          if ((__LSDRAIN_i ==  0.0)) begin
            ijunsti =  0.0;
            qjunsti =  0.0;
          end
          else begin
            if ((__one_minus_PSTI_d ==  0.5)) begin
              tmp = sqrt(( 1.0 - (vj * __vbiinvsti_d)));
            end
            else begin
              tmp = pow(( 1.0 - (vj * __vbiinvsti_d)), __one_minus_PSTI_d);
            end
            qjunsti = ((__qprefsti_d * ( 1.0 - tmp)) + (__qpref2sti_d * (__V3 - vj)));
            id = (__idsatsti_d * idmult);
            if (((__CSRHSTID_i ==  0.0) && (__CTATSTID_i ==  0.0))) begin
              isrh =  0.0;
            end
            else begin
              vbi_minus_vjsrh = (__vbisti_d - vjsrh);
              wsrhstep = ( 1.0 - sqrt(( 1.0 - (two_psistar / vbi_minus_vjsrh))));
              if ((__PSTID_i ==  0.5)) begin
                dwsrh =  0.0;
              end
              else begin
                dwsrh = (((((wsrhstep * wsrhstep) * ln(wsrhstep)) / ( 1.0 - wsrhstep)) + wsrhstep) * ( 1.0 - (__PSTID_i *  2.0)));
              end
              wsrh = (wsrhstep + dwsrh);
              if ((__PSTID_i ==  0.5)) begin
                tmp = sqrt((vbi_minus_vjsrh * __VBIRSTIinv_d));
              end
              else begin
                tmp = pow((vbi_minus_vjsrh * __VBIRSTIinv_d), __PSTID_i);
              end
              wdep = (__wdepnulrsti_d * tmp);
              asrh = (__ftdsti_d * ((zinv -  1.0) * wdep));
              isrh = (__CSRHSTID_i * (asrh * wsrh));
            end
            if ((__CTATSTID_i ==  0.0)) begin
              itat =  0.0;
            end
            else begin
              btat = (__btatpartsti_d * ((wdep * __one_minus_PSTI_d) / vbi_minus_vjsrh));
              twoatatoverthreebtat = ((__atatsti_d *  0.666666666666667) / btat);
              umaxbeforelimiting = (twoatatoverthreebtat * twoatatoverthreebtat);
              umax = sqrt(((umaxbeforelimiting * umaxbeforelimiting) / ((umaxbeforelimiting * umaxbeforelimiting) +  1.0)));
              sqrtumax = sqrt(umax);
              umaxpoweronepointfive = (umax * sqrtumax);
              if ((((- __PSTID_i) * __one_over_one_minus_PSTI_d) == -1.0)) begin
                wgamma = ( 1.0 / ((btat * umaxpoweronepointfive) +  1.0));
              end
              else begin
                wgamma = pow(((btat * umaxpoweronepointfive) +  1.0), ((- __PSTID_i) * __one_over_one_minus_PSTI_d));
              end
              wtat = ((wsrh * wgamma) / (wsrh + wgamma));
              ktat = sqrt(((btat / sqrtumax) *  0.375));
              ltat = (((twoatatoverthreebtat * sqrtumax) *  2.0) - umax);
              mtat = ((((__atatsti_d * twoatatoverthreebtat) * sqrtumax) - (__atatsti_d * umax)) + ((btat * umaxpoweronepointfive) *  0.5));
              xerfc = ((ltat -  1.0) * ktat);
              ysq = (xerfc * xerfc);
              if ((xerfc >  0.0)) begin
                terfc = ( 1.0 / ((__perfc * xerfc) +  1.0));
              end
              else begin
                terfc = ( 1.0 / ( 1.0 - (__perfc * xerfc)));
              end
              if ((((- ysq) + mtat) > -230.258509299405)) begin
                tmp = exp(((- ysq) + mtat));
              end
              else begin
                tmp = ( 100.0e-102 / (((-230.258509299405 - ((- ysq) + mtat)) * ((((-230.258509299405 - ((- ysq) + mtat)) * (((-230.258509299405 - ((- ysq) + mtat)) *  0.333333333333333) +  1.0)) *  0.5) +  1.0)) +  1.0));
              end
              erfcpos = ((((terfc *  0.29214664) + (__berfc * (terfc * terfc))) + (__cerfc * ((terfc * terfc) * terfc))) * tmp);
              if ((xerfc >  0.0)) begin
                erfctimesexpmtat = erfcpos;
              end
              else begin
                if ((mtat > -230.258509299405)) begin
                  tmp = exp(mtat);
                end
                else begin
                  tmp = ( 100.0e-102 / (((-230.258509299405 - mtat) * ((((-230.258509299405 - mtat) * (((-230.258509299405 - mtat) *  0.333333333333333) +  1.0)) *  0.5) +  1.0)) +  1.0));
                end
                erfctimesexpmtat = ((tmp *  2.0) - erfcpos);
              end
              gammamax = (((__atatsti_d * erfctimesexpmtat) / ktat) *  0.886226925452758);
              itat = (__CTATSTID_i * ((asrh * gammamax) * wtat));
            end
            if ((__CBBTSTID_i ==  0.0)) begin
              ibbt =  0.0;
            end
            else begin
              if ((__PSTID_i ==  0.5)) begin
                tmp = sqrt(((__VBIRSTID_i - vbbt) * __VBIRSTIinv_d));
              end
              else begin
                tmp = pow(((__VBIRSTID_i - vbbt) * __VBIRSTIinv_d), __PSTID_i);
              end
              Fmaxr = (__one_over_one_minus_PSTI_d * (((__VBIRSTID_i - vbbt) * __wdepnulrinvsti_d) / tmp));
              if ((abs(((- __fbbtsti_d) / Fmaxr)) <  230.258509299405)) begin
                tmp = exp(((- __fbbtsti_d) / Fmaxr));
              end
              else begin
                if ((((- __fbbtsti_d) / Fmaxr) <  0.0)) begin
                  tmp = ( 100.0e-102 / (((-230.258509299405 - ((- __fbbtsti_d) / Fmaxr)) * ((((-230.258509299405 - ((- __fbbtsti_d) / Fmaxr)) * (((-230.258509299405 - ((- __fbbtsti_d) / Fmaxr)) *  0.333333333333333) +  1.0)) *  0.5) +  1.0)) +  1.0));
                end
                else begin
                  tmp = ((((((- __fbbtsti_d) / Fmaxr) -  230.258509299405) * ((((((- __fbbtsti_d) / Fmaxr) -  230.258509299405) * (((((- __fbbtsti_d) / Fmaxr) -  230.258509299405) *  0.333333333333333) +  1.0)) *  0.5) +  1.0)) +  1.0) *  10.0e+99);
                end
              end
              ibbt = (__CBBTSTID_i * (((__V3 * Fmaxr) * Fmaxr) * tmp));
            end
            if ((__VBRSTID_i >  1.0e+3)) begin
              fbreakdown =  1.0;
            end
            else begin
              if ((vav > ((- __alphaav) * __VBRSTID_i))) begin
                if ((__PBRSTID_i ==  4.0)) begin
                  tmp = ((((vav * __VBRinvsti_d) * (vav * __VBRinvsti_d)) * (vav * __VBRinvsti_d)) * (vav * __VBRinvsti_d));
                end
                else begin
                  tmp = pow(abs((vav * __VBRinvsti_d)), __PBRSTID_i);
                end
                fbreakdown = ( 1.0 / ( 1.0 - tmp));
              end
              else begin
                fbreakdown = (__fstopsti_d + ((vav + (__alphaav * __VBRSTID_i)) * __slopesti_d));
              end
            end
            ijunsti = ((((id + isrh) + itat) + ibbt) * fbreakdown);
          end
          if ((__LGDRAIN_i ==  0.0)) begin
            ijungat =  0.0;
            qjungat =  0.0;
          end
          else begin
            if ((__one_minus_PGAT_d ==  0.5)) begin
              tmp = sqrt(( 1.0 - (vj * __vbiinvgat_d)));
            end
            else begin
              tmp = pow(( 1.0 - (vj * __vbiinvgat_d)), __one_minus_PGAT_d);
            end
            qjungat = ((__qprefgat_d * ( 1.0 - tmp)) + (__qpref2gat_d * (__V3 - vj)));
            id = (__idsatgat_d * idmult);
            if (((__CSRHGATD_i ==  0.0) && (__CTATGATD_i ==  0.0))) begin
              isrh =  0.0;
            end
            else begin
              vbi_minus_vjsrh = (__vbigat_d - vjsrh);
              wsrhstep = ( 1.0 - sqrt(( 1.0 - (two_psistar / vbi_minus_vjsrh))));
              if ((__PGATD_i ==  0.5)) begin
                dwsrh =  0.0;
              end
              else begin
                dwsrh = (((((wsrhstep * wsrhstep) * ln(wsrhstep)) / ( 1.0 - wsrhstep)) + wsrhstep) * ( 1.0 - (__PGATD_i *  2.0)));
              end
              wsrh = (wsrhstep + dwsrh);
              if ((__PGATD_i ==  0.5)) begin
                tmp = sqrt((vbi_minus_vjsrh * __VBIRGATinv_d));
              end
              else begin
                tmp = pow((vbi_minus_vjsrh * __VBIRGATinv_d), __PGATD_i);
              end
              wdep = (__wdepnulrgat_d * tmp);
              asrh = (__ftdgat_d * ((zinv -  1.0) * wdep));
              isrh = (__CSRHGATD_i * (asrh * wsrh));
            end
            if ((__CTATGATD_i ==  0.0)) begin
              itat =  0.0;
            end
            else begin
              btat = (__btatpartgat_d * ((wdep * __one_minus_PGAT_d) / vbi_minus_vjsrh));
              twoatatoverthreebtat = ((__atatgat_d *  0.666666666666667) / btat);
              umaxbeforelimiting = (twoatatoverthreebtat * twoatatoverthreebtat);
              umax = sqrt(((umaxbeforelimiting * umaxbeforelimiting) / ((umaxbeforelimiting * umaxbeforelimiting) +  1.0)));
              sqrtumax = sqrt(umax);
              umaxpoweronepointfive = (umax * sqrtumax);
              if ((((- __PGATD_i) * __one_over_one_minus_PGAT_d) == -1.0)) begin
                wgamma = ( 1.0 / ((btat * umaxpoweronepointfive) +  1.0));
              end
              else begin
                wgamma = pow(((btat * umaxpoweronepointfive) +  1.0), ((- __PGATD_i) * __one_over_one_minus_PGAT_d));
              end
              wtat = ((wsrh * wgamma) / (wsrh + wgamma));
              ktat = sqrt(((btat / sqrtumax) *  0.375));
              ltat = (((twoatatoverthreebtat * sqrtumax) *  2.0) - umax);
              mtat = ((((__atatgat_d * twoatatoverthreebtat) * sqrtumax) - (__atatgat_d * umax)) + ((btat * umaxpoweronepointfive) *  0.5));
              xerfc = ((ltat -  1.0) * ktat);
              ysq = (xerfc * xerfc);
              if ((xerfc >  0.0)) begin
                terfc = ( 1.0 / ((__perfc * xerfc) +  1.0));
              end
              else begin
                terfc = ( 1.0 / ( 1.0 - (__perfc * xerfc)));
              end
              if ((((- ysq) + mtat) > -230.258509299405)) begin
                tmp = exp(((- ysq) + mtat));
              end
              else begin
                tmp = ( 100.0e-102 / (((-230.258509299405 - ((- ysq) + mtat)) * ((((-230.258509299405 - ((- ysq) + mtat)) * (((-230.258509299405 - ((- ysq) + mtat)) *  0.333333333333333) +  1.0)) *  0.5) +  1.0)) +  1.0));
              end
              erfcpos = ((((terfc *  0.29214664) + (__berfc * (terfc * terfc))) + (__cerfc * ((terfc * terfc) * terfc))) * tmp);
              if ((xerfc >  0.0)) begin
                erfctimesexpmtat = erfcpos;
              end
              else begin
                if ((mtat > -230.258509299405)) begin
                  tmp = exp(mtat);
                end
                else begin
                  tmp = ( 100.0e-102 / (((-230.258509299405 - mtat) * ((((-230.258509299405 - mtat) * (((-230.258509299405 - mtat) *  0.333333333333333) +  1.0)) *  0.5) +  1.0)) +  1.0));
                end
                erfctimesexpmtat = ((tmp *  2.0) - erfcpos);
              end
              gammamax = (((__atatgat_d * erfctimesexpmtat) / ktat) *  0.886226925452758);
              itat = (__CTATGATD_i * ((asrh * gammamax) * wtat));
            end
            if ((__CBBTGATD_i ==  0.0)) begin
              ibbt =  0.0;
            end
            else begin
              if ((__PGATD_i ==  0.5)) begin
                tmp = sqrt(((__VBIRGATD_i - vbbt) * __VBIRGATinv_d));
              end
              else begin
                tmp = pow(((__VBIRGATD_i - vbbt) * __VBIRGATinv_d), __PGATD_i);
              end
              Fmaxr = (__one_over_one_minus_PGAT_d * (((__VBIRGATD_i - vbbt) * __wdepnulrinvgat_d) / tmp));
              if ((abs(((- __fbbtgat_d) / Fmaxr)) <  230.258509299405)) begin
                tmp = exp(((- __fbbtgat_d) / Fmaxr));
              end
              else begin
                if ((((- __fbbtgat_d) / Fmaxr) <  0.0)) begin
                  tmp = ( 100.0e-102 / (((-230.258509299405 - ((- __fbbtgat_d) / Fmaxr)) * ((((-230.258509299405 - ((- __fbbtgat_d) / Fmaxr)) * (((-230.258509299405 - ((- __fbbtgat_d) / Fmaxr)) *  0.333333333333333) +  1.0)) *  0.5) +  1.0)) +  1.0));
                end
                else begin
                  tmp = ((((((- __fbbtgat_d) / Fmaxr) -  230.258509299405) * ((((((- __fbbtgat_d) / Fmaxr) -  230.258509299405) * (((((- __fbbtgat_d) / Fmaxr) -  230.258509299405) *  0.333333333333333) +  1.0)) *  0.5) +  1.0)) +  1.0) *  10.0e+99);
                end
              end
              ibbt = (__CBBTGATD_i * (((__V3 * Fmaxr) * Fmaxr) * tmp));
            end
            if ((__VBRGATD_i >  1.0e+3)) begin
              fbreakdown =  1.0;
            end
            else begin
              if ((vav > ((- __alphaav) * __VBRGATD_i))) begin
                if ((__PBRGATD_i ==  4.0)) begin
                  tmp = ((((vav * __VBRinvgat_d) * (vav * __VBRinvgat_d)) * (vav * __VBRinvgat_d)) * (vav * __VBRinvgat_d));
                end
                else begin
                  tmp = pow(abs((vav * __VBRinvgat_d)), __PBRGATD_i);
                end
                fbreakdown = ( 1.0 / ( 1.0 - tmp));
              end
              else begin
                fbreakdown = (__fstopgat_d + ((vav + (__alphaav * __VBRGATD_i)) * __slopegat_d));
              end
            end
            ijungat = ((((id + isrh) + itat) + ibbt) * fbreakdown);
          end
          __I3 = (((__ABDRAIN_i * ijunbot) + (__LSDRAIN_i * ijunsti)) + (__LGDRAIN_i * ijungat));
          vbbt =  0.0;
          two_psistar =  0.0;
          if ((! (((__ABDRAIN_i ==  0.0) && (__LSDRAIN_i ==  0.0)) && (__LGDRAIN_i ==  0.0)))) begin
            h1 = ((__vch_d *  4.0) * __vch_d);
            h2 = (__vch_d / __vfmin_d);
            h2d = (__V4 + (__vch_d * h2));
            h3 = (__vfmin_d + h2d);
            h4 = (__vfmin_d - h2d);
            h5 = sqrt(((h4 * h4) + h1));
            vj = (((__V4 * __vfmin_d) / (h3 + h5)) *  2.0);
            if ((__V4 < __VMAX_d)) begin
              if ((abs(((__V4 * __phitdinv) *  0.5)) <  230.258509299405)) begin
                zinv = exp(((__V4 * __phitdinv) *  0.5));
              end
              else begin
                if ((((__V4 * __phitdinv) *  0.5) <  0.0)) begin
                  zinv = ( 100.0e-102 / (((-230.258509299405 - ((__V4 * __phitdinv) *  0.5)) * ((((-230.258509299405 - ((__V4 * __phitdinv) *  0.5)) * (((-230.258509299405 - ((__V4 * __phitdinv) *  0.5)) *  0.333333333333333) +  1.0)) *  0.5) +  1.0)) +  1.0));
                end
                else begin
                  zinv = ((((((__V4 * __phitdinv) *  0.5) -  230.258509299405) * ((((((__V4 * __phitdinv) *  0.5) -  230.258509299405) * (((((__V4 * __phitdinv) *  0.5) -  230.258509299405) *  0.333333333333333) +  1.0)) *  0.5) +  1.0)) +  1.0) *  10.0e+99);
                end
              end
              idmult = (zinv * zinv);
            end
            else begin
              idmult = ((((__V4 - __VMAX_d) * __phitdinv) +  1.0) * __exp_VMAX_over_phitd_d);
              zinv = sqrt(idmult);
            end
            idmult = (idmult -  1.0);
            z = ( 1.0 / zinv);
            if ((__V4 >  0.0)) begin
              two_psistar = ((__phitd * ln(((z +  2.0) + sqrt(((z +  1.0) * (z +  3.0)))))) *  2.0);
            end
            else begin
              two_psistar = ((- __V4) + ((__phitd * ln((((zinv *  2.0) +  1.0) + sqrt(((zinv +  1.0) * ((zinv *  3.0) +  1.0)))))) *  2.0));
            end
            vjlim = (__vbimin_d - two_psistar);
            vjsrh = (((__V4 + vjlim) - sqrt((((__V4 - vjlim) * (__V4 - vjlim)) + ((__phitd *  4.0) * __phitd)))) *  0.5);
            vbbt = (((__V4 + __vbbtlim_d) - sqrt((((__V4 - __vbbtlim_d) * (__V4 - __vbbtlim_d)) + ((__phitr *  4.0) * __phitr)))) *  0.5);
            vav = ((__V4 - sqrt(((__V4 * __V4) +  4.0e-12))) *  0.5);
          end
          if ((__ABDRAIN_i ==  0.0)) begin
            ijunbot =  0.0;
            qjunbot =  0.0;
          end
          else begin
            if ((__one_minus_PBOT_d ==  0.5)) begin
              tmp = sqrt(( 1.0 - (vj * __vbiinvbot_d)));
            end
            else begin
              tmp = pow(( 1.0 - (vj * __vbiinvbot_d)), __one_minus_PBOT_d);
            end
            qjunbot = ((__qprefbot_d * ( 1.0 - tmp)) + (__qpref2bot_d * (__V4 - vj)));
            id = (__idsatbot_d * idmult);
            if (((__CSRHBOTD_i ==  0.0) && (__CTATBOTD_i ==  0.0))) begin
              isrh =  0.0;
            end
            else begin
              vbi_minus_vjsrh = (__vbibot_d - vjsrh);
              wsrhstep = ( 1.0 - sqrt(( 1.0 - (two_psistar / vbi_minus_vjsrh))));
              if ((__PBOTD_i ==  0.5)) begin
                dwsrh =  0.0;
              end
              else begin
                dwsrh = (((((wsrhstep * wsrhstep) * ln(wsrhstep)) / ( 1.0 - wsrhstep)) + wsrhstep) * ( 1.0 - (__PBOTD_i *  2.0)));
              end
              wsrh = (wsrhstep + dwsrh);
              if ((__PBOTD_i ==  0.5)) begin
                tmp = sqrt((vbi_minus_vjsrh * __VBIRBOTinv_d));
              end
              else begin
                tmp = pow((vbi_minus_vjsrh * __VBIRBOTinv_d), __PBOTD_i);
              end
              wdep = (__wdepnulrbot_d * tmp);
              asrh = (__ftdbot_d * ((zinv -  1.0) * wdep));
              isrh = (__CSRHBOTD_i * (asrh * wsrh));
            end
            if ((__CTATBOTD_i ==  0.0)) begin
              itat =  0.0;
            end
            else begin
              btat = (__btatpartbot_d * ((wdep * __one_minus_PBOT_d) / vbi_minus_vjsrh));
              twoatatoverthreebtat = ((__atatbot_d *  0.666666666666667) / btat);
              umaxbeforelimiting = (twoatatoverthreebtat * twoatatoverthreebtat);
              umax = sqrt(((umaxbeforelimiting * umaxbeforelimiting) / ((umaxbeforelimiting * umaxbeforelimiting) +  1.0)));
              sqrtumax = sqrt(umax);
              umaxpoweronepointfive = (umax * sqrtumax);
              if ((((- __PBOTD_i) * __one_over_one_minus_PBOT_d) == -1.0)) begin
                wgamma = ( 1.0 / ((btat * umaxpoweronepointfive) +  1.0));
              end
              else begin
                wgamma = pow(((btat * umaxpoweronepointfive) +  1.0), ((- __PBOTD_i) * __one_over_one_minus_PBOT_d));
              end
              wtat = ((wsrh * wgamma) / (wsrh + wgamma));
              ktat = sqrt(((btat / sqrtumax) *  0.375));
              ltat = (((twoatatoverthreebtat * sqrtumax) *  2.0) - umax);
              mtat = ((((__atatbot_d * twoatatoverthreebtat) * sqrtumax) - (__atatbot_d * umax)) + ((btat * umaxpoweronepointfive) *  0.5));
              xerfc = ((ltat -  1.0) * ktat);
              ysq = (xerfc * xerfc);
              if ((xerfc >  0.0)) begin
                terfc = ( 1.0 / ((__perfc * xerfc) +  1.0));
              end
              else begin
                terfc = ( 1.0 / ( 1.0 - (__perfc * xerfc)));
              end
              if ((((- ysq) + mtat) > -230.258509299405)) begin
                tmp = exp(((- ysq) + mtat));
              end
              else begin
                tmp = ( 100.0e-102 / (((-230.258509299405 - ((- ysq) + mtat)) * ((((-230.258509299405 - ((- ysq) + mtat)) * (((-230.258509299405 - ((- ysq) + mtat)) *  0.333333333333333) +  1.0)) *  0.5) +  1.0)) +  1.0));
              end
              erfcpos = ((((terfc *  0.29214664) + (__berfc * (terfc * terfc))) + (__cerfc * ((terfc * terfc) * terfc))) * tmp);
              if ((xerfc >  0.0)) begin
                erfctimesexpmtat = erfcpos;
              end
              else begin
                if ((mtat > -230.258509299405)) begin
                  tmp = exp(mtat);
                end
                else begin
                  tmp = ( 100.0e-102 / (((-230.258509299405 - mtat) * ((((-230.258509299405 - mtat) * (((-230.258509299405 - mtat) *  0.333333333333333) +  1.0)) *  0.5) +  1.0)) +  1.0));
                end
                erfctimesexpmtat = ((tmp *  2.0) - erfcpos);
              end
              gammamax = (((__atatbot_d * erfctimesexpmtat) / ktat) *  0.886226925452758);
              itat = (__CTATBOTD_i * ((asrh * gammamax) * wtat));
            end
            if ((__CBBTBOTD_i ==  0.0)) begin
              ibbt =  0.0;
            end
            else begin
              if ((__PBOTD_i ==  0.5)) begin
                tmp = sqrt(((__VBIRBOTD_i - vbbt) * __VBIRBOTinv_d));
              end
              else begin
                tmp = pow(((__VBIRBOTD_i - vbbt) * __VBIRBOTinv_d), __PBOTD_i);
              end
              Fmaxr = (__one_over_one_minus_PBOT_d * (((__VBIRBOTD_i - vbbt) * __wdepnulrinvbot_d) / tmp));
              if ((abs(((- __fbbtbot_d) / Fmaxr)) <  230.258509299405)) begin
                tmp = exp(((- __fbbtbot_d) / Fmaxr));
              end
              else begin
                if ((((- __fbbtbot_d) / Fmaxr) <  0.0)) begin
                  tmp = ( 100.0e-102 / (((-230.258509299405 - ((- __fbbtbot_d) / Fmaxr)) * ((((-230.258509299405 - ((- __fbbtbot_d) / Fmaxr)) * (((-230.258509299405 - ((- __fbbtbot_d) / Fmaxr)) *  0.333333333333333) +  1.0)) *  0.5) +  1.0)) +  1.0));
                end
                else begin
                  tmp = ((((((- __fbbtbot_d) / Fmaxr) -  230.258509299405) * ((((((- __fbbtbot_d) / Fmaxr) -  230.258509299405) * (((((- __fbbtbot_d) / Fmaxr) -  230.258509299405) *  0.333333333333333) +  1.0)) *  0.5) +  1.0)) +  1.0) *  10.0e+99);
                end
              end
              ibbt = (__CBBTBOTD_i * (((__V4 * Fmaxr) * Fmaxr) * tmp));
            end
            if ((__VBRBOTD_i >  1.0e+3)) begin
              fbreakdown =  1.0;
            end
            else begin
              if ((vav > ((- __alphaav) * __VBRBOTD_i))) begin
                if ((__PBRBOTD_i ==  4.0)) begin
                  tmp = ((((vav * __VBRinvbot_d) * (vav * __VBRinvbot_d)) * (vav * __VBRinvbot_d)) * (vav * __VBRinvbot_d));
                end
                else begin
                  tmp = pow(abs((vav * __VBRinvbot_d)), __PBRBOTD_i);
                end
                fbreakdown = ( 1.0 / ( 1.0 - tmp));
              end
              else begin
                fbreakdown = (__fstopbot_d + ((vav + (__alphaav * __VBRBOTD_i)) * __slopebot_d));
              end
            end
            ijunbot = ((((id + isrh) + itat) + ibbt) * fbreakdown);
          end
          if ((__LSDRAIN_i ==  0.0)) begin
            ijunsti =  0.0;
            qjunsti =  0.0;
          end
          else begin
            if ((__one_minus_PSTI_d ==  0.5)) begin
              tmp = sqrt(( 1.0 - (vj * __vbiinvsti_d)));
            end
            else begin
              tmp = pow(( 1.0 - (vj * __vbiinvsti_d)), __one_minus_PSTI_d);
            end
            qjunsti = ((__qprefsti_d * ( 1.0 - tmp)) + (__qpref2sti_d * (__V4 - vj)));
            id = (__idsatsti_d * idmult);
            if (((__CSRHSTID_i ==  0.0) && (__CTATSTID_i ==  0.0))) begin
              isrh =  0.0;
            end
            else begin
              vbi_minus_vjsrh = (__vbisti_d - vjsrh);
              wsrhstep = ( 1.0 - sqrt(( 1.0 - (two_psistar / vbi_minus_vjsrh))));
              if ((__PSTID_i ==  0.5)) begin
                dwsrh =  0.0;
              end
              else begin
                dwsrh = (((((wsrhstep * wsrhstep) * ln(wsrhstep)) / ( 1.0 - wsrhstep)) + wsrhstep) * ( 1.0 - (__PSTID_i *  2.0)));
              end
              wsrh = (wsrhstep + dwsrh);
              if ((__PSTID_i ==  0.5)) begin
                tmp = sqrt((vbi_minus_vjsrh * __VBIRSTIinv_d));
              end
              else begin
                tmp = pow((vbi_minus_vjsrh * __VBIRSTIinv_d), __PSTID_i);
              end
              wdep = (__wdepnulrsti_d * tmp);
              asrh = (__ftdsti_d * ((zinv -  1.0) * wdep));
              isrh = (__CSRHSTID_i * (asrh * wsrh));
            end
            if ((__CTATSTID_i ==  0.0)) begin
              itat =  0.0;
            end
            else begin
              btat = (__btatpartsti_d * ((wdep * __one_minus_PSTI_d) / vbi_minus_vjsrh));
              twoatatoverthreebtat = ((__atatsti_d *  0.666666666666667) / btat);
              umaxbeforelimiting = (twoatatoverthreebtat * twoatatoverthreebtat);
              umax = sqrt(((umaxbeforelimiting * umaxbeforelimiting) / ((umaxbeforelimiting * umaxbeforelimiting) +  1.0)));
              sqrtumax = sqrt(umax);
              umaxpoweronepointfive = (umax * sqrtumax);
              if ((((- __PSTID_i) * __one_over_one_minus_PSTI_d) == -1.0)) begin
                wgamma = ( 1.0 / ((btat * umaxpoweronepointfive) +  1.0));
              end
              else begin
                wgamma = pow(((btat * umaxpoweronepointfive) +  1.0), ((- __PSTID_i) * __one_over_one_minus_PSTI_d));
              end
              wtat = ((wsrh * wgamma) / (wsrh + wgamma));
              ktat = sqrt(((btat / sqrtumax) *  0.375));
              ltat = (((twoatatoverthreebtat * sqrtumax) *  2.0) - umax);
              mtat = ((((__atatsti_d * twoatatoverthreebtat) * sqrtumax) - (__atatsti_d * umax)) + ((btat * umaxpoweronepointfive) *  0.5));
              xerfc = ((ltat -  1.0) * ktat);
              ysq = (xerfc * xerfc);
              if ((xerfc >  0.0)) begin
                terfc = ( 1.0 / ((__perfc * xerfc) +  1.0));
              end
              else begin
                terfc = ( 1.0 / ( 1.0 - (__perfc * xerfc)));
              end
              if ((((- ysq) + mtat) > -230.258509299405)) begin
                tmp = exp(((- ysq) + mtat));
              end
              else begin
                tmp = ( 100.0e-102 / (((-230.258509299405 - ((- ysq) + mtat)) * ((((-230.258509299405 - ((- ysq) + mtat)) * (((-230.258509299405 - ((- ysq) + mtat)) *  0.333333333333333) +  1.0)) *  0.5) +  1.0)) +  1.0));
              end
              erfcpos = ((((terfc *  0.29214664) + (__berfc * (terfc * terfc))) + (__cerfc * ((terfc * terfc) * terfc))) * tmp);
              if ((xerfc >  0.0)) begin
                erfctimesexpmtat = erfcpos;
              end
              else begin
                if ((mtat > -230.258509299405)) begin
                  tmp = exp(mtat);
                end
                else begin
                  tmp = ( 100.0e-102 / (((-230.258509299405 - mtat) * ((((-230.258509299405 - mtat) * (((-230.258509299405 - mtat) *  0.333333333333333) +  1.0)) *  0.5) +  1.0)) +  1.0));
                end
                erfctimesexpmtat = ((tmp *  2.0) - erfcpos);
              end
              gammamax = (((__atatsti_d * erfctimesexpmtat) / ktat) *  0.886226925452758);
              itat = (__CTATSTID_i * ((asrh * gammamax) * wtat));
            end
            if ((__CBBTSTID_i ==  0.0)) begin
              ibbt =  0.0;
            end
            else begin
              if ((__PSTID_i ==  0.5)) begin
                tmp = sqrt(((__VBIRSTID_i - vbbt) * __VBIRSTIinv_d));
              end
              else begin
                tmp = pow(((__VBIRSTID_i - vbbt) * __VBIRSTIinv_d), __PSTID_i);
              end
              Fmaxr = (__one_over_one_minus_PSTI_d * (((__VBIRSTID_i - vbbt) * __wdepnulrinvsti_d) / tmp));
              if ((abs(((- __fbbtsti_d) / Fmaxr)) <  230.258509299405)) begin
                tmp = exp(((- __fbbtsti_d) / Fmaxr));
              end
              else begin
                if ((((- __fbbtsti_d) / Fmaxr) <  0.0)) begin
                  tmp = ( 100.0e-102 / (((-230.258509299405 - ((- __fbbtsti_d) / Fmaxr)) * ((((-230.258509299405 - ((- __fbbtsti_d) / Fmaxr)) * (((-230.258509299405 - ((- __fbbtsti_d) / Fmaxr)) *  0.333333333333333) +  1.0)) *  0.5) +  1.0)) +  1.0));
                end
                else begin
                  tmp = ((((((- __fbbtsti_d) / Fmaxr) -  230.258509299405) * ((((((- __fbbtsti_d) / Fmaxr) -  230.258509299405) * (((((- __fbbtsti_d) / Fmaxr) -  230.258509299405) *  0.333333333333333) +  1.0)) *  0.5) +  1.0)) +  1.0) *  10.0e+99);
                end
              end
              ibbt = (__CBBTSTID_i * (((__V4 * Fmaxr) * Fmaxr) * tmp));
            end
            if ((__VBRSTID_i >  1.0e+3)) begin
              fbreakdown =  1.0;
            end
            else begin
              if ((vav > ((- __alphaav) * __VBRSTID_i))) begin
                if ((__PBRSTID_i ==  4.0)) begin
                  tmp = ((((vav * __VBRinvsti_d) * (vav * __VBRinvsti_d)) * (vav * __VBRinvsti_d)) * (vav * __VBRinvsti_d));
                end
                else begin
                  tmp = pow(abs((vav * __VBRinvsti_d)), __PBRSTID_i);
                end
                fbreakdown = ( 1.0 / ( 1.0 - tmp));
              end
              else begin
                fbreakdown = (__fstopsti_d + ((vav + (__alphaav * __VBRSTID_i)) * __slopesti_d));
              end
            end
            ijunsti = ((((id + isrh) + itat) + ibbt) * fbreakdown);
          end
          if ((__LGDRAIN_i ==  0.0)) begin
            ijungat =  0.0;
            qjungat =  0.0;
          end
          else begin
            if ((__one_minus_PGAT_d ==  0.5)) begin
              tmp = sqrt(( 1.0 - (vj * __vbiinvgat_d)));
            end
            else begin
              tmp = pow(( 1.0 - (vj * __vbiinvgat_d)), __one_minus_PGAT_d);
            end
            qjungat = ((__qprefgat_d * ( 1.0 - tmp)) + (__qpref2gat_d * (__V4 - vj)));
            id = (__idsatgat_d * idmult);
            if (((__CSRHGATD_i ==  0.0) && (__CTATGATD_i ==  0.0))) begin
              isrh =  0.0;
            end
            else begin
              vbi_minus_vjsrh = (__vbigat_d - vjsrh);
              wsrhstep = ( 1.0 - sqrt(( 1.0 - (two_psistar / vbi_minus_vjsrh))));
              if ((__PGATD_i ==  0.5)) begin
                dwsrh =  0.0;
              end
              else begin
                dwsrh = (((((wsrhstep * wsrhstep) * ln(wsrhstep)) / ( 1.0 - wsrhstep)) + wsrhstep) * ( 1.0 - (__PGATD_i *  2.0)));
              end
              wsrh = (wsrhstep + dwsrh);
              if ((__PGATD_i ==  0.5)) begin
                tmp = sqrt((vbi_minus_vjsrh * __VBIRGATinv_d));
              end
              else begin
                tmp = pow((vbi_minus_vjsrh * __VBIRGATinv_d), __PGATD_i);
              end
              wdep = (__wdepnulrgat_d * tmp);
              asrh = (__ftdgat_d * ((zinv -  1.0) * wdep));
              isrh = (__CSRHGATD_i * (asrh * wsrh));
            end
            if ((__CTATGATD_i ==  0.0)) begin
              itat =  0.0;
            end
            else begin
              btat = (__btatpartgat_d * ((wdep * __one_minus_PGAT_d) / vbi_minus_vjsrh));
              twoatatoverthreebtat = ((__atatgat_d *  0.666666666666667) / btat);
              umaxbeforelimiting = (twoatatoverthreebtat * twoatatoverthreebtat);
              umax = sqrt(((umaxbeforelimiting * umaxbeforelimiting) / ((umaxbeforelimiting * umaxbeforelimiting) +  1.0)));
              sqrtumax = sqrt(umax);
              umaxpoweronepointfive = (umax * sqrtumax);
              if ((((- __PGATD_i) * __one_over_one_minus_PGAT_d) == -1.0)) begin
                wgamma = ( 1.0 / ((btat * umaxpoweronepointfive) +  1.0));
              end
              else begin
                wgamma = pow(((btat * umaxpoweronepointfive) +  1.0), ((- __PGATD_i) * __one_over_one_minus_PGAT_d));
              end
              wtat = ((wsrh * wgamma) / (wsrh + wgamma));
              ktat = sqrt(((btat / sqrtumax) *  0.375));
              ltat = (((twoatatoverthreebtat * sqrtumax) *  2.0) - umax);
              mtat = ((((__atatgat_d * twoatatoverthreebtat) * sqrtumax) - (__atatgat_d * umax)) + ((btat * umaxpoweronepointfive) *  0.5));
              xerfc = ((ltat -  1.0) * ktat);
              ysq = (xerfc * xerfc);
              if ((xerfc >  0.0)) begin
                terfc = ( 1.0 / ((__perfc * xerfc) +  1.0));
              end
              else begin
                terfc = ( 1.0 / ( 1.0 - (__perfc * xerfc)));
              end
              if ((((- ysq) + mtat) > -230.258509299405)) begin
                tmp = exp(((- ysq) + mtat));
              end
              else begin
                tmp = ( 100.0e-102 / (((-230.258509299405 - ((- ysq) + mtat)) * ((((-230.258509299405 - ((- ysq) + mtat)) * (((-230.258509299405 - ((- ysq) + mtat)) *  0.333333333333333) +  1.0)) *  0.5) +  1.0)) +  1.0));
              end
              erfcpos = ((((terfc *  0.29214664) + (__berfc * (terfc * terfc))) + (__cerfc * ((terfc * terfc) * terfc))) * tmp);
              if ((xerfc >  0.0)) begin
                erfctimesexpmtat = erfcpos;
              end
              else begin
                if ((mtat > -230.258509299405)) begin
                  tmp = exp(mtat);
                end
                else begin
                  tmp = ( 100.0e-102 / (((-230.258509299405 - mtat) * ((((-230.258509299405 - mtat) * (((-230.258509299405 - mtat) *  0.333333333333333) +  1.0)) *  0.5) +  1.0)) +  1.0));
                end
                erfctimesexpmtat = ((tmp *  2.0) - erfcpos);
              end
              gammamax = (((__atatgat_d * erfctimesexpmtat) / ktat) *  0.886226925452758);
              itat = (__CTATGATD_i * ((asrh * gammamax) * wtat));
            end
            if ((__CBBTGATD_i ==  0.0)) begin
              ibbt =  0.0;
            end
            else begin
              if ((__PGATD_i ==  0.5)) begin
                tmp = sqrt(((__VBIRGATD_i - vbbt) * __VBIRGATinv_d));
              end
              else begin
                tmp = pow(((__VBIRGATD_i - vbbt) * __VBIRGATinv_d), __PGATD_i);
              end
              Fmaxr = (__one_over_one_minus_PGAT_d * (((__VBIRGATD_i - vbbt) * __wdepnulrinvgat_d) / tmp));
              if ((abs(((- __fbbtgat_d) / Fmaxr)) <  230.258509299405)) begin
                tmp = exp(((- __fbbtgat_d) / Fmaxr));
              end
              else begin
                if ((((- __fbbtgat_d) / Fmaxr) <  0.0)) begin
                  tmp = ( 100.0e-102 / (((-230.258509299405 - ((- __fbbtgat_d) / Fmaxr)) * ((((-230.258509299405 - ((- __fbbtgat_d) / Fmaxr)) * (((-230.258509299405 - ((- __fbbtgat_d) / Fmaxr)) *  0.333333333333333) +  1.0)) *  0.5) +  1.0)) +  1.0));
                end
                else begin
                  tmp = ((((((- __fbbtgat_d) / Fmaxr) -  230.258509299405) * ((((((- __fbbtgat_d) / Fmaxr) -  230.258509299405) * (((((- __fbbtgat_d) / Fmaxr) -  230.258509299405) *  0.333333333333333) +  1.0)) *  0.5) +  1.0)) +  1.0) *  10.0e+99);
                end
              end
              ibbt = (__CBBTGATD_i * (((__V4 * Fmaxr) * Fmaxr) * tmp));
            end
            if ((__VBRGATD_i >  1.0e+3)) begin
              fbreakdown =  1.0;
            end
            else begin
              if ((vav > ((- __alphaav) * __VBRGATD_i))) begin
                if ((__PBRGATD_i ==  4.0)) begin
                  tmp = ((((vav * __VBRinvgat_d) * (vav * __VBRinvgat_d)) * (vav * __VBRinvgat_d)) * (vav * __VBRinvgat_d));
                end
                else begin
                  tmp = pow(abs((vav * __VBRinvgat_d)), __PBRGATD_i);
                end
                fbreakdown = ( 1.0 / ( 1.0 - tmp));
              end
              else begin
                fbreakdown = (__fstopgat_d + ((vav + (__alphaav * __VBRGATD_i)) * __slopegat_d));
              end
            end
            ijungat = ((((id + isrh) + itat) + ibbt) * fbreakdown);
          end
          __I4 = (((__ABDRAIN_i * ijunbot) + (__LSDRAIN_i * ijunsti)) + (__LGDRAIN_i * ijungat));
          vbbt =  0.0;
          two_psistar =  0.0;
          if ((! (((__ABDRAIN_i ==  0.0) && (__LSDRAIN_i ==  0.0)) && (__LGDRAIN_i ==  0.0)))) begin
            h1 = ((__vch_d *  4.0) * __vch_d);
            h2 = (__vch_d / __vfmin_d);
            h2d = (__V5 + (__vch_d * h2));
            h3 = (__vfmin_d + h2d);
            h4 = (__vfmin_d - h2d);
            h5 = sqrt(((h4 * h4) + h1));
            vj = (((__V5 * __vfmin_d) / (h3 + h5)) *  2.0);
            if ((__V5 < __VMAX_d)) begin
              if ((abs(((__V5 * __phitdinv) *  0.5)) <  230.258509299405)) begin
                zinv = exp(((__V5 * __phitdinv) *  0.5));
              end
              else begin
                if ((((__V5 * __phitdinv) *  0.5) <  0.0)) begin
                  zinv = ( 100.0e-102 / (((-230.258509299405 - ((__V5 * __phitdinv) *  0.5)) * ((((-230.258509299405 - ((__V5 * __phitdinv) *  0.5)) * (((-230.258509299405 - ((__V5 * __phitdinv) *  0.5)) *  0.333333333333333) +  1.0)) *  0.5) +  1.0)) +  1.0));
                end
                else begin
                  zinv = ((((((__V5 * __phitdinv) *  0.5) -  230.258509299405) * ((((((__V5 * __phitdinv) *  0.5) -  230.258509299405) * (((((__V5 * __phitdinv) *  0.5) -  230.258509299405) *  0.333333333333333) +  1.0)) *  0.5) +  1.0)) +  1.0) *  10.0e+99);
                end
              end
              idmult = (zinv * zinv);
            end
            else begin
              idmult = ((((__V5 - __VMAX_d) * __phitdinv) +  1.0) * __exp_VMAX_over_phitd_d);
              zinv = sqrt(idmult);
            end
            idmult = (idmult -  1.0);
            z = ( 1.0 / zinv);
            if ((__V5 >  0.0)) begin
              two_psistar = ((__phitd * ln(((z +  2.0) + sqrt(((z +  1.0) * (z +  3.0)))))) *  2.0);
            end
            else begin
              two_psistar = ((- __V5) + ((__phitd * ln((((zinv *  2.0) +  1.0) + sqrt(((zinv +  1.0) * ((zinv *  3.0) +  1.0)))))) *  2.0));
            end
            vjlim = (__vbimin_d - two_psistar);
            vjsrh = (((__V5 + vjlim) - sqrt((((__V5 - vjlim) * (__V5 - vjlim)) + ((__phitd *  4.0) * __phitd)))) *  0.5);
            vbbt = (((__V5 + __vbbtlim_d) - sqrt((((__V5 - __vbbtlim_d) * (__V5 - __vbbtlim_d)) + ((__phitr *  4.0) * __phitr)))) *  0.5);
            vav = ((__V5 - sqrt(((__V5 * __V5) +  4.0e-12))) *  0.5);
          end
          if ((__ABDRAIN_i ==  0.0)) begin
            ijunbot =  0.0;
            qjunbot =  0.0;
          end
          else begin
            if ((__one_minus_PBOT_d ==  0.5)) begin
              tmp = sqrt(( 1.0 - (vj * __vbiinvbot_d)));
            end
            else begin
              tmp = pow(( 1.0 - (vj * __vbiinvbot_d)), __one_minus_PBOT_d);
            end
            qjunbot = ((__qprefbot_d * ( 1.0 - tmp)) + (__qpref2bot_d * (__V5 - vj)));
            id = (__idsatbot_d * idmult);
            if (((__CSRHBOTD_i ==  0.0) && (__CTATBOTD_i ==  0.0))) begin
              isrh =  0.0;
            end
            else begin
              vbi_minus_vjsrh = (__vbibot_d - vjsrh);
              wsrhstep = ( 1.0 - sqrt(( 1.0 - (two_psistar / vbi_minus_vjsrh))));
              if ((__PBOTD_i ==  0.5)) begin
                dwsrh =  0.0;
              end
              else begin
                dwsrh = (((((wsrhstep * wsrhstep) * ln(wsrhstep)) / ( 1.0 - wsrhstep)) + wsrhstep) * ( 1.0 - (__PBOTD_i *  2.0)));
              end
              wsrh = (wsrhstep + dwsrh);
              if ((__PBOTD_i ==  0.5)) begin
                tmp = sqrt((vbi_minus_vjsrh * __VBIRBOTinv_d));
              end
              else begin
                tmp = pow((vbi_minus_vjsrh * __VBIRBOTinv_d), __PBOTD_i);
              end
              wdep = (__wdepnulrbot_d * tmp);
              asrh = (__ftdbot_d * ((zinv -  1.0) * wdep));
              isrh = (__CSRHBOTD_i * (asrh * wsrh));
            end
            if ((__CTATBOTD_i ==  0.0)) begin
              itat =  0.0;
            end
            else begin
              btat = (__btatpartbot_d * ((wdep * __one_minus_PBOT_d) / vbi_minus_vjsrh));
              twoatatoverthreebtat = ((__atatbot_d *  0.666666666666667) / btat);
              umaxbeforelimiting = (twoatatoverthreebtat * twoatatoverthreebtat);
              umax = sqrt(((umaxbeforelimiting * umaxbeforelimiting) / ((umaxbeforelimiting * umaxbeforelimiting) +  1.0)));
              sqrtumax = sqrt(umax);
              umaxpoweronepointfive = (umax * sqrtumax);
              if ((((- __PBOTD_i) * __one_over_one_minus_PBOT_d) == -1.0)) begin
                wgamma = ( 1.0 / ((btat * umaxpoweronepointfive) +  1.0));
              end
              else begin
                wgamma = pow(((btat * umaxpoweronepointfive) +  1.0), ((- __PBOTD_i) * __one_over_one_minus_PBOT_d));
              end
              wtat = ((wsrh * wgamma) / (wsrh + wgamma));
              ktat = sqrt(((btat / sqrtumax) *  0.375));
              ltat = (((twoatatoverthreebtat * sqrtumax) *  2.0) - umax);
              mtat = ((((__atatbot_d * twoatatoverthreebtat) * sqrtumax) - (__atatbot_d * umax)) + ((btat * umaxpoweronepointfive) *  0.5));
              xerfc = ((ltat -  1.0) * ktat);
              ysq = (xerfc * xerfc);
              if ((xerfc >  0.0)) begin
                terfc = ( 1.0 / ((__perfc * xerfc) +  1.0));
              end
              else begin
                terfc = ( 1.0 / ( 1.0 - (__perfc * xerfc)));
              end
              if ((((- ysq) + mtat) > -230.258509299405)) begin
                tmp = exp(((- ysq) + mtat));
              end
              else begin
                tmp = ( 100.0e-102 / (((-230.258509299405 - ((- ysq) + mtat)) * ((((-230.258509299405 - ((- ysq) + mtat)) * (((-230.258509299405 - ((- ysq) + mtat)) *  0.333333333333333) +  1.0)) *  0.5) +  1.0)) +  1.0));
              end
              erfcpos = ((((terfc *  0.29214664) + (__berfc * (terfc * terfc))) + (__cerfc * ((terfc * terfc) * terfc))) * tmp);
              if ((xerfc >  0.0)) begin
                erfctimesexpmtat = erfcpos;
              end
              else begin
                if ((mtat > -230.258509299405)) begin
                  tmp = exp(mtat);
                end
                else begin
                  tmp = ( 100.0e-102 / (((-230.258509299405 - mtat) * ((((-230.258509299405 - mtat) * (((-230.258509299405 - mtat) *  0.333333333333333) +  1.0)) *  0.5) +  1.0)) +  1.0));
                end
                erfctimesexpmtat = ((tmp *  2.0) - erfcpos);
              end
              gammamax = (((__atatbot_d * erfctimesexpmtat) / ktat) *  0.886226925452758);
              itat = (__CTATBOTD_i * ((asrh * gammamax) * wtat));
            end
            if ((__CBBTBOTD_i ==  0.0)) begin
              ibbt =  0.0;
            end
            else begin
              if ((__PBOTD_i ==  0.5)) begin
                tmp = sqrt(((__VBIRBOTD_i - vbbt) * __VBIRBOTinv_d));
              end
              else begin
                tmp = pow(((__VBIRBOTD_i - vbbt) * __VBIRBOTinv_d), __PBOTD_i);
              end
              Fmaxr = (__one_over_one_minus_PBOT_d * (((__VBIRBOTD_i - vbbt) * __wdepnulrinvbot_d) / tmp));
              if ((abs(((- __fbbtbot_d) / Fmaxr)) <  230.258509299405)) begin
                tmp = exp(((- __fbbtbot_d) / Fmaxr));
              end
              else begin
                if ((((- __fbbtbot_d) / Fmaxr) <  0.0)) begin
                  tmp = ( 100.0e-102 / (((-230.258509299405 - ((- __fbbtbot_d) / Fmaxr)) * ((((-230.258509299405 - ((- __fbbtbot_d) / Fmaxr)) * (((-230.258509299405 - ((- __fbbtbot_d) / Fmaxr)) *  0.333333333333333) +  1.0)) *  0.5) +  1.0)) +  1.0));
                end
                else begin
                  tmp = ((((((- __fbbtbot_d) / Fmaxr) -  230.258509299405) * ((((((- __fbbtbot_d) / Fmaxr) -  230.258509299405) * (((((- __fbbtbot_d) / Fmaxr) -  230.258509299405) *  0.333333333333333) +  1.0)) *  0.5) +  1.0)) +  1.0) *  10.0e+99);
                end
              end
              ibbt = (__CBBTBOTD_i * (((__V5 * Fmaxr) * Fmaxr) * tmp));
            end
            if ((__VBRBOTD_i >  1.0e+3)) begin
              fbreakdown =  1.0;
            end
            else begin
              if ((vav > ((- __alphaav) * __VBRBOTD_i))) begin
                if ((__PBRBOTD_i ==  4.0)) begin
                  tmp = ((((vav * __VBRinvbot_d) * (vav * __VBRinvbot_d)) * (vav * __VBRinvbot_d)) * (vav * __VBRinvbot_d));
                end
                else begin
                  tmp = pow(abs((vav * __VBRinvbot_d)), __PBRBOTD_i);
                end
                fbreakdown = ( 1.0 / ( 1.0 - tmp));
              end
              else begin
                fbreakdown = (__fstopbot_d + ((vav + (__alphaav * __VBRBOTD_i)) * __slopebot_d));
              end
            end
            ijunbot = ((((id + isrh) + itat) + ibbt) * fbreakdown);
          end
          if ((__LSDRAIN_i ==  0.0)) begin
            ijunsti =  0.0;
            qjunsti =  0.0;
          end
          else begin
            if ((__one_minus_PSTI_d ==  0.5)) begin
              tmp = sqrt(( 1.0 - (vj * __vbiinvsti_d)));
            end
            else begin
              tmp = pow(( 1.0 - (vj * __vbiinvsti_d)), __one_minus_PSTI_d);
            end
            qjunsti = ((__qprefsti_d * ( 1.0 - tmp)) + (__qpref2sti_d * (__V5 - vj)));
            id = (__idsatsti_d * idmult);
            if (((__CSRHSTID_i ==  0.0) && (__CTATSTID_i ==  0.0))) begin
              isrh =  0.0;
            end
            else begin
              vbi_minus_vjsrh = (__vbisti_d - vjsrh);
              wsrhstep = ( 1.0 - sqrt(( 1.0 - (two_psistar / vbi_minus_vjsrh))));
              if ((__PSTID_i ==  0.5)) begin
                dwsrh =  0.0;
              end
              else begin
                dwsrh = (((((wsrhstep * wsrhstep) * ln(wsrhstep)) / ( 1.0 - wsrhstep)) + wsrhstep) * ( 1.0 - (__PSTID_i *  2.0)));
              end
              wsrh = (wsrhstep + dwsrh);
              if ((__PSTID_i ==  0.5)) begin
                tmp = sqrt((vbi_minus_vjsrh * __VBIRSTIinv_d));
              end
              else begin
                tmp = pow((vbi_minus_vjsrh * __VBIRSTIinv_d), __PSTID_i);
              end
              wdep = (__wdepnulrsti_d * tmp);
              asrh = (__ftdsti_d * ((zinv -  1.0) * wdep));
              isrh = (__CSRHSTID_i * (asrh * wsrh));
            end
            if ((__CTATSTID_i ==  0.0)) begin
              itat =  0.0;
            end
            else begin
              btat = (__btatpartsti_d * ((wdep * __one_minus_PSTI_d) / vbi_minus_vjsrh));
              twoatatoverthreebtat = ((__atatsti_d *  0.666666666666667) / btat);
              umaxbeforelimiting = (twoatatoverthreebtat * twoatatoverthreebtat);
              umax = sqrt(((umaxbeforelimiting * umaxbeforelimiting) / ((umaxbeforelimiting * umaxbeforelimiting) +  1.0)));
              sqrtumax = sqrt(umax);
              umaxpoweronepointfive = (umax * sqrtumax);
              if ((((- __PSTID_i) * __one_over_one_minus_PSTI_d) == -1.0)) begin
                wgamma = ( 1.0 / ((btat * umaxpoweronepointfive) +  1.0));
              end
              else begin
                wgamma = pow(((btat * umaxpoweronepointfive) +  1.0), ((- __PSTID_i) * __one_over_one_minus_PSTI_d));
              end
              wtat = ((wsrh * wgamma) / (wsrh + wgamma));
              ktat = sqrt(((btat / sqrtumax) *  0.375));
              ltat = (((twoatatoverthreebtat * sqrtumax) *  2.0) - umax);
              mtat = ((((__atatsti_d * twoatatoverthreebtat) * sqrtumax) - (__atatsti_d * umax)) + ((btat * umaxpoweronepointfive) *  0.5));
              xerfc = ((ltat -  1.0) * ktat);
              ysq = (xerfc * xerfc);
              if ((xerfc >  0.0)) begin
                terfc = ( 1.0 / ((__perfc * xerfc) +  1.0));
              end
              else begin
                terfc = ( 1.0 / ( 1.0 - (__perfc * xerfc)));
              end
              if ((((- ysq) + mtat) > -230.258509299405)) begin
                tmp = exp(((- ysq) + mtat));
              end
              else begin
                tmp = ( 100.0e-102 / (((-230.258509299405 - ((- ysq) + mtat)) * ((((-230.258509299405 - ((- ysq) + mtat)) * (((-230.258509299405 - ((- ysq) + mtat)) *  0.333333333333333) +  1.0)) *  0.5) +  1.0)) +  1.0));
              end
              erfcpos = ((((terfc *  0.29214664) + (__berfc * (terfc * terfc))) + (__cerfc * ((terfc * terfc) * terfc))) * tmp);
              if ((xerfc >  0.0)) begin
                erfctimesexpmtat = erfcpos;
              end
              else begin
                if ((mtat > -230.258509299405)) begin
                  tmp = exp(mtat);
                end
                else begin
                  tmp = ( 100.0e-102 / (((-230.258509299405 - mtat) * ((((-230.258509299405 - mtat) * (((-230.258509299405 - mtat) *  0.333333333333333) +  1.0)) *  0.5) +  1.0)) +  1.0));
                end
                erfctimesexpmtat = ((tmp *  2.0) - erfcpos);
              end
              gammamax = (((__atatsti_d * erfctimesexpmtat) / ktat) *  0.886226925452758);
              itat = (__CTATSTID_i * ((asrh * gammamax) * wtat));
            end
            if ((__CBBTSTID_i ==  0.0)) begin
              ibbt =  0.0;
            end
            else begin
              if ((__PSTID_i ==  0.5)) begin
                tmp = sqrt(((__VBIRSTID_i - vbbt) * __VBIRSTIinv_d));
              end
              else begin
                tmp = pow(((__VBIRSTID_i - vbbt) * __VBIRSTIinv_d), __PSTID_i);
              end
              Fmaxr = (__one_over_one_minus_PSTI_d * (((__VBIRSTID_i - vbbt) * __wdepnulrinvsti_d) / tmp));
              if ((abs(((- __fbbtsti_d) / Fmaxr)) <  230.258509299405)) begin
                tmp = exp(((- __fbbtsti_d) / Fmaxr));
              end
              else begin
                if ((((- __fbbtsti_d) / Fmaxr) <  0.0)) begin
                  tmp = ( 100.0e-102 / (((-230.258509299405 - ((- __fbbtsti_d) / Fmaxr)) * ((((-230.258509299405 - ((- __fbbtsti_d) / Fmaxr)) * (((-230.258509299405 - ((- __fbbtsti_d) / Fmaxr)) *  0.333333333333333) +  1.0)) *  0.5) +  1.0)) +  1.0));
                end
                else begin
                  tmp = ((((((- __fbbtsti_d) / Fmaxr) -  230.258509299405) * ((((((- __fbbtsti_d) / Fmaxr) -  230.258509299405) * (((((- __fbbtsti_d) / Fmaxr) -  230.258509299405) *  0.333333333333333) +  1.0)) *  0.5) +  1.0)) +  1.0) *  10.0e+99);
                end
              end
              ibbt = (__CBBTSTID_i * (((__V5 * Fmaxr) * Fmaxr) * tmp));
            end
            if ((__VBRSTID_i >  1.0e+3)) begin
              fbreakdown =  1.0;
            end
            else begin
              if ((vav > ((- __alphaav) * __VBRSTID_i))) begin
                if ((__PBRSTID_i ==  4.0)) begin
                  tmp = ((((vav * __VBRinvsti_d) * (vav * __VBRinvsti_d)) * (vav * __VBRinvsti_d)) * (vav * __VBRinvsti_d));
                end
                else begin
                  tmp = pow(abs((vav * __VBRinvsti_d)), __PBRSTID_i);
                end
                fbreakdown = ( 1.0 / ( 1.0 - tmp));
              end
              else begin
                fbreakdown = (__fstopsti_d + ((vav + (__alphaav * __VBRSTID_i)) * __slopesti_d));
              end
            end
            ijunsti = ((((id + isrh) + itat) + ibbt) * fbreakdown);
          end
          if ((__LGDRAIN_i ==  0.0)) begin
            ijungat =  0.0;
            qjungat =  0.0;
          end
          else begin
            if ((__one_minus_PGAT_d ==  0.5)) begin
              tmp = sqrt(( 1.0 - (vj * __vbiinvgat_d)));
            end
            else begin
              tmp = pow(( 1.0 - (vj * __vbiinvgat_d)), __one_minus_PGAT_d);
            end
            qjungat = ((__qprefgat_d * ( 1.0 - tmp)) + (__qpref2gat_d * (__V5 - vj)));
            id = (__idsatgat_d * idmult);
            if (((__CSRHGATD_i ==  0.0) && (__CTATGATD_i ==  0.0))) begin
              isrh =  0.0;
            end
            else begin
              vbi_minus_vjsrh = (__vbigat_d - vjsrh);
              wsrhstep = ( 1.0 - sqrt(( 1.0 - (two_psistar / vbi_minus_vjsrh))));
              if ((__PGATD_i ==  0.5)) begin
                dwsrh =  0.0;
              end
              else begin
                dwsrh = (((((wsrhstep * wsrhstep) * ln(wsrhstep)) / ( 1.0 - wsrhstep)) + wsrhstep) * ( 1.0 - (__PGATD_i *  2.0)));
              end
              wsrh = (wsrhstep + dwsrh);
              if ((__PGATD_i ==  0.5)) begin
                tmp = sqrt((vbi_minus_vjsrh * __VBIRGATinv_d));
              end
              else begin
                tmp = pow((vbi_minus_vjsrh * __VBIRGATinv_d), __PGATD_i);
              end
              wdep = (__wdepnulrgat_d * tmp);
              asrh = (__ftdgat_d * ((zinv -  1.0) * wdep));
              isrh = (__CSRHGATD_i * (asrh * wsrh));
            end
            if ((__CTATGATD_i ==  0.0)) begin
              itat =  0.0;
            end
            else begin
              btat = (__btatpartgat_d * ((wdep * __one_minus_PGAT_d) / vbi_minus_vjsrh));
              twoatatoverthreebtat = ((__atatgat_d *  0.666666666666667) / btat);
              umaxbeforelimiting = (twoatatoverthreebtat * twoatatoverthreebtat);
              umax = sqrt(((umaxbeforelimiting * umaxbeforelimiting) / ((umaxbeforelimiting * umaxbeforelimiting) +  1.0)));
              sqrtumax = sqrt(umax);
              umaxpoweronepointfive = (umax * sqrtumax);
              if ((((- __PGATD_i) * __one_over_one_minus_PGAT_d) == -1.0)) begin
                wgamma = ( 1.0 / ((btat * umaxpoweronepointfive) +  1.0));
              end
              else begin
                wgamma = pow(((btat * umaxpoweronepointfive) +  1.0), ((- __PGATD_i) * __one_over_one_minus_PGAT_d));
              end
              wtat = ((wsrh * wgamma) / (wsrh + wgamma));
              ktat = sqrt(((btat / sqrtumax) *  0.375));
              ltat = (((twoatatoverthreebtat * sqrtumax) *  2.0) - umax);
              mtat = ((((__atatgat_d * twoatatoverthreebtat) * sqrtumax) - (__atatgat_d * umax)) + ((btat * umaxpoweronepointfive) *  0.5));
              xerfc = ((ltat -  1.0) * ktat);
              ysq = (xerfc * xerfc);
              if ((xerfc >  0.0)) begin
                terfc = ( 1.0 / ((__perfc * xerfc) +  1.0));
              end
              else begin
                terfc = ( 1.0 / ( 1.0 - (__perfc * xerfc)));
              end
              if ((((- ysq) + mtat) > -230.258509299405)) begin
                tmp = exp(((- ysq) + mtat));
              end
              else begin
                tmp = ( 100.0e-102 / (((-230.258509299405 - ((- ysq) + mtat)) * ((((-230.258509299405 - ((- ysq) + mtat)) * (((-230.258509299405 - ((- ysq) + mtat)) *  0.333333333333333) +  1.0)) *  0.5) +  1.0)) +  1.0));
              end
              erfcpos = ((((terfc *  0.29214664) + (__berfc * (terfc * terfc))) + (__cerfc * ((terfc * terfc) * terfc))) * tmp);
              if ((xerfc >  0.0)) begin
                erfctimesexpmtat = erfcpos;
              end
              else begin
                if ((mtat > -230.258509299405)) begin
                  tmp = exp(mtat);
                end
                else begin
                  tmp = ( 100.0e-102 / (((-230.258509299405 - mtat) * ((((-230.258509299405 - mtat) * (((-230.258509299405 - mtat) *  0.333333333333333) +  1.0)) *  0.5) +  1.0)) +  1.0));
                end
                erfctimesexpmtat = ((tmp *  2.0) - erfcpos);
              end
              gammamax = (((__atatgat_d * erfctimesexpmtat) / ktat) *  0.886226925452758);
              itat = (__CTATGATD_i * ((asrh * gammamax) * wtat));
            end
            if ((__CBBTGATD_i ==  0.0)) begin
              ibbt =  0.0;
            end
            else begin
              if ((__PGATD_i ==  0.5)) begin
                tmp = sqrt(((__VBIRGATD_i - vbbt) * __VBIRGATinv_d));
              end
              else begin
                tmp = pow(((__VBIRGATD_i - vbbt) * __VBIRGATinv_d), __PGATD_i);
              end
              Fmaxr = (__one_over_one_minus_PGAT_d * (((__VBIRGATD_i - vbbt) * __wdepnulrinvgat_d) / tmp));
              if ((abs(((- __fbbtgat_d) / Fmaxr)) <  230.258509299405)) begin
                tmp = exp(((- __fbbtgat_d) / Fmaxr));
              end
              else begin
                if ((((- __fbbtgat_d) / Fmaxr) <  0.0)) begin
                  tmp = ( 100.0e-102 / (((-230.258509299405 - ((- __fbbtgat_d) / Fmaxr)) * ((((-230.258509299405 - ((- __fbbtgat_d) / Fmaxr)) * (((-230.258509299405 - ((- __fbbtgat_d) / Fmaxr)) *  0.333333333333333) +  1.0)) *  0.5) +  1.0)) +  1.0));
                end
                else begin
                  tmp = ((((((- __fbbtgat_d) / Fmaxr) -  230.258509299405) * ((((((- __fbbtgat_d) / Fmaxr) -  230.258509299405) * (((((- __fbbtgat_d) / Fmaxr) -  230.258509299405) *  0.333333333333333) +  1.0)) *  0.5) +  1.0)) +  1.0) *  10.0e+99);
                end
              end
              ibbt = (__CBBTGATD_i * (((__V5 * Fmaxr) * Fmaxr) * tmp));
            end
            if ((__VBRGATD_i >  1.0e+3)) begin
              fbreakdown =  1.0;
            end
            else begin
              if ((vav > ((- __alphaav) * __VBRGATD_i))) begin
                if ((__PBRGATD_i ==  4.0)) begin
                  tmp = ((((vav * __VBRinvgat_d) * (vav * __VBRinvgat_d)) * (vav * __VBRinvgat_d)) * (vav * __VBRinvgat_d));
                end
                else begin
                  tmp = pow(abs((vav * __VBRinvgat_d)), __PBRGATD_i);
                end
                fbreakdown = ( 1.0 / ( 1.0 - tmp));
              end
              else begin
                fbreakdown = (__fstopgat_d + ((vav + (__alphaav * __VBRGATD_i)) * __slopegat_d));
              end
            end
            ijungat = ((((id + isrh) + itat) + ibbt) * fbreakdown);
          end
          __I5 = (((__ABDRAIN_i * ijunbot) + (__LSDRAIN_i * ijunsti)) + (__LGDRAIN_i * ijungat));
          __ISATFOR1_d = (((__ABDRAIN_i * __idsatbot_d) + (__LSDRAIN_i * __idsatsti_d)) + (__LGDRAIN_i * __idsatgat_d));
          __I4_cor = (__I4 - (__ISATFOR1_d * (exp(((__V4 * __phitdinv) * __MFOR1_d)) -  1.0)));
          __I5_cor = (__I5 - (__ISATFOR1_d * (exp(((__V5 * __phitdinv) * __MFOR1_d)) -  1.0)));
          if ((! (((__ABDRAIN_i ==  0.0) && (__LSDRAIN_i ==  0.0)) && (__LGDRAIN_i ==  0.0)))) begin
            if (((__I4 >  0.0) && (__I5 >  0.0))) begin
              if (((((((__I4_cor / __I4) >  0.001) || ((__I5_cor / __I5) >  0.001)) && (__I4_cor >  0.0)) && (__I5_cor >  0.0)) && (__I5_cor > __I4_cor))) begin
                __alphaje = (__I4_cor / __I5_cor);
                __MFOR2_d = ((__phitd * ln(__alphaje)) / (__V4 - __V5));
                __ISATFOR2_d = (__I4_cor / (exp(((__V4 * __phitdinv) * __MFOR2_d)) -  1.0));
              end
            end
            __I1_cor = ((__I1 - (__ISATFOR1_d * (exp(((__V1 * __phitdinv) * __MFOR1_d)) -  1.0))) - (__ISATFOR2_d * (exp(((__V1 * __phitdinv) * __MFOR2_d)) -  1.0)));
            __I2_cor = ((__I2 - (__ISATFOR1_d * (exp(((__V2 * __phitdinv) * __MFOR1_d)) -  1.0))) - (__ISATFOR2_d * (exp(((__V2 * __phitdinv) * __MFOR2_d)) -  1.0)));
            __I3_cor = ((__I3 - (__ISATFOR1_d * (exp(((__V3 * __phitdinv) * __MFOR1_d)) -  1.0))) - (__ISATFOR2_d * (exp(((__V3 * __phitdinv) * __MFOR2_d)) -  1.0)));
            if ((((__I1 <  0.0) && (__I2 <  0.0)) && (__I3 <  0.0))) begin
              if ((((((((__I1_cor / __I1) >  0.001) || ((__I2_cor / __I2) >  0.001)) || ((__I3_cor / __I3) >  0.001)) && (__I1_cor <  0.0)) && (__I2_cor <  0.0)) && (__I3_cor <  0.0))) begin
                __alphaje = (__I1_cor / __I2_cor);
                __m0_rev = (((- __phitd) * ln(__alphaje)) / (__V1 - __V2));
                __tt0 = (__V2 / (__V2 - __V1));
                __tt1 = ((__phitd * (__alphaje -  1.0)) * (pow(__alphaje, __tt0) -  1.0));
                __tt0 = (__V1 / (__V1 - __V2));
                __tt2 = (((pow(__alphaje, __tt0) * (__V2 - __V1)) + (__alphaje * __V1)) - __V2);
                __mcor_rev = (__tt1 / __tt2);
                __MREV_d = (__m0_rev + __mcor_rev);
                if ((abs(((__V3 * __phitdinv) * __MREV_d)) <  1.0e-6)) begin
                  __m0flag_d =  1.0;
                  __ISATREV_d = (__I3_cor * (( 1.0 / __V3) + ((__phitdinv *  0.5) * __MREV_d)));
                  __MREV_d = ((((__I3_cor * -0.5) * __MREV_d) * __phitdinv) / __V3);
                end
                else begin
                  __m0flag_d =  0.0;
                  __ISATREV_d = ((- __I3_cor) / (exp((((- __V3) * __phitdinv) * __MREV_d)) -  1.0));
                end
              end
            end
          end
          __zfrac = (__FJUNQD_i * (((__ABDRAIN_i * __cjobot_d) + (__LSDRAIN_i * __cjosti_d)) + (__LGDRAIN_i * __cjogat_d)));
          if (((__ABDRAIN_i * __cjobot_d) <= __zfrac)) begin
            __zflagbot_d =  0.0;
          end
          if (((__LSDRAIN_i * __cjosti_d) <= __zfrac)) begin
            __zflagsti_d =  0.0;
          end
          if (((__LGDRAIN_i * __cjogat_d) <= __zfrac)) begin
            __zflaggat_d =  0.0;
          end
          if ((! (((__ABDRAIN_i ==  0.0) && (__LSDRAIN_i ==  0.0)) && (__LGDRAIN_i ==  0.0)))) begin
            __xhighf1_d = ln(( 827.55e-6 / (__ISATFOR1_d +  1.0e-21)));
            __xhighf2_d = ln(( 827.55e-6 / (__ISATFOR2_d +  1.0e-21)));
            __xhighr_d = ln(( 827.55e-6 / (abs(__ISATREV_d) +  1.0e-21)));
          end
          __xhighf1_d = min(__xhighf1_d,  230.258509299405);
          __expxhf1_d = exp(__xhighf1_d);
          __xhighf2_d = min(__xhighf2_d,  230.258509299405);
          __expxhf2_d = exp(__xhighf2_d);
          __xhighr_d = min(__xhighr_d,  230.258509299405);
          __expxhr_d = exp(__xhighr_d);
        end
      end
    end
    begin : evaluateblock
      real sigVds, dphit1, xgct, xsct0, xbct, xsbstar, xsct, dCTG, ct_fact, phit1, inv_phit1, Vgb1_dc, xg_dc, alpha_dc, dps_dc, qim_dc;
      real qim1_dc, H_dc, FdL_dc, Gvsatinv_dc, Ids, Iimpact, mavl, Igdov, Igsov, Igcd, Igcs, eta_p_ac, Gvsat_ac, Gmob_dL_ac, Vgsinr_ac;
      real Vsginr_ac, Vgdinr_ac, Vdginr_ac, H0, COX_qm, ijun_s, ijunbot_s, ijunsti_s, ijungat_s, ijun_d, ijunbot_d, ijunsti_d, ijungat_d;
      real qjun_s, qjunbot_s, qjunsti_s, qjungat_s, qjun_d, qjunbot_d, qjunsti_d, qjungat_d, jnoise_s, jnoise_d, Gmob_dc, xitsb_dc;
      real Vdse_dc, Vgsinr_dc, Vsginr_dc, Vgdinr_dc, Vdginr_dc, Vsbstaredge, Vsbxedge, dphit1edge, phit1edge, inv_phit1edge, Vdspedge;
      real delVgedge, xgedge, xbedge, dxthedge, xnedge_s, qseffedge, xnedge_d, qdseffedge, qdeffedge, qmeffedge, dsqredge, alphabmedge;
      real Idsedge, Sfledge, midedge, sqidedge;
      real temp, temp1, temp2;
      begin : evaluateStatic
        temp =  0.0;
        temp1 =  0.0;
        temp2 =  0.0;
        __QCLM =  0.0;
        __xs_ov =  0.0;
        __xd_ov =  0.0;
        __Vovs =  0.0;
        __Vovd =  0.0;
        Iimpact =  0.0;
        mavl =  0.0;
        __pd =  1.0;
        __ym =  0.0;
        if ((__CHNL_TYPE == 1)) begin
          __Vgs = V(GP, SI);
          __Vds = V(DI, SI);
          __Vsb = V(SI, BP);
          __Vjun_s = (- V(SI, BS));
          __Vjun_d = (- V(DI, BD));
        end
        else begin
          __Vgs = (- V(GP, SI));
          __Vds = (- V(DI, SI));
          __Vsb = (- V(SI, BP));
          __Vjun_s = V(SI, BS);
          __Vjun_d = V(DI, BD);
        end
        __Vgb = (__Vgs + __Vsb);
        __VgsPrime = __Vgs;
        __VsbPrime = __Vsb;
        __VdbPrime = (__Vds + __Vsb);
        __VgdPrime = (__Vgs - __Vds);
        __xgs_ov = ((- __VgsPrime) * __inv_phita);
        __xgd_ov = ((- __VgdPrime) * __inv_phita);
        __xgb_ov = ((- (__Vgb - __VFB_T)) * __inv_phita);
        if (0) begin
          if ((abs(__Vgs) >  1.6)) begin
            $strobe("%M: Vgs=%g has exceeded Vgs_max=%g", __Vgs,  1.6);
          end
          if ((abs(__VgdPrime) >  1.6)) begin
            $strobe("%M: Vgd=%g has exceeded Vgd_max=%g", __VgdPrime,  1.6);
          end
          if ((abs(__Vds) >  1.6)) begin
            $strobe("%M: Vds=%g has exceeded Vds_max=%g", __Vds,  1.6);
          end
          if ((abs((__Vgs + __Vsb)) >  1.6)) begin
            $strobe("%M: Vgb=%g has exceeded Vgb_max=%g", (__Vgs + __Vsb),  1.6);
          end
          if ((abs(__Vsb) >  1.6)) begin
            $strobe("%M: Vsb=%g has exceeded Vsb_max=%g", __Vsb,  1.6);
          end
          if ((abs(__VdbPrime) >  1.6)) begin
            $strobe("%M: Vdb=%g has exceeded Vdb_max=%g", __VdbPrime,  1.6);
          end
        end
        sigVds =  1.0;
        if ((__Vds <  0.0)) begin
          sigVds = -1.0;
          __Vgs = (__Vgs - __Vds);
          __Vsb = (__Vsb + __Vds);
          __Vds = (- __Vds);
        end
        __Vdb = (__Vds + __Vsb);
        __Vdsx = ((__Vds * __Vds) / (sqrt(((__Vds * __Vds) +  0.01)) +  0.1));
        begin : SPcalc_dc
          real phib, G_0, Vsbstar, cfloc, thesatloc, axloc, alploc;
          real Vsbx, xg, Dnsub, Gf, Gf2, inv_Gf2, xi, inv_xi, Ux, xn_s, delta_ns, margin, x_s, delta_1s, xi0s, xi1s;
          real xi2s, Es, Ds, Ps, Rxcor, xgs, qis, qbs, rhob, GR, Eeffm, Mutmp, Gmob, xitsb, wsat, thesat1, phi_inf;
          real ysat, za, Phi_0, asat, Phi_2, Phi_0_2, Phi0_Phi2, Phi_sat, Vdse, Udse, xn_d, k_ds, delta_nd, x_d, x_ds;
          real pC, qC, dps, xi0d, Ed, Dd, Pd, sqd, qbd, x_m, Em, D_bar, Dm, Pm, xgm, eta_p, sqm, alpha, d0, x_pm, p_pd;
          real q_pd, xi_pd, u_pd, km, km0, qim, qim1, qbm, qeff, qeff1, s1, dL, GdL, Gmob_dL, zsat, Gvsat, Gvsatinv;
          real Voxm, alpha1, H, Vgsinr, Vsginr, Vgdinr, Vdginr;
          real SP_S_temp, SP_S_temp1, SP_S_temp2;
          real SP_S_yg, SP_S_ysub, SP_S_eta, SP_S_a, SP_S_c, SP_S_tau, SP_S_y0, SP_S_delta0, SP_S_delta1, SP_S_xi0;
          real SP_S_xi1, SP_S_xi2, SP_S_pC, SP_S_qC, SP_xg1, SP_S_A_fac, SP_S_xbar, SP_S_w, SP_S_x1, SP_S_bx, SP_S_b;
          real SP_S_x0;
          real FdL, qim1_1, r1, r2, s2, dL1;
          temp = ((((__Vdb + __Vsb) - sqrt((((__Vdb - __Vsb) * (__Vdb - __Vsb)) + __bphi_dc))) *  0.5) + __phix_dc);
          __Vsbstar_dc = ((__Vsb - ((temp - sqrt(((temp * temp) + __aphi_dc))) *  0.5)) + __phix1_dc);
          __Vsbstar_dc_tmp = __Vsbstar_dc;
          if (0) begin
          end
          phib = __phib_dc;
          G_0 = __G_0_dc;
          Vsbstar = __Vsbstar_dc;
          cfloc = __CF_i;
          thesatloc = __THESAT_T;
          axloc = __AX_i;
          alploc = __ALP_i;
          FdL =  1.0;
          alpha =  0.0;
          GdL =  1.0;
          dL =  0.0;
          qbm =  0.0;
          dps =  0.0;
          qim =  0.0;
          qim1 =  0.0;
          H =  1.0;
          s1 =  0.0;
          eta_p =  1.0;
          Gvsat =  1.0;
          Gvsatinv =  1.0;
          SP_S_x1 =  0.0;
          x_s =  0.0;
          sqm =  0.0;
          xitsb =  0.0;
          rhob =  0.0;
          Gmob =  1.0;
          Gmob_dL =  1.0;
          Udse =  0.0;
          thesat1 =  0.0;
          Em =  0.0;
          Dm =  0.0;
          Pm =  0.0;
          xgm =  0.0;
          qbs =  0.0;
          qbd =  0.0;
          if (0) begin
          end
          else begin
            __Vgb1 = ((__Vgs + Vsbstar) - __VFB_T);
          end
          Vsbx = (Vsbstar + ((__Vds - __Vdsx) *  0.5));
          __Vdsp = ((__Vdsx *  2.0) / (sqrt(((__CFD_i * __Vdsx) +  1.0)) +  1.0));
          __delVg = ((cfloc * __Vdsp) * ((__CFB_i * Vsbx) +  1.0));
          dphit1 = ((__PSCE_i * ((__PSCED_i * __Vdsx) +  1.0)) * ((__PSCEB_i * Vsbx) +  1.0));
          __Vgb1 = (__Vgb1 + __delVg);
          if ((__DNSUB_i >  0.0)) begin
            Dnsub = ((__DNSUB_i *  0.5) * (((__Vgs + __Vsb) - __VNSUB_i) + sqrt(((( 0.0 - ((__Vgs + __Vsb) - __VNSUB_i)) * ( 0.0 - ((__Vgs + __Vsb) - __VNSUB_i))) + __NSLP_i))));
            Gf = (G_0 * sqrt((Dnsub +  1.0)));
          end
          else begin
            Gf = G_0;
          end
          Gf2 = (Gf * Gf);
          inv_Gf2 = ( 1.0 / Gf2);
          dCTG =  1.0;
          if ((__CTG_i >  0.0)) begin
            xgct = ((__Vgb1 *  2.0) * __inv_phit);
            temp1 = (Gf2 + xgct);
            temp2 = (((temp1 + xgct) + sqrt((((temp1 + xgct) * (temp1 + xgct)) +  5.0))) *  0.5);
            xsct0 = ((temp1 - (Gf * sqrt(temp2))) *  0.5);
            xbct = (phib * __inv_phit);
            xsbstar = (Vsbx * __inv_phit);
            temp1 = ((xbct + xsbstar) +  2.0);
            xsct = (((xsct0 + temp1) - sqrt((((xsct0 - temp1) * (xsct0 - temp1)) +  5.0))) *  0.5);
            temp2 = (__CTG_T * (xsct - ((__CTB_i +  1.0) * ((xbct *  0.5) + xsbstar))));
            if ((temp2 > -230.258509299405)) begin
              dCTG = exp(temp2);
            end
            else begin
              dCTG = ( 100.0e-102 / (((-230.258509299405 - temp2) * ((((-230.258509299405 - temp2) * (((-230.258509299405 - temp2) *  0.333333333333333) +  1.0)) *  0.5) +  1.0)) +  1.0));
            end
          end
          ct_fact = ((__CT_T * dCTG) +  1.0);
          phit1 = ((__phit * ct_fact) * (dphit1 +  1.0));
          inv_phit1 = ( 1.0 / phit1);
          xg = (__Vgb1 * inv_phit1);
          if (0) begin
          end
          xi = ((Gf *  0.707106781186547) +  1.0);
          inv_xi = ( 1.0 / xi);
          Ux = (Vsbstar * inv_phit1);
          xn_s = ((phib * inv_phit1) + Ux);
          if ((xn_s <  460.517018598809)) begin
            delta_ns = exp((- xn_s));
          end
          else begin
            delta_ns = ( 10.0e-201 / (((xn_s -  460.517018598809) * ((((xn_s -  460.517018598809) * (((xn_s -  460.517018598809) *  0.333333333333333) +  1.0)) *  0.5) +  1.0)) +  1.0));
          end
          margin = (xi *  10.0e-6);
          if ((abs(xg) <= margin)) begin
            SP_S_temp1 = ((inv_xi * inv_xi) *  0.117851130197758);
            x_s = ((xg * inv_xi) * ((((xg * ( 1.0 - delta_ns)) * Gf) * SP_S_temp1) +  1.0));
          end
          else begin
            if ((xg < (- margin))) begin
              SP_S_yg = (- xg);
              SP_S_ysub = ((SP_S_yg * inv_xi) *  1.25);
              SP_S_eta = (((SP_S_ysub + 10) - sqrt((((SP_S_ysub -  6.0) * (SP_S_ysub -  6.0)) +  64.0))) *  0.5);
              SP_S_temp = (SP_S_yg - SP_S_eta);
              SP_S_a = ((SP_S_temp * SP_S_temp) + (Gf2 * (SP_S_eta +  1.0)));
              SP_S_c = ((SP_S_temp *  2.0) - Gf2);
              SP_S_tau = ((- SP_S_eta) + ln((SP_S_a * inv_Gf2)));
              __nu = (SP_S_a + SP_S_c);
              __mutau = ((__nu * __nu) + (SP_S_tau * (((SP_S_c * SP_S_c) *  0.5) - SP_S_a)));
              SP_S_y0 = (SP_S_eta + (((SP_S_a * __nu) * SP_S_tau) / (__mutau + (((((__nu / __mutau) * SP_S_tau) * SP_S_tau) * SP_S_c) * (((SP_S_c * SP_S_c) *  0.333333333333333) - SP_S_a)))));
              if ((SP_S_y0 <  230.258509299405)) begin
                SP_S_delta0 = exp(SP_S_y0);
              end
              else begin
                SP_S_delta0 = ((((SP_S_y0 -  230.258509299405) * ((((SP_S_y0 -  230.258509299405) * (((SP_S_y0 -  230.258509299405) *  0.333333333333333) +  1.0)) *  0.5) +  1.0)) +  1.0) *  10.0e+99);
              end
              SP_S_delta1 = ( 1.0 / SP_S_delta0);
              SP_S_temp = ( 1.0 / ((SP_S_y0 * SP_S_y0) +  2.0));
              SP_S_xi0 = ((SP_S_y0 * SP_S_y0) * SP_S_temp);
              SP_S_xi1 = (((SP_S_y0 * SP_S_temp) * SP_S_temp) *  4.0);
              SP_S_xi2 = ((((SP_S_temp *  8.0) - (SP_S_xi0 *  12.0)) * SP_S_temp) * SP_S_temp);
              SP_S_temp = (SP_S_yg - SP_S_y0);
              SP_S_temp1 = (delta_ns * SP_S_delta1);
              SP_S_pC = ((SP_S_temp *  2.0) + (Gf2 * (((SP_S_delta0 -  1.0) - SP_S_temp1) + (delta_ns * ( 1.0 - SP_S_xi1)))));
              SP_S_qC = ((SP_S_temp * SP_S_temp) - (Gf2 * ((((SP_S_delta0 - SP_S_y0) -  1.0) + SP_S_temp1) + (delta_ns * ((SP_S_y0 -  1.0) - SP_S_xi0)))));
              SP_S_temp = ( 2.0 - (Gf2 * ((SP_S_delta0 + SP_S_temp1) - (delta_ns * SP_S_xi2))));
              SP_S_temp = ((SP_S_pC * SP_S_pC) - ((SP_S_qC * SP_S_temp) *  2.0));
              x_s = ((- SP_S_y0) - ((SP_S_qC / (SP_S_pC + sqrt(SP_S_temp))) *  2.0));
            end
            else begin
              SP_xg1 = ( 1.0 / ((Gf *  0.732464877560822) +  1.25));
              SP_S_A_fac = ((((xi *  1.25) * SP_xg1) -  1.0) * SP_xg1);
              SP_S_xbar = ((xg * inv_xi) * ((SP_S_A_fac * xg) +  1.0));
              if (((- SP_S_xbar) > -230.258509299405)) begin
                SP_S_temp = exp((- SP_S_xbar));
              end
              else begin
                SP_S_temp = ( 100.0e-102 / (((-230.258509299405 - (- SP_S_xbar)) * ((((-230.258509299405 - (- SP_S_xbar)) * (((-230.258509299405 - (- SP_S_xbar)) *  0.333333333333333) +  1.0)) *  0.5) +  1.0)) +  1.0));
              end
              SP_S_w = ( 1.0 - SP_S_temp);
              SP_S_x1 = ((xg + (Gf2 *  0.5)) - (Gf * sqrt(((xg + (Gf2 *  0.25)) - SP_S_w))));
              SP_S_bx = (xn_s +  3.0);
              SP_S_eta = ((((SP_S_x1 + SP_S_bx) - sqrt((((SP_S_x1 - SP_S_bx) * (SP_S_x1 - SP_S_bx)) +  5.0))) *  0.5) - ((SP_S_bx - sqrt(((SP_S_bx * SP_S_bx) +  5.0))) *  0.5));
              SP_S_temp = (xg - SP_S_eta);
              SP_S_temp1 = exp((- SP_S_eta));
              SP_S_temp2 = ( 1.0 / ((SP_S_eta * SP_S_eta) +  2.0));
              SP_S_xi0 = ((SP_S_eta * SP_S_eta) * SP_S_temp2);
              SP_S_xi1 = (((SP_S_eta * SP_S_temp2) * SP_S_temp2) *  4.0);
              SP_S_xi2 = ((((SP_S_temp2 *  8.0) - (SP_S_xi0 *  12.0)) * SP_S_temp2) * SP_S_temp2);
              SP_S_a = max( 100.0e-42, ((SP_S_temp * SP_S_temp) - (Gf2 * (((SP_S_temp1 + SP_S_eta) -  1.0) - (delta_ns * ((SP_S_eta +  1.0) + SP_S_xi0))))));
              SP_S_b = ( 1.0 - ((Gf2 * (SP_S_temp1 - (delta_ns * SP_S_xi2))) *  0.5));
              SP_S_c = ((SP_S_temp *  2.0) + (Gf2 * (( 1.0 - SP_S_temp1) - (delta_ns * (SP_S_xi1 +  1.0)))));
              SP_S_tau = ((xn_s - SP_S_eta) + ln((SP_S_a / Gf2)));
              __nu = (SP_S_a + SP_S_c);
              __mutau = ((__nu * __nu) + (SP_S_tau * (((SP_S_c * SP_S_c) *  0.5) - (SP_S_a * SP_S_b))));
              SP_S_x0 = (SP_S_eta + (((SP_S_a * __nu) * SP_S_tau) / (__mutau + (((((__nu / __mutau) * SP_S_tau) * SP_S_tau) * SP_S_c) * (((SP_S_c * SP_S_c) *  0.333333333333333) - (SP_S_a * SP_S_b))))));
              if ((SP_S_x0 <  230.258509299405)) begin
                SP_S_delta0 = exp(SP_S_x0);
                SP_S_delta1 = ( 1.0 / SP_S_delta0);
                SP_S_delta0 = (delta_ns * SP_S_delta0);
              end
              else begin
                if ((SP_S_x0 > (xn_s -  230.258509299405))) begin
                  SP_S_delta0 = exp((SP_S_x0 - xn_s));
                  SP_S_delta1 = (delta_ns / SP_S_delta0);
                end
                else begin
                  SP_S_delta0 = ( 100.0e-102 / ((((xn_s - SP_S_x0) -  230.258509299405) * (((((xn_s - SP_S_x0) -  230.258509299405) * ((((xn_s - SP_S_x0) -  230.258509299405) *  0.333333333333333) +  1.0)) *  0.5) +  1.0)) +  1.0));
                  SP_S_delta1 = ( 100.0e-102 / (((SP_S_x0 -  230.258509299405) * ((((SP_S_x0 -  230.258509299405) * (((SP_S_x0 -  230.258509299405) *  0.333333333333333) +  1.0)) *  0.5) +  1.0)) +  1.0));
                end
              end
              SP_S_temp = ( 1.0 / ((SP_S_x0 * SP_S_x0) +  2.0));
              SP_S_xi0 = ((SP_S_x0 * SP_S_x0) * SP_S_temp);
              SP_S_xi1 = (((SP_S_x0 * SP_S_temp) * SP_S_temp) *  4.0);
              SP_S_xi2 = ((((SP_S_temp *  8.0) - (SP_S_xi0 *  12.0)) * SP_S_temp) * SP_S_temp);
              SP_S_temp = (xg - SP_S_x0);
              SP_S_pC = ((SP_S_temp *  2.0) + (Gf2 * ((( 1.0 - SP_S_delta1) + SP_S_delta0) - (delta_ns * (SP_S_xi1 +  1.0)))));
              SP_S_qC = ((SP_S_temp * SP_S_temp) - (Gf2 * ((((SP_S_delta1 + SP_S_x0) -  1.0) + SP_S_delta0) - (delta_ns * ((SP_S_x0 +  1.0) + SP_S_xi0)))));
              SP_S_temp = ( 2.0 - (Gf2 * ((SP_S_delta1 + SP_S_delta0) - (delta_ns * SP_S_xi2))));
              SP_S_temp = ((SP_S_pC * SP_S_pC) - ((SP_S_qC * SP_S_temp) *  2.0));
              x_s = (SP_S_x0 + ((SP_S_qC / (SP_S_pC + sqrt(SP_S_temp))) *  2.0));
            end
          end
          x_d = x_s;
          x_m = x_s;
          x_ds =  0.0;
          __Vdsat_lim = (phit1 *  3.912023005);
          if ((xg <=  0.0)) begin
            qis =  0.0;
            xgm = (xg - x_s);
            qbs = (xgm * phit1);
            qbd = qbs;
            Voxm = (xgm * phit1);
            qeff1 = Voxm;
            __Vdsat = __Vdsat_lim;
            Vdse = __Vds;
          end
          else begin
            delta_1s =  0.0;
            temp = ( 1.0 / ((x_s * x_s) +  2.0));
            xi0s = ((x_s * x_s) * temp);
            xi1s = (((x_s * temp) * temp) *  4.0);
            xi2s = ((((temp *  8.0) - (xi0s *  12.0)) * temp) * temp);
            if ((x_s <  230.258509299405)) begin
              delta_1s = exp(x_s);
              Es = ( 1.0 / delta_1s);
              delta_1s = (delta_ns * delta_1s);
            end
            else begin
              if ((x_s > (xn_s -  230.258509299405))) begin
                delta_1s = exp((x_s - xn_s));
                Es = (delta_ns / delta_1s);
              end
              else begin
                delta_1s = ( 100.0e-102 / ((((xn_s - x_s) -  230.258509299405) * (((((xn_s - x_s) -  230.258509299405) * ((((xn_s - x_s) -  230.258509299405) *  0.333333333333333) +  1.0)) *  0.5) +  1.0)) +  1.0));
                Es = ( 100.0e-102 / (((x_s -  230.258509299405) * ((((x_s -  230.258509299405) * (((x_s -  230.258509299405) *  0.333333333333333) +  1.0)) *  0.5) +  1.0)) +  1.0));
              end
            end
            Ds = (delta_1s - (delta_ns * ((x_s +  1.0) + xi0s)));
            if ((x_s <  10.0e-6)) begin
              Ps = (((x_s * x_s) * ( 1.0 - ((x_s * ( 1.0 - (x_s *  0.25))) *  0.333333333333333))) *  0.5);
              Ds = (((((delta_ns * x_s) * x_s) * x_s) * ((x_s *  1.75) +  1.0)) *  0.166666666666667);
              temp = sqrt(( 1.0 - ((x_s * ( 1.0 - (x_s *  0.25))) *  0.333333333333333)));
              sqm = ((x_s * temp) *  0.707106781186547);
              alpha = ((((Gf *  0.707106781186547) * (( 1.0 - (x_s *  0.5)) + ((x_s * x_s) *  0.166666666666667))) / temp) +  1.0);
            end
            else begin
              Ps = ((x_s -  1.0) + Es);
              sqm = sqrt(Ps);
              alpha = ((((Gf * ( 1.0 - Es)) / sqm) *  0.5) +  1.0);
            end
            Em = Es;
            Ed = Em;
            Dm = Ds;
            Dd = Dm;
            Rxcor = ((((__XCOR_T *  0.2) * Vsbx) +  1.0) / ((__XCOR_T * Vsbx) +  1.0));
            if ((Ds >  100.0e-102)) begin
              xgs = (Gf * sqrt((Ps + Ds)));
              qis = (((Gf2 * Ds) * phit1) / (xgs + (Gf * sqm)));
              qbs = ((sqm * Gf) * phit1);
              if ((__RSB_i <  0.0)) begin
                rhob = ( 1.0 / ( 1.0 - (__RSB_i * Vsbx)));
              end
              else begin
                rhob = ((__RSB_i * Vsbx) +  1.0);
              end
              if ((__RSG_i <  0.0)) begin
                temp = ( 1.0 - (__RSG_i * qis));
              end
              else begin
                temp = ( 1.0 / ((__RSG_i * qis) +  1.0));
              end
              GR = (__THER_i * ((rhob * temp) * qis));
              Eeffm = (__E_eff0 * (qbs + (__eta_mu * qis)));
              temp1 = ln((Ps / ((Ps + Ds) +  10.0e-15)));
              Mutmp = (pow((Eeffm * __MUE_T), __THEMU_T) + (__CS_T * exp(((__THECS_T *  0.5) * temp1))));
              Gmob = (((Mutmp +  1.0) + GR) * Rxcor);
              if ((__THESATB_i <  0.0)) begin
                xitsb = ( 1.0 / ( 1.0 - (__THESATB_i * Vsbx)));
              end
              else begin
                xitsb = ((__THESATB_i * Vsbx) +  1.0);
              end
              temp2 = (qis * xitsb);
              wsat = ((temp2 / (temp2 +  100.0)) *  100.0);
              if ((__THESATG_i <  0.0)) begin
                temp = ( 1.0 / ( 1.0 - (__THESATG_i * wsat)));
              end
              else begin
                temp = ((__THESATG_i * wsat) +  1.0);
              end
              thesat1 = (thesatloc * (temp / Gmob));
              phi_inf = ((qis / alpha) + phit1);
              ysat = ((thesat1 * phi_inf) *  0.707106781186547);
              if ((__CHNL_TYPE == -1)) begin
                ysat = (ysat / sqrt((ysat +  1.0)));
              end
              za = ( 2.0 / (sqrt(((ysat *  4.0) +  1.0)) +  1.0));
              temp1 = (za * ysat);
              Phi_0 = ((phi_inf * za) * ((((temp1 * ( 1.0 - (temp1 * za))) / ((((temp1 * temp1) * za) *  4.0) +  1.0)) *  0.86) +  1.0));
              asat = (xgs + (Gf2 *  0.5));
              Phi_2 = ((((Gf2 * Ds) * phit1) / (asat + sqrt(((asat * asat) - ((Gf2 * Ds) *  0.98))))) *  0.98);
              Phi_0_2 = (Phi_0 + Phi_2);
              Phi0_Phi2 = ((Phi_0 * Phi_2) *  2.0);
              Phi_sat = (Phi0_Phi2 / (Phi_0_2 + sqrt(((Phi_0_2 * Phi_0_2) - (Phi0_Phi2 *  1.98)))));
              __Vdsat = (Phi_sat - (phit1 * ln(((((Phi_sat * (Phi_sat - ((asat *  2.0) * phit1))) * inv_Gf2) / ((phit1 * phit1) * Ds)) +  1.0))));
            end
            else begin
              __Vdsat = __Vdsat_lim;
            end
            temp = pow((__Vds / __Vdsat), axloc);
            temp1 = (-1.0 / axloc);
            Vdse = (__Vds * pow((temp +  1.0), temp1));
            Udse = (Vdse * inv_phit1);
            xn_d = (xn_s + Udse);
            if ((Udse <  460.517018598809)) begin
              k_ds = exp((- Udse));
            end
            else begin
              k_ds = ( 10.0e-201 / (((Udse -  460.517018598809) * ((((Udse -  460.517018598809) * (((Udse -  460.517018598809) *  0.333333333333333) +  1.0)) *  0.5) +  1.0)) +  1.0));
            end
            delta_nd = (delta_ns * k_ds);
            if ((abs(xg) <= margin)) begin
              SP_S_temp1 = ((inv_xi * inv_xi) *  0.117851130197758);
              x_d = ((xg * inv_xi) * ((((xg * ( 1.0 - delta_nd)) * Gf) * SP_S_temp1) +  1.0));
            end
            else begin
              SP_S_bx = (xn_d +  3.0);
              SP_S_eta = ((((SP_S_x1 + SP_S_bx) - sqrt((((SP_S_x1 - SP_S_bx) * (SP_S_x1 - SP_S_bx)) +  5.0))) *  0.5) - ((SP_S_bx - sqrt(((SP_S_bx * SP_S_bx) +  5.0))) *  0.5));
              SP_S_temp = (xg - SP_S_eta);
              SP_S_temp1 = exp((- SP_S_eta));
              SP_S_temp2 = ( 1.0 / ((SP_S_eta * SP_S_eta) +  2.0));
              SP_S_xi0 = ((SP_S_eta * SP_S_eta) * SP_S_temp2);
              SP_S_xi1 = (((SP_S_eta * SP_S_temp2) * SP_S_temp2) *  4.0);
              SP_S_xi2 = ((((SP_S_temp2 *  8.0) - (SP_S_xi0 *  12.0)) * SP_S_temp2) * SP_S_temp2);
              SP_S_a = max( 100.0e-42, ((SP_S_temp * SP_S_temp) - (Gf2 * (((SP_S_temp1 + SP_S_eta) -  1.0) - (delta_nd * ((SP_S_eta +  1.0) + SP_S_xi0))))));
              SP_S_b = ( 1.0 - ((Gf2 * (SP_S_temp1 - (delta_nd * SP_S_xi2))) *  0.5));
              SP_S_c = ((SP_S_temp *  2.0) + (Gf2 * (( 1.0 - SP_S_temp1) - (delta_nd * (SP_S_xi1 +  1.0)))));
              SP_S_tau = ((xn_d - SP_S_eta) + ln((SP_S_a / Gf2)));
              __nu = (SP_S_a + SP_S_c);
              __mutau = ((__nu * __nu) + (SP_S_tau * (((SP_S_c * SP_S_c) *  0.5) - (SP_S_a * SP_S_b))));
              SP_S_x0 = (SP_S_eta + (((SP_S_a * __nu) * SP_S_tau) / (__mutau + (((((__nu / __mutau) * SP_S_tau) * SP_S_tau) * SP_S_c) * (((SP_S_c * SP_S_c) *  0.333333333333333) - (SP_S_a * SP_S_b))))));
              if ((SP_S_x0 <  230.258509299405)) begin
                SP_S_delta0 = exp(SP_S_x0);
                SP_S_delta1 = ( 1.0 / SP_S_delta0);
                SP_S_delta0 = (delta_nd * SP_S_delta0);
              end
              else begin
                if ((SP_S_x0 > (xn_d -  230.258509299405))) begin
                  SP_S_delta0 = exp((SP_S_x0 - xn_d));
                  SP_S_delta1 = (delta_nd / SP_S_delta0);
                end
                else begin
                  SP_S_delta0 = ( 100.0e-102 / ((((xn_d - SP_S_x0) -  230.258509299405) * (((((xn_d - SP_S_x0) -  230.258509299405) * ((((xn_d - SP_S_x0) -  230.258509299405) *  0.333333333333333) +  1.0)) *  0.5) +  1.0)) +  1.0));
                  SP_S_delta1 = ( 100.0e-102 / (((SP_S_x0 -  230.258509299405) * ((((SP_S_x0 -  230.258509299405) * (((SP_S_x0 -  230.258509299405) *  0.333333333333333) +  1.0)) *  0.5) +  1.0)) +  1.0));
                end
              end
              SP_S_temp = ( 1.0 / ((SP_S_x0 * SP_S_x0) +  2.0));
              SP_S_xi0 = ((SP_S_x0 * SP_S_x0) * SP_S_temp);
              SP_S_xi1 = (((SP_S_x0 * SP_S_temp) * SP_S_temp) *  4.0);
              SP_S_xi2 = ((((SP_S_temp *  8.0) - (SP_S_xi0 *  12.0)) * SP_S_temp) * SP_S_temp);
              SP_S_temp = (xg - SP_S_x0);
              SP_S_pC = ((SP_S_temp *  2.0) + (Gf2 * ((( 1.0 - SP_S_delta1) + SP_S_delta0) - (delta_nd * (SP_S_xi1 +  1.0)))));
              SP_S_qC = ((SP_S_temp * SP_S_temp) - (Gf2 * ((((SP_S_delta1 + SP_S_x0) -  1.0) + SP_S_delta0) - (delta_nd * ((SP_S_x0 +  1.0) + SP_S_xi0)))));
              SP_S_temp = ( 2.0 - (Gf2 * ((SP_S_delta1 + SP_S_delta0) - (delta_nd * SP_S_xi2))));
              SP_S_temp = ((SP_S_pC * SP_S_pC) - ((SP_S_qC * SP_S_temp) *  2.0));
              x_d = (SP_S_x0 + ((SP_S_qC / (SP_S_pC + sqrt(SP_S_temp))) *  2.0));
            end
            x_ds = (x_d - x_s);
            if ((x_ds <  100.0e-12)) begin
              pC = (((xg - x_s) *  2.0) + (Gf2 * ((( 1.0 - Es) + (delta_1s * k_ds)) - (delta_nd * (xi1s +  1.0)))));
              qC = ((Gf2 * ( 1.0 - k_ds)) * Ds);
              temp = ( 2.0 - (Gf2 * ((Es + (delta_1s * k_ds)) - (delta_nd * xi2s))));
              temp = ((pC * pC) - ((temp * qC) *  2.0));
              x_ds = ((qC / (pC + sqrt(temp))) *  2.0);
              x_d = (x_s + x_ds);
            end
            dps = (x_ds * phit1);
            xi0d = ((x_d * x_d) / ((x_d * x_d) +  2.0));
            if ((x_d <  230.258509299405)) begin
              Ed = exp((- x_d));
              if ((x_d <  10.0e-6)) begin
                Pd = (((x_d * x_d) * ( 1.0 - ((x_d * ( 1.0 - (x_d *  0.25))) *  0.333333333333333))) *  0.5);
                temp = sqrt(( 1.0 - ((x_d * ( 1.0 - (x_d *  0.25))) *  0.333333333333333)));
                sqd = ((x_d * temp) *  0.707106781186547);
                Dd = (((((delta_nd *  0.166666666666667) * x_d) * x_d) * x_d) * ((x_d *  1.75) +  1.0));
              end
              else begin
                Pd = ((x_d -  1.0) + Ed);
                sqd = sqrt(Pd);
                Dd = (delta_nd * (((( 1.0 / Ed) - x_d) -  1.0) - xi0d));
              end
            end
            else begin
              if ((x_d > (xn_d -  230.258509299405))) begin
                temp = exp((x_d - xn_d));
                Ed = (delta_nd / temp);
                Dd = (temp - (delta_nd * ((x_d +  1.0) + xi0d)));
              end
              else begin
                Ed = ( 100.0e-102 / (((x_d -  230.258509299405) * ((((x_d -  230.258509299405) * (((x_d -  230.258509299405) *  0.333333333333333) +  1.0)) *  0.5) +  1.0)) +  1.0));
                temp = ( 100.0e-102 / ((((xn_d - x_d) -  230.258509299405) * (((((xn_d - x_d) -  230.258509299405) * ((((xn_d - x_d) -  230.258509299405) *  0.333333333333333) +  1.0)) *  0.5) +  1.0)) +  1.0));
                Dd = (temp - (delta_nd * ((x_d +  1.0) + xi0d)));
              end
              Pd = ((x_d -  1.0) + Ed);
              sqd = sqrt(Pd);
            end
            qbd = ((sqd * Gf) * phit1);
            x_m = ((x_s + x_d) *  0.5);
            Em =  0.0;
            temp = (Ed * Es);
            if ((temp >  0.0)) begin
              Em = sqrt(temp);
            end
            D_bar = ((Ds + Dd) *  0.5);
            Dm = (D_bar + (((x_ds * x_ds) * (Em - (inv_Gf2 *  2.0))) *  0.125));
            if ((x_m <  10.0e-6)) begin
              Pm = (((x_m * x_m) * ( 1.0 - ((x_m * ( 1.0 - (x_m *  0.25))) *  0.333333333333333))) *  0.5);
              xgm = (Gf * sqrt((Dm + Pm)));
              if ((__kp >  0.0)) begin
                eta_p = ( 1.0 / sqrt(((__kp * xgm) +  1.0)));
              end
              temp = sqrt(( 1.0 - ((x_m * ( 1.0 - (x_m *  0.25))) *  0.333333333333333)));
              sqm = ((x_m * temp) *  0.707106781186547);
              alpha = (eta_p + (((Gf * (( 1.0 - (x_m *  0.5)) + ((x_m * x_m) *  0.166666666666667))) / temp) *  0.707106781186547));
            end
            else begin
              Pm = ((x_m -  1.0) + Em);
              xgm = (Gf * sqrt((Dm + Pm)));
              if ((__kp >  0.0)) begin
                d0 = (( 1.0 - Em) + ((xgm * inv_Gf2) *  2.0));
                eta_p = ( 1.0 / sqrt(((__kp * xgm) +  1.0)));
                temp = (eta_p / (eta_p +  1.0));
                x_pm = (__kp * (((temp * temp) * Gf2) * Dm));
                p_pd = (((xgm - x_pm) *  2.0) + (Gf2 * (( 1.0 - Em) + Dm)));
                q_pd = (x_pm * (x_pm - (xgm *  2.0)));
                xi_pd = ( 1.0 - ((Gf2 * (Em + Dm)) *  0.5));
                u_pd = ((q_pd * p_pd) / ((p_pd * p_pd) - (xi_pd * q_pd)));
                x_m = (x_m + u_pd);
                km = exp(u_pd);
                Em = (Em / km);
                Dm = (Dm * km);
                Pm = ((x_m -  1.0) + Em);
                xgm = (Gf * sqrt((Dm + Pm)));
                km0 = (( 1.0 - Em) + (((xgm * eta_p) * inv_Gf2) *  2.0));
                x_ds = (((x_ds * km) * (d0 + D_bar)) / (km0 + (km * D_bar)));
                dps = (x_ds * phit1);
              end
              sqm = sqrt(Pm);
              alpha = (eta_p + (((Gf * ( 1.0 - Em)) / sqm) *  0.5));
            end
            qim = (phit1 * ((Gf2 * Dm) / (xgm + (Gf * sqm))));
            qim1 = (qim + (phit1 * alpha));
            qbm = ((sqm * Gf) * phit1);
            if ((__RSG_i <  0.0)) begin
              temp = ( 1.0 - (__RSG_i * qim));
            end
            else begin
              temp = ( 1.0 / ((__RSG_i * qim) +  1.0));
            end
            GR = (__THER_i * ((rhob * temp) * qim));
            qeff = (qbm + (__eta_mu * qim));
            qeff1 = (qbm + (__eta_mu1 * qim));
            Eeffm = (__E_eff0 * qeff);
            temp1 = ln((Pm / ((Pm + Dm) +  10.0e-15)));
            Mutmp = (pow((Eeffm * __MUE_T), __THEMU_T) + (__CS_T * exp(((__THECS_T *  0.5) * temp1))));
            Gmob = (((Mutmp +  1.0) + GR) * Rxcor);
            s1 = ln(((((__Vds - dps) * __inv_VP) +  1.0) / (((Vdse - dps) * __inv_VP) +  1.0)));
            dL = (alploc * s1);
            GdL = ( 1.0 / ((dL +  1.0) + (dL * dL)));
            temp2 = (qim * xitsb);
            wsat = ((temp2 / (temp2 +  100.0)) *  100.0);
            Gmob_dL = (Gmob * GdL);
            if ((__THESATG_i <  0.0)) begin
              temp = ( 1.0 / ( 1.0 - (__THESATG_i * wsat)));
            end
            else begin
              temp = ((__THESATG_i * wsat) +  1.0);
            end
            thesat1 = (thesatloc * (temp / Gmob_dL));
            zsat = (((thesat1 * thesat1) * dps) * dps);
            if ((__CHNL_TYPE == -1)) begin
              zsat = (zsat / ((thesat1 * dps) +  1.0));
            end
            Gvsat = ((Gmob_dL * (sqrt(((zsat *  2.0) +  1.0)) +  1.0)) *  0.5);
            Gvsatinv = ( 1.0 / Gvsat);
            Voxm = (xgm * phit1);
            temp = (Gmob_dL * Gvsatinv);
            alpha1 = (alpha * ((((zsat * temp) * temp) *  0.5) +  1.0));
            H = ((temp * qim1) / alpha1);
          end
          Vgsinr = (phit1 * (x_s - xn_s));
          Vsginr = ((__Vgb1 - Vgsinr) - qbs);
          Vgdinr = ((dps + Vgsinr) - __Vds);
          Vdginr = ((__Vgb1 - Vgdinr) - qbd);
          if ((xg >  0.0)) begin
            qim1_1 = ( 1.0 / qim1);
            r1 = (qim * qim1_1);
            r2 = (phit1 * (alpha * qim1_1));
            s2 = ln(((__Vdsx * __inv_VP) +  1.0));
            dL1 = ((dL + (__ALP1_i * ((qim1_1 * r1) * s1))) + (__ALP2_i * (((qbm * r2) * r2) * s2)));
            FdL = (((dL1 +  1.0) + (dL1 * dL1)) * GdL);
          end
          Vgb1_dc = __Vgb1;
          xg_dc = xg;
          __qeff1_dc = qeff1;
          __Voxm_dc = Voxm;
          alpha_dc = alpha;
          dps_dc = dps;
          qim_dc = qim;
          qim1_dc = qim1;
          __GdL_dc = GdL;
          FdL_dc = FdL;
          H_dc = H;
          __eta_p_dc = eta_p;
          __Gvsat_dc = Gvsat;
          Gvsatinv_dc = Gvsatinv;
          __Gmob_dL_dc = Gmob_dL;
          __x_ds_dc = x_ds;
          __x_m_dc = x_m;
          __Gf_dc = Gf;
          __Vdsat_dc = __Vdsat;
          __Udse_dc = Udse;
          Gmob_dc = Gmob;
          xitsb_dc = xitsb;
          Vdse_dc = Vdse;
          Vgsinr_dc = Vgsinr;
          Vsginr_dc = Vsginr;
          Vgdinr_dc = Vgdinr;
          Vdginr_dc = Vdginr;
          __xgm_dc = xgm;
          __thesat1_dc = thesat1;
          __margin_dc = margin;
        end
        if ((xg_dc <=  0.0)) begin
          Ids =  0.0;
        end
        else begin
          Ids = (__BET_i * (((FdL_dc * qim1_dc) * dps_dc) * Gvsatinv_dc));
        end
        if (((((1 && ((__IGOV_i >  0.0) || (__IGOVD_i >  0.0))) || (1 && ((__AGIDL_i >  0.0) || (__AGIDLD_i >  0.0)))) || (__CGOV_i >  0.0)) || (__CGOVD_i >  0.0))) begin
          __SP_OV_xg = ((__xgs_ov + sqrt(((__xgs_ov * __xgs_ov) + __SP_OV_eps2_s))) *  0.5);
          __xs_ov = ((((- __SP_OV_xg) - (__GOV2_s *  0.5)) + (__GOV_s * sqrt(((__SP_OV_xg + (__GOV2_s *  0.25)) + __SP_OV_a_s)))) + __SP_OV_delta1_s);
          __SP_OV_xg = ((__xgd_ov + sqrt(((__xgd_ov * __xgd_ov) + __SP_OV_eps2_d))) *  0.5);
          __xd_ov = ((((- __SP_OV_xg) - (__GOV2_d *  0.5)) + (__GOV_d * sqrt(((__SP_OV_xg + (__GOV2_d *  0.25)) + __SP_OV_a_d)))) + __SP_OV_delta1_d);
          __Vovs = ((- __phita) * (__xgs_ov + __xs_ov));
          __Vovd = ((- __phita) * (__xgd_ov + __xd_ov));
        end
        Igsov =  0.0;
        Igdov =  0.0;
        __Igc =  0.0;
        __Igb =  0.0;
        Igcs =  0.0;
        Igcd =  0.0;
        if (1) begin
          if ((__IGOV_i >  0.0)) begin
            __zg = (sqrt(((__Vovs * __Vovs) +  1.0e-6)) * __inv_CHIB);
            if ((__GC3OV_i <  0.0)) begin
              __zg = (((__zg + __GCQOV) - sqrt((((__zg - __GCQOV) * (__zg - __GCQOV)) +  1.0e-6))) *  0.5);
            end
            temp = (__BOV * ((__zg * (__GC2OV_i + (__GC3OV_i * __zg))) + -1.5));
            if ((temp >  0.0)) begin
              __TP = ((temp * (((temp * ((temp *  0.333333333333333) +  1.0)) *  0.5) +  1.0)) +  1.0);
            end
            else begin
              if ((temp > -230.258509299405)) begin
                __TP = exp(temp);
              end
              else begin
                __TP = ( 100.0e-102 / (((-230.258509299405 - temp) * ((((-230.258509299405 - temp) * (((-230.258509299405 - temp) *  0.333333333333333) +  1.0)) *  0.5) +  1.0)) +  1.0));
              end
            end
            __Fs1 = (__xs_ov +  3.0);
            __Fs2 = (-3.0 - __GCO_i);
            __Fs3 = (__VgsPrime *  30.0);
            __tme1 =  3.1;
            __tme2 = (__Fs1 + __Fs3);
            temp = (( 2.0 / __tme1) * (__tme2 - sqrt(((__tme2 * __tme2) - ((__tme1 * __Fs1) * __Fs3)))));
            __tme1 =  3.7;
            __tme2 = (__Fs2 + temp);
            __Fs = (( 2.0 / __tme1) * (__tme2 + sqrt(((__tme2 * __tme2) - ((__tme1 * __Fs2) * temp)))));
            Igsov = (__IGOV_i * (__TP * __Fs));
          end
          if ((__IGOVD_i >  0.0)) begin
            __zg = (sqrt(((__Vovd * __Vovd) +  1.0e-6)) * __inv_CHIB);
            if ((__GC3OV_i <  0.0)) begin
              __zg = (((__zg + __GCQOV) - sqrt((((__zg - __GCQOV) * (__zg - __GCQOV)) +  1.0e-6))) *  0.5);
            end
            temp = (__BOV_d * ((__zg * (__GC2OV_i + (__GC3OV_i * __zg))) + -1.5));
            if ((temp >  0.0)) begin
              __TP = ((temp * (((temp * ((temp *  0.333333333333333) +  1.0)) *  0.5) +  1.0)) +  1.0);
            end
            else begin
              if ((temp > -230.258509299405)) begin
                __TP = exp(temp);
              end
              else begin
                __TP = ( 100.0e-102 / (((-230.258509299405 - temp) * ((((-230.258509299405 - temp) * (((-230.258509299405 - temp) *  0.333333333333333) +  1.0)) *  0.5) +  1.0)) +  1.0));
              end
            end
            __Fs1 = (__xd_ov +  3.0);
            __Fs2 = (-3.0 - __GCO_i);
            __Fs3 = (__VgdPrime *  30.0);
            __tme1 =  3.1;
            __tme2 = (__Fs1 + __Fs3);
            temp = (( 2.0 / __tme1) * (__tme2 - sqrt(((__tme2 * __tme2) - ((__tme1 * __Fs1) * __Fs3)))));
            __tme1 =  3.7;
            __tme2 = (__Fs2 + temp);
            __Fs = (( 2.0 / __tme1) * (__tme2 + sqrt(((__tme2 * __tme2) - ((__tme1 * __Fs2) * temp)))));
            Igdov = (__IGOVD_i * (__TP * __Fs));
          end
          if ((__IGINV_i >  0.0)) begin
            if ((xg_dc <=  0.0)) begin
              temp = pow((__Vds / __Vdsat_lim), __AX_i);
              __Udse_dc = ((__Vds * pow((temp +  1.0), (- __inv_AX))) * inv_phit1);
            end
            if (((__x_ds_dc - __Udse_dc) > -230.258509299405)) begin
              temp = exp((__x_ds_dc - __Udse_dc));
            end
            else begin
              temp = ( 100.0e-102 / (((-230.258509299405 - (__x_ds_dc - __Udse_dc)) * ((((-230.258509299405 - (__x_ds_dc - __Udse_dc)) * (((-230.258509299405 - (__x_ds_dc - __Udse_dc)) *  0.333333333333333) +  1.0)) *  0.5) +  1.0)) +  1.0));
            end
            __Vm = (__Vsbstar_dc + (phit1 * ((__x_ds_dc *  0.5) - ln(((temp +  1.0) *  0.5)))));
            __Dch = (__GCO_i * phit1);
            __arg2mina = (__Voxm_dc + __Dch);
            __psi_t = ((__arg2mina - sqrt(((( 0.0 - __arg2mina) * ( 0.0 - __arg2mina)) +  0.01))) *  0.5);
            __zg = (sqrt(((__Voxm_dc * __Voxm_dc) +  1.0e-6)) * __inv_CHIB);
            if ((__GC3_i <  0.0)) begin
              __zg = (((__zg + __GCQ) - sqrt((((__zg - __GCQ) * (__zg - __GCQ)) +  1.0e-6))) *  0.5);
            end
            __arg1 = (__x_m_dc + (((__psi_t - __alpha_b) - __Vm) * inv_phit1));
            if ((abs(__arg1) <  230.258509299405)) begin
              __Dsi = exp(__arg1);
            end
            else begin
              if ((__arg1 <  0.0)) begin
                __Dsi = ( 100.0e-102 / (((-230.258509299405 - __arg1) * ((((-230.258509299405 - __arg1) * (((-230.258509299405 - __arg1) *  0.333333333333333) +  1.0)) *  0.5) +  1.0)) +  1.0));
              end
              else begin
                __Dsi = ((((__arg1 -  230.258509299405) * ((((__arg1 -  230.258509299405) * (((__arg1 -  230.258509299405) *  0.333333333333333) +  1.0)) *  0.5) +  1.0)) +  1.0) *  10.0e+99);
              end
            end
            __arg1 = ((- ((__Vgs + __Vsbstar_dc) - __Vm)) * inv_phit1);
            if ((abs(__arg1) <  230.258509299405)) begin
              temp = exp(__arg1);
            end
            else begin
              if ((__arg1 <  0.0)) begin
                temp = ( 100.0e-102 / (((-230.258509299405 - __arg1) * ((((-230.258509299405 - __arg1) * (((-230.258509299405 - __arg1) *  0.333333333333333) +  1.0)) *  0.5) +  1.0)) +  1.0));
              end
              else begin
                temp = ((((__arg1 -  230.258509299405) * ((((__arg1 -  230.258509299405) * (((__arg1 -  230.258509299405) *  0.333333333333333) +  1.0)) *  0.5) +  1.0)) +  1.0) *  10.0e+99);
              end
            end
            __Dgate = (__Dsi * temp);
            temp = (__BCH * ((__zg * (__GC2_i + (__GC3_i * __zg))) + -1.5));
            if ((temp >  0.0)) begin
              __TP = ((temp * (((temp * ((temp *  0.333333333333333) +  1.0)) *  0.5) +  1.0)) +  1.0);
            end
            else begin
              if ((temp > -230.258509299405)) begin
                __TP = exp(temp);
              end
              else begin
                __TP = ( 100.0e-102 / (((-230.258509299405 - temp) * ((((-230.258509299405 - temp) * (((-230.258509299405 - temp) *  0.333333333333333) +  1.0)) *  0.5) +  1.0)) +  1.0));
              end
            end
            __Igc0 = (__IGINV_i * (__TP * ln(((__Dsi +  1.0) / (__Dgate +  1.0)))));
            if (((xg_dc <=  0.0) || ((__GC2_i ==  0.0) && (__GC3_i ==  0.0)))) begin
              __igc =  1.0;
              __igcd_h =  0.5;
            end
            else begin
              temp = (__GC2_i + ((__GC3_i *  2.0) * __zg));
              __u0 = (__CHIB_i / (temp * __BCH));
              __x = ((dps_dc / __u0) *  0.5);
              __u0_div_H = (__u0 / H_dc);
              __Bg = ((__u0_div_H * ( 1.0 - __u0_div_H)) *  0.5);
              __Ag = ( 0.5 - (__Bg *  3.0));
              if ((__x <  0.001)) begin
                __xsq = (__x * __x);
                __igc = ((__xsq * (((__u0_div_H *  0.333333333333333) +  0.166666666666667) + ((__xsq * ((__u0_div_H *  0.2) +  0.05)) *  0.166666666666667))) +  1.0);
                __igcd_h = ((__igc *  0.5) - ((__x * ((__xsq * (((__Bg +  0.25) *  0.4) + ((__xsq * (__Bg +  0.125)) *  0.0285714285714))) +  1.0)) *  0.166666666666667));
              end
              else begin
                __inv_x = ( 1.0 / __x);
                if ((abs(__x) <  230.258509299405)) begin
                  __ex = exp(__x);
                end
                else begin
                  if ((__x <  0.0)) begin
                    __ex = ( 100.0e-102 / (((-230.258509299405 - __x) * ((((-230.258509299405 - __x) * (((-230.258509299405 - __x) *  0.333333333333333) +  1.0)) *  0.5) +  1.0)) +  1.0));
                  end
                  else begin
                    __ex = ((((__x -  230.258509299405) * ((((__x -  230.258509299405) * (((__x -  230.258509299405) *  0.333333333333333) +  1.0)) *  0.5) +  1.0)) +  1.0) *  10.0e+99);
                  end
                end
                __inv_ex = ( 1.0 / __ex);
                temp = (__ex - __inv_ex);
                temp2 = (__ex + __inv_ex);
                __igc = ((((( 1.0 - __u0_div_H) * temp) * __inv_x) + (__u0_div_H * temp2)) *  0.5);
                __igcd_h = (((__igc - (temp * (__Bg - ((__Ag * __inv_x) * __inv_x)))) - ((__Ag * temp2) * __inv_x)) *  0.5);
              end
            end
            __Sg = (((xg_dc / sqrt(((xg_dc * xg_dc) +  1.0e-6))) +  1.0) *  0.5);
            __Igc = ((__Igc0 * __igc) * __Sg);
            Igcd = ((__Igc0 * __igcd_h) * __Sg);
            Igcs = (__Igc - Igcd);
            __Igb = ((__Igc0 * __igc) * ( 1.0 - __Sg));
          end
        end
        __Igidl =  0.0;
        __Igisl =  0.0;
        if (1) begin
          if (((__AGIDLD_i >  0.0) && (__Vovd <  0.0))) begin
            __Vtovd = sqrt((((__Vovd * __Vovd) + ((__CGIDLD_i * __CGIDLD_i) * (__VdbPrime * __VdbPrime))) +  1.0e-6));
            temp = ((- __BGIDLDs) / __Vtovd);
            if ((temp > -230.258509299405)) begin
              temp2 = exp(temp);
            end
            else begin
              temp2 = ( 100.0e-102 / (((-230.258509299405 - temp) * ((((-230.258509299405 - temp) * (((-230.258509299405 - temp) *  0.333333333333333) +  1.0)) *  0.5) +  1.0)) +  1.0));
            end
            __Igidl = ((- __AGIDLDs) * (((__VdbPrime * __Vovd) * __Vtovd) * temp2));
          end
          if (((__AGIDL_i >  0.0) && (__Vovs <  0.0))) begin
            __Vtovs = sqrt((((__Vovs * __Vovs) + ((__CGIDL_i * __CGIDL_i) * (__VsbPrime * __VsbPrime))) +  1.0e-6));
            temp = ((- __BGIDLs) / __Vtovs);
            if ((temp > -230.258509299405)) begin
              temp2 = exp(temp);
            end
            else begin
              temp2 = ( 100.0e-102 / (((-230.258509299405 - temp) * ((((-230.258509299405 - temp) * (((-230.258509299405 - temp) *  0.333333333333333) +  1.0)) *  0.5) +  1.0)) +  1.0));
            end
            __Igisl = ((- __AGIDLs) * (((__VsbPrime * __Vovs) * __Vtovs) * temp2));
          end
        end
        xgedge =  0.0;
        qdseffedge =  0.0;
        qmeffedge =  0.0;
        dsqredge =  100.0e-42;
        alphabmedge =  1.0;
        Idsedge =  0.0;
        if (0) begin
          if (0) begin
          end
          else begin
          end
          if ((__Q_EDGE_xgt > -12.0)) begin
            if (((__Q_EDGE_xgt - __Q_EDGE_qi0) <  230.258509299405)) begin
            end
            else begin
            end
          end
          else begin
            if (((__Q_EDGE_n_inv * (__Q_EDGE_xgt + __lnGfedge2)) > -230.258509299405)) begin
            end
            else begin
            end
          end
          if (((qseffedge <  0.001) && (Vdse_dc <  1.0e-6))) begin
            if ((((- xnedge_d) + xnedge_s) > -230.258509299405)) begin
            end
            else begin
            end
          end
          else begin
            if ((__Q_EDGE_xgt > -12.0)) begin
              if (((__Q_EDGE_xgt - __Q_EDGE_qi0) <  230.258509299405)) begin
              end
              else begin
              end
            end
            else begin
              if (((__Q_EDGE_n_inv * (__Q_EDGE_xgt + __lnGfedge2)) > -230.258509299405)) begin
              end
              else begin
              end
            end
          end
        end
        if (((xg_dc >  0.0) && 1)) begin
          __delVsat = (__Vds - (__A3_i * dps_dc));
          if ((__delVsat >  0.0)) begin
            temp2 = (__A2_T * (((__A4_i * (sqrt((__phib_dc + __Vsbstar_dc)) - __sqrt_phib_dc)) +  1.0) / (__delVsat +  1.0e-30)));
            if ((abs((- temp2)) <  230.258509299405)) begin
              temp = exp((- temp2));
            end
            else begin
              if (((- temp2) <  0.0)) begin
                temp = ( 100.0e-102 / (((-230.258509299405 - (- temp2)) * ((((-230.258509299405 - (- temp2)) * (((-230.258509299405 - (- temp2)) *  0.333333333333333) +  1.0)) *  0.5) +  1.0)) +  1.0));
              end
              else begin
                temp = (((((- temp2) -  230.258509299405) * (((((- temp2) -  230.258509299405) * ((((- temp2) -  230.258509299405) *  0.333333333333333) +  1.0)) *  0.5) +  1.0)) +  1.0) *  10.0e+99);
              end
            end
            mavl = (__A1_i * (__delVsat * temp));
            Iimpact = (mavl * (Ids + Idsedge));
          end
        end
        __P_D = (((__Gf_dc * __kp) *  0.25) +  1.0);
        __facvsb0 = (__phib_dc + (phit1 *  2.0));
        __facvsb = (__Vsbstar_dc + __facvsb0);
        __vts_i = (((__VFB_T + (__P_D * __facvsb)) - __Vsbstar_dc) + (__Gf_dc * sqrt((phit1 * __facvsb))));
        __vth_i = (__vts_i - __delVg);
      end
      begin : evaluateDynamic
        real Vginr, Vginreff, fqinr, dVinracc, finracc, xginrdep, finrdep, dVinrdep, finr, dVinr, xgbeff_ov_s;
        real yb_ov_s, xgbeff_ov_d, yb_ov_d;
        begin : SPcalc_ac
          real phib, G_0, Vsbstar, cfloc, thesatloc, axloc, alploc;
          real Vsbx, xg, Dnsub, Gf, Gf2, inv_Gf2, xi, inv_xi, Ux, xn_s, delta_ns, margin, x_s, delta_1s, xi0s, xi1s;
          real xi2s, Es, Ds, Ps, Rxcor, xgs, qis, qbs, rhob, GR, Eeffm, Mutmp, Gmob, xitsb, wsat, thesat1, phi_inf;
          real ysat, za, Phi_0, asat, Phi_2, Phi_0_2, Phi0_Phi2, Phi_sat, Vdse, Udse, xn_d, k_ds, delta_nd, x_d, x_ds;
          real pC, qC, dps, xi0d, Ed, Dd, Pd, sqd, qbd, x_m, Em, D_bar, Dm, Pm, xgm, eta_p, sqm, alpha, d0, x_pm, p_pd;
          real q_pd, xi_pd, u_pd, km, km0, qim, qim1, qbm, qeff, qeff1, s1, dL, GdL, Gmob_dL, zsat, Gvsat, Gvsatinv;
          real Voxm, alpha1, H, Vgsinr, Vsginr, Vgdinr, Vdginr;
          real SP_S_temp, SP_S_temp1, SP_S_temp2;
          real SP_S_yg, SP_S_ysub, SP_S_eta, SP_S_a, SP_S_c, SP_S_tau, SP_S_y0, SP_S_delta0, SP_S_delta1, SP_S_xi0;
          real SP_S_xi1, SP_S_xi2, SP_S_pC, SP_S_qC, SP_xg1, SP_S_A_fac, SP_S_xbar, SP_S_w, SP_S_x1, SP_S_bx, SP_S_b;
          real SP_S_x0;
          if (0) begin
            if (0) begin
            end
            if (0) begin
            end
            if (0) begin
            end
            else begin
            end
            if ((__DNSUB_i >  0.0)) begin
            end
            else begin
            end
            if ((__CTG_i >  0.0)) begin
              if ((temp2 > -230.258509299405)) begin
              end
              else begin
              end
            end
            if (0) begin
            end
            if ((xn_s <  460.517018598809)) begin
            end
            else begin
            end
            if ((abs(xg) <= margin)) begin
            end
            else begin
              if ((xg < (- margin))) begin
                if ((SP_S_y0 <  230.258509299405)) begin
                end
                else begin
                end
              end
              else begin
                if (((- SP_S_xbar) > -230.258509299405)) begin
                end
                else begin
                end
                if ((SP_S_x0 <  230.258509299405)) begin
                end
                else begin
                  if ((SP_S_x0 > (xn_s -  230.258509299405))) begin
                  end
                  else begin
                  end
                end
              end
            end
            if ((xg <=  0.0)) begin
            end
            else begin
              if ((x_s <  230.258509299405)) begin
              end
              else begin
                if ((x_s > (xn_s -  230.258509299405))) begin
                end
                else begin
                end
              end
              if ((x_s <  10.0e-6)) begin
              end
              else begin
              end
              if ((Ds >  100.0e-102)) begin
                if ((__RSB_i <  0.0)) begin
                end
                else begin
                end
                if ((__RSG_i <  0.0)) begin
                end
                else begin
                end
                if ((__THESATB_i <  0.0)) begin
                end
                else begin
                end
                if ((__THESATG_i <  0.0)) begin
                end
                else begin
                end
                if ((__CHNL_TYPE == -1)) begin
                end
              end
              else begin
              end
              if ((Udse <  460.517018598809)) begin
              end
              else begin
              end
              if ((abs(xg) <= margin)) begin
              end
              else begin
                if ((SP_S_x0 <  230.258509299405)) begin
                end
                else begin
                  if ((SP_S_x0 > (xn_d -  230.258509299405))) begin
                  end
                  else begin
                  end
                end
              end
              if ((x_ds <  100.0e-12)) begin
              end
              if ((x_d <  230.258509299405)) begin
                if ((x_d <  10.0e-6)) begin
                end
                else begin
                end
              end
              else begin
                if ((x_d > (xn_d -  230.258509299405))) begin
                end
                else begin
                end
              end
              if ((temp >  0.0)) begin
              end
              if ((x_m <  10.0e-6)) begin
                if ((__kp >  0.0)) begin
                end
              end
              else begin
                if ((__kp >  0.0)) begin
                end
              end
              if ((__RSG_i <  0.0)) begin
              end
              else begin
              end
              if ((__THESATG_i <  0.0)) begin
              end
              else begin
              end
              if ((__CHNL_TYPE == -1)) begin
              end
            end
          end
          else begin
            __Vgb1_ac = Vgb1_dc;
            __xg_ac = xg_dc;
            __qeff1_ac = __qeff1_dc;
            __Voxm_ac = __Voxm_dc;
            __alpha_ac = alpha_dc;
            __dps_ac = dps_dc;
            __qim_ac = qim_dc;
            __GdL_ac = __GdL_dc;
            __H_ac = H_dc;
            eta_p_ac = __eta_p_dc;
            Gvsat_ac = __Gvsat_dc;
            Gmob_dL_ac = __Gmob_dL_dc;
            __Gf_ac = __Gf_dc;
            Vgsinr_ac = Vgsinr_dc;
            Vsginr_ac = Vsginr_dc;
            Vgdinr_ac = Vgdinr_dc;
            Vdginr_ac = Vdginr_dc;
            __x_m_ac = __x_m_dc;
            __xgm_ac = __xgm_dc;
            __thesat1_ac = __thesat1_dc;
            __margin_ac = __margin_dc;
          end
        end
        COX_qm = __COX_i;
        if ((__qq >  0.0)) begin
          COX_qm = (__COX_i / ((__qq * pow(((__qeff1_ac * __qeff1_ac) + __qlim2), -0.166666666666667)) +  1.0));
        end
        if ((__xg_ac <=  0.0)) begin
          __QG = __Voxm_ac;
          __QI =  0.0;
          __QD =  0.0;
          __QB = __QG;
        end
        else begin
          __Fj = ((__dps_ac / __H_ac) *  0.5);
          __Fj2 = (__Fj * __Fj);
          __QG = (__Voxm_ac + (((eta_p_ac * __dps_ac) * ((((__Fj * __GdL_ac) *  0.333333333333333) -  1.0) + __GdL_ac)) *  0.5));
          temp = ((__alpha_ac * __dps_ac) *  0.166666666666667);
          if (0) begin
          end
          else begin
            __QCLM = (( 1.0 - __GdL_ac) * (__qim_ac - ((__alpha_ac * __dps_ac) *  0.5)));
            __QD = ((((__GdL_ac * __GdL_ac) * (__qim_ac - (temp * (( 1.0 - __Fj) - (__Fj2 *  0.2))))) + (__QCLM * (__GdL_ac +  1.0))) *  0.5);
          end
          __QI = ((__GdL_ac * (__qim_ac + (temp * __Fj))) + __QCLM);
          __QB = (__QG - __QI);
        end
        __Qg = (__QG * COX_qm);
        __Qd = ((- __QD) * COX_qm);
        __Qb = ((- __QB) * COX_qm);
        __Qsinr =  0.0;
        __Qdinr =  0.0;
        __Qginr =  0.0;
        if (((__CINR_i >  0.0) || (__CINRD_i >  0.0))) begin
          finracc =  1.0;
          dVinracc = __Vgb1_ac;
          if ((__FCINRACC_i >  100.0e-12)) begin
            Vginr = ((__Vgb1_ac - __DVFBINR_i) + __Vinr_max);
            temp = (((Vginr + __Vinr_max) + sqrt((((Vginr - __Vinr_max) * (Vginr - __Vinr_max)) + __ainr))) *  0.5);
            temp1 = (temp * (((temp *  2.0) - __Vinr_max) - Vginr));
            temp2 = (__Vinr_max / temp);
            Vginreff = (Vginr * temp2);
            fqinr = sqrt(( 1.0 - (Vginreff * __FCINRACC_i)));
            dVinracc = (((( 1.0 - fqinr) / __FCINRACC_i) + Vginr) - Vginreff);
            finracc = (((((( 0.5 / fqinr) -  1.0) * (temp1 + (Vginr * (__Vinr_max - temp)))) * temp2) / temp1) +  1.0);
          end
          finrdep =  1.0;
          dVinrdep =  0.0;
          if ((__FCINRDEP_i >  0.0)) begin
            temp = ((__phib_ac *  0.5) + (phit1 * ((__Gf_ac *  0.707106781186547) +  1.0)));
            xginrdep = (__Vgb1_ac / temp);
            if ((abs(xginrdep) <  230.258509299405)) begin
              finrdep = ( 1.0 / (exp((- xginrdep)) +  1.0));
            end
            else begin
              if ((xginrdep <  0.0)) begin
                finrdep = ( 100.0e-102 / (((xginrdep + -230.258509299405) * ((((xginrdep + -230.258509299405) * (((xginrdep + -230.258509299405) *  0.333333333333333) +  1.0)) *  0.5) +  1.0)) +  1.0));
              end
            end
            if ((xginrdep <  230.258509299405)) begin
              temp1 = ln((exp(xginrdep) +  1.0));
            end
            else begin
              temp1 = xginrdep;
            end
            dVinrdep = (temp * temp1);
          end
          finr = ((__FCINRDEP_i * (finrdep - finracc)) + finracc);
          dVinr = ((__FCINRDEP_i * (dVinrdep - dVinracc)) + dVinracc);
          if ((sigVds >  0.0)) begin
            __Qginr = (finr * ((__CINRD_i * Vgdinr_ac) + (__CINR_i * Vgsinr_ac)));
            __Qsinr = (__CINR_i * (Vsginr_ac - dVinr));
            __Qdinr = (__CINRD_i * (Vdginr_ac - dVinr));
          end
          else begin
            __Qginr = (finr * ((__CINR_i * Vgdinr_ac) + (__CINRD_i * Vgsinr_ac)));
            __Qsinr = (__CINRD_i * (Vsginr_ac - dVinr));
            __Qdinr = (__CINR_i * (Vdginr_ac - dVinr));
          end
          __Qg = (__Qg + __Qginr);
          __Qd = (__Qd + __Qdinr);
          __Qb = (((__Qb - __Qginr) - __Qdinr) - __Qsinr);
        end
        __Qgs_ov = (__CGOV_i * __Vovs);
        __Qgd_ov = (__CGOVD_i * __Vovd);
        __Qg_ov_s =  0.0;
        yb_ov_s =  0.0;
        if (((__CGOV_i >  0.0) && (__FCGOVACC_i >  0.0))) begin
          temp = (__CGOVACCG_i * ((__xgb_ov *  0.5) + __dxgb_ov_s));
          if ((temp <  230.258509299405)) begin
            if ((temp > -230.258509299405)) begin
              yb_ov_s = exp(temp);
            end
            else begin
              yb_ov_s = ( 100.0e-102 / (((-230.258509299405 - temp) * ((((-230.258509299405 - temp) * (((-230.258509299405 - temp) *  0.333333333333333) +  1.0)) *  0.5) +  1.0)) +  1.0));
            end
            if ((yb_ov_s >  100.0e-12)) begin
              xgbeff_ov_s = ln((yb_ov_s +  1.0));
              temp1 = (xgbeff_ov_s * ( 1.0 - (ln((xgbeff_ov_s +  1.0)) / (xgbeff_ov_s +  2.0))));
            end
            else begin
              xgbeff_ov_s = yb_ov_s;
              temp1 = ((xgbeff_ov_s *  2.0) / (xgbeff_ov_s +  2.0));
            end
          end
          else begin
            xgbeff_ov_s = temp;
            temp1 = (xgbeff_ov_s * ( 1.0 - (ln((xgbeff_ov_s +  1.0)) / (xgbeff_ov_s +  2.0))));
          end
          __Qg_ov_s = (((((__FCGOVACC_i * -2.0) / __CGOVACCG_i) * __CGOV_i) * __phita) * temp1);
        end
        __Qg_ov_d =  0.0;
        yb_ov_d =  0.0;
        if (((__CGOVD_i >  0.0) && (__FCGOVACCD_i >  0.0))) begin
          temp = (__CGOVACCG_i * ((__xgb_ov *  0.5) + __dxgb_ov_d));
          if ((temp <  230.258509299405)) begin
            if ((temp > -230.258509299405)) begin
              yb_ov_d = exp(temp);
            end
            else begin
              yb_ov_d = ( 100.0e-102 / (((-230.258509299405 - temp) * ((((-230.258509299405 - temp) * (((-230.258509299405 - temp) *  0.333333333333333) +  1.0)) *  0.5) +  1.0)) +  1.0));
            end
            if ((yb_ov_d >  100.0e-12)) begin
              xgbeff_ov_d = ln((yb_ov_d +  1.0));
              temp1 = (xgbeff_ov_d * ( 1.0 - (ln((xgbeff_ov_d +  1.0)) / (xgbeff_ov_d +  2.0))));
            end
            else begin
              xgbeff_ov_d = yb_ov_d;
              temp1 = ((xgbeff_ov_d *  2.0) / (xgbeff_ov_d +  2.0));
            end
          end
          else begin
            xgbeff_ov_d = temp;
            temp1 = (xgbeff_ov_d * ( 1.0 - (ln((xgbeff_ov_d +  1.0)) / (xgbeff_ov_d +  2.0))));
          end
          __Qg_ov_d = (((((__FCGOVACCD_i * -2.0) / __CGOVACCG_i) * __CGOVD_i) * __phita) * temp1);
        end
        __Qg_ov = (__Qg_ov_s + __Qg_ov_d);
        __Qgb_ov = ((__CGBOV_i * __Vgb) + __Qg_ov);
        __Qfgs = (__CFR_i * __VgsPrime);
        __Qfgd = (__CFRD_i * __VgdPrime);
        __Gp =  0.0;
        __Gp2 =  0.0;
        __a_factrp =  0.0;
        __marginp =  0.0;
        if ((__SWNQS_i != 0)) begin
          if ((__xg_ac <=  0.0)) begin
            __ym =  0.5;
            __pd =  1.0;
            __Gp = __Gf_ac;
          end
          else begin
            __ym = ((((__dps_ac / __H_ac) *  0.25) +  1.0) *  0.5);
            __pd = (__xgm_ac / (__xg_ac - __x_m_ac));
            __Gp = (__Gf_ac / __pd);
          end
          __Gp2 = (__Gp * __Gp);
          __a_factrp = ((__Gp *  0.707106781186547) +  1.0);
          __marginp = (__a_factrp *  10.0e-6);
        end
      end
      begin : evaluateStaticDynamic
        real ysq, terfc, erfcpos;
        real h1, h2, h2d, h3, h4, h5;
        real idmult, vj, z, zinv, two_psistar, vjlim, vjsrh, vbbt, vav;
        real tmp, id;
        real isrh, vbi_minus_vjsrh, wsrhstep, dwsrh, wsrh, wdep, asrh;
        real itat, btat, twoatatoverthreebtat, umaxbeforelimiting, umax, sqrtumax, umaxpoweronepointfive;
        real wgamma, wtat, ktat, ltat, mtat, xerfc, erfctimesexpmtat, gammamax;
        real ibbt, Fmaxr;
        real fbreakdown;
        ysq =  0.0;
        terfc =  0.0;
        erfcpos =  0.0;
        h1 =  0.0;
        h2 =  0.0;
        h2d =  0.0;
        h3 =  0.0;
        h4 =  0.0;
        h5 =  0.0;
        idmult =  0.0;
        vj =  0.0;
        z =  0.0;
        zinv =  0.0;
        two_psistar =  0.0;
        vjlim =  0.0;
        vjsrh =  0.0;
        vbbt =  0.0;
        vav =  0.0;
        tmp =  0.0;
        id =  0.0;
        isrh =  0.0;
        vbi_minus_vjsrh =  0.0;
        wsrhstep =  0.0;
        dwsrh =  0.0;
        wsrh =  0.0;
        wdep =  0.0;
        asrh =  0.0;
        itat =  0.0;
        btat =  0.0;
        twoatatoverthreebtat =  0.0;
        umaxbeforelimiting =  0.0;
        umax =  0.0;
        sqrtumax =  0.0;
        umaxpoweronepointfive =  0.0;
        wgamma =  0.0;
        wtat =  0.0;
        ktat =  0.0;
        ltat =  0.0;
        mtat =  0.0;
        xerfc =  0.0;
        erfctimesexpmtat =  0.0;
        gammamax =  0.0;
        ibbt =  0.0;
        Fmaxr =  0.0;
        fbreakdown =  0.0;
        ijun_s =  0.0;
        ijunbot_s =  0.0;
        ijunsti_s =  0.0;
        ijungat_s =  0.0;
        ijun_d =  0.0;
        ijunbot_d =  0.0;
        ijunsti_d =  0.0;
        ijungat_d =  0.0;
        qjun_s =  0.0;
        qjunbot_s =  0.0;
        qjunsti_s =  0.0;
        qjungat_s =  0.0;
        qjun_d =  0.0;
        qjunbot_d =  0.0;
        qjunsti_d =  0.0;
        qjungat_d =  0.0;
        if (1) begin
          if ((__SWJUNEXP_i == 1)) begin
            __tm0 = ((__Vjun_s * __phitdinv) * __MFOR1_s);
            __tm1 = (((__tm0 < -230.258509299405))? (( 100.0e-102 / (-229.258509299405 - __tm0))):((((__tm0 > __xhighf1_s))? ((__expxhf1_s * ((__tm0 - __xhighf1_s) +  1.0))):(exp(__tm0)))));
            __ijunfor1 = (__ISATFOR1_s * (__tm1 -  1.0));
            __tm0 = ((__Vjun_s * __phitdinv) * __MFOR2_s);
            __tm1 = (((__tm0 < -230.258509299405))? (( 100.0e-102 / (-229.258509299405 - __tm0))):((((__tm0 > __xhighf2_s))? ((__expxhf2_s * ((__tm0 - __xhighf2_s) +  1.0))):(exp(__tm0)))));
            __ijunfor2 = (__ISATFOR2_s * (__tm1 -  1.0));
            __ijunrev =  0.0;
            if ((__m0flag_s >  0.0)) begin
              __ijunrev = (__Vjun_s * (__ISATREV_s + (__Vjun_s * __MREV_s)));
            end
            else begin
              __tm0 = (((- __Vjun_s) * __phitdinv) * __MREV_s);
              __tm1 = (((__tm0 < -230.258509299405))? (( 100.0e-102 / (-229.258509299405 - __tm0))):((((__tm0 > __xhighr_s))? ((__expxhr_s * ((__tm0 - __xhighr_s) +  1.0))):(exp(__tm0)))));
              __ijunrev = ((- __ISATREV_s) * (__tm1 -  1.0));
            end
            ijun_s = ((__ijunfor1 + __ijunfor2) + __ijunrev);
            __tm0 = ((__Vjun_d * __phitdinv) * __MFOR1_d);
            __tm1 = (((__tm0 < -230.258509299405))? (( 100.0e-102 / (-229.258509299405 - __tm0))):((((__tm0 > __xhighf1_d))? ((__expxhf1_d * ((__tm0 - __xhighf1_d) +  1.0))):(exp(__tm0)))));
            __ijunfor1 = (__ISATFOR1_d * (__tm1 -  1.0));
            __tm0 = ((__Vjun_d * __phitdinv) * __MFOR2_d);
            __tm1 = (((__tm0 < -230.258509299405))? (( 100.0e-102 / (-229.258509299405 - __tm0))):((((__tm0 > __xhighf2_d))? ((__expxhf2_d * ((__tm0 - __xhighf2_d) +  1.0))):(exp(__tm0)))));
            __ijunfor2 = (__ISATFOR2_d * (__tm1 -  1.0));
            __ijunrev =  0.0;
            if ((__m0flag_d >  0.0)) begin
              __ijunrev = (__Vjun_d * (__ISATREV_d + (__Vjun_d * __MREV_d)));
            end
            else begin
              __tm0 = (((- __Vjun_d) * __phitdinv) * __MREV_d);
              __tm1 = (((__tm0 < -230.258509299405))? (( 100.0e-102 / (-229.258509299405 - __tm0))):((((__tm0 > __xhighr_d))? ((__expxhr_d * ((__tm0 - __xhighr_d) +  1.0))):(exp(__tm0)))));
              __ijunrev = ((- __ISATREV_d) * (__tm1 -  1.0));
            end
            ijun_d = ((__ijunfor1 + __ijunfor2) + __ijunrev);
            begin : evaluateDynamic
              real tmpv, vjv;
              tmpv =  0.0;
              vjv =  0.0;
              h1 = ((__vch_s *  4.0) * __vch_s);
              h2 = (__vch_s / __vfmin_s);
              h2d = (__Vjun_s + (__vch_s * h2));
              h3 = (__vfmin_s + h2d);
              h4 = (__vfmin_s - h2d);
              h5 = sqrt(((h4 * h4) + h1));
              vjv = (((__Vjun_s * __vfmin_s) / (h3 + h5)) *  2.0);
              if ((__zflagbot_s >  0.5)) begin
                if ((__one_minus_PBOT ==  0.5)) begin
                  tmpv = sqrt(( 1.0 - (vjv * __vbiinvbot)));
                end
                else begin
                  tmpv = pow(( 1.0 - (vjv * __vbiinvbot)), __one_minus_PBOT);
                end
                qjunbot_s = ((__qprefbot * ( 1.0 - tmpv)) + (__qpref2bot * (__Vjun_s - vjv)));
              end
              if ((__zflagsti_s >  0.5)) begin
                if ((__one_minus_PSTI ==  0.5)) begin
                  tmpv = sqrt(( 1.0 - (vjv * __vbiinvsti)));
                end
                else begin
                  tmpv = pow(( 1.0 - (vjv * __vbiinvsti)), __one_minus_PSTI);
                end
                qjunsti_s = ((__qprefsti * ( 1.0 - tmpv)) + (__qpref2sti * (__Vjun_s - vjv)));
              end
              if ((__zflaggat_s >  0.5)) begin
                if ((__one_minus_PGAT ==  0.5)) begin
                  tmpv = sqrt(( 1.0 - (vjv * __vbiinvgat)));
                end
                else begin
                  tmpv = pow(( 1.0 - (vjv * __vbiinvgat)), __one_minus_PGAT);
                end
                qjungat_s = ((__qprefgat * ( 1.0 - tmpv)) + (__qpref2gat * (__Vjun_s - vjv)));
              end
              tmpv =  0.0;
              vjv =  0.0;
              h1 = ((__vch_d *  4.0) * __vch_d);
              h2 = (__vch_d / __vfmin_d);
              h2d = (__Vjun_d + (__vch_d * h2));
              h3 = (__vfmin_d + h2d);
              h4 = (__vfmin_d - h2d);
              h5 = sqrt(((h4 * h4) + h1));
              vjv = (((__Vjun_d * __vfmin_d) / (h3 + h5)) *  2.0);
              if ((__zflagbot_d >  0.5)) begin
                if ((__one_minus_PBOT_d ==  0.5)) begin
                  tmpv = sqrt(( 1.0 - (vjv * __vbiinvbot_d)));
                end
                else begin
                  tmpv = pow(( 1.0 - (vjv * __vbiinvbot_d)), __one_minus_PBOT_d);
                end
                qjunbot_d = ((__qprefbot_d * ( 1.0 - tmpv)) + (__qpref2bot_d * (__Vjun_d - vjv)));
              end
              if ((__zflagsti_d >  0.5)) begin
                if ((__one_minus_PSTI_d ==  0.5)) begin
                  tmpv = sqrt(( 1.0 - (vjv * __vbiinvsti_d)));
                end
                else begin
                  tmpv = pow(( 1.0 - (vjv * __vbiinvsti_d)), __one_minus_PSTI_d);
                end
                qjunsti_d = ((__qprefsti_d * ( 1.0 - tmpv)) + (__qpref2sti_d * (__Vjun_d - vjv)));
              end
              if ((__zflaggat_d >  0.5)) begin
                if ((__one_minus_PGAT_d ==  0.5)) begin
                  tmpv = sqrt(( 1.0 - (vjv * __vbiinvgat_d)));
                end
                else begin
                  tmpv = pow(( 1.0 - (vjv * __vbiinvgat_d)), __one_minus_PGAT_d);
                end
                qjungat_d = ((__qprefgat_d * ( 1.0 - tmpv)) + (__qpref2gat_d * (__Vjun_d - vjv)));
              end
            end
          end
          else begin
            vbbt =  0.0;
            two_psistar =  0.0;
            if ((! (((__ABSOURCE_i ==  0.0) && (__LSSOURCE_i ==  0.0)) && (__LGSOURCE_i ==  0.0)))) begin
              h1 = ((__vch_s *  4.0) * __vch_s);
              h2 = (__vch_s / __vfmin_s);
              h2d = (__Vjun_s + (__vch_s * h2));
              h3 = (__vfmin_s + h2d);
              h4 = (__vfmin_s - h2d);
              h5 = sqrt(((h4 * h4) + h1));
              vj = (((__Vjun_s * __vfmin_s) / (h3 + h5)) *  2.0);
              if ((__Vjun_s < __VMAX_s)) begin
                if ((abs(((__Vjun_s * __phitdinv) *  0.5)) <  230.258509299405)) begin
                  zinv = exp(((__Vjun_s * __phitdinv) *  0.5));
                end
                else begin
                  if ((((__Vjun_s * __phitdinv) *  0.5) <  0.0)) begin
                    zinv = ( 100.0e-102 / (((-230.258509299405 - ((__Vjun_s * __phitdinv) *  0.5)) * ((((-230.258509299405 - ((__Vjun_s * __phitdinv) *  0.5)) * (((-230.258509299405 - ((__Vjun_s * __phitdinv) *  0.5)) *  0.333333333333333) +  1.0)) *  0.5) +  1.0)) +  1.0));
                  end
                  else begin
                    zinv = ((((((__Vjun_s * __phitdinv) *  0.5) -  230.258509299405) * ((((((__Vjun_s * __phitdinv) *  0.5) -  230.258509299405) * (((((__Vjun_s * __phitdinv) *  0.5) -  230.258509299405) *  0.333333333333333) +  1.0)) *  0.5) +  1.0)) +  1.0) *  10.0e+99);
                  end
                end
                idmult = (zinv * zinv);
              end
              else begin
                idmult = ((((__Vjun_s - __VMAX_s) * __phitdinv) +  1.0) * __exp_VMAX_over_phitd_s);
                zinv = sqrt(idmult);
              end
              idmult = (idmult -  1.0);
              z = ( 1.0 / zinv);
              if ((__Vjun_s >  0.0)) begin
                two_psistar = ((__phitd * ln(((z +  2.0) + sqrt(((z +  1.0) * (z +  3.0)))))) *  2.0);
              end
              else begin
                two_psistar = ((- __Vjun_s) + ((__phitd * ln((((zinv *  2.0) +  1.0) + sqrt(((zinv +  1.0) * ((zinv *  3.0) +  1.0)))))) *  2.0));
              end
              vjlim = (__vbimin_s - two_psistar);
              vjsrh = (((__Vjun_s + vjlim) - sqrt((((__Vjun_s - vjlim) * (__Vjun_s - vjlim)) + ((__phitd *  4.0) * __phitd)))) *  0.5);
              vbbt = (((__Vjun_s + __vbbtlim_s) - sqrt((((__Vjun_s - __vbbtlim_s) * (__Vjun_s - __vbbtlim_s)) + ((__phitr *  4.0) * __phitr)))) *  0.5);
              vav = ((__Vjun_s - sqrt(((__Vjun_s * __Vjun_s) +  4.0e-12))) *  0.5);
            end
            if ((__ABSOURCE_i ==  0.0)) begin
              ijunbot_s =  0.0;
              qjunbot_s =  0.0;
            end
            else begin
              if ((__one_minus_PBOT ==  0.5)) begin
                tmp = sqrt(( 1.0 - (vj * __vbiinvbot)));
              end
              else begin
                tmp = pow(( 1.0 - (vj * __vbiinvbot)), __one_minus_PBOT);
              end
              qjunbot_s = ((__qprefbot * ( 1.0 - tmp)) + (__qpref2bot * (__Vjun_s - vj)));
              id = (__idsatbot * idmult);
              if (0) begin
              end
              else begin
                vbi_minus_vjsrh = (__vbibot - vjsrh);
                wsrhstep = ( 1.0 - sqrt(( 1.0 - (two_psistar / vbi_minus_vjsrh))));
                if (0) begin
                end
                else begin
                  dwsrh = (((((wsrhstep * wsrhstep) * ln(wsrhstep)) / ( 1.0 - wsrhstep)) + wsrhstep) *  0.2764);
                end
                wsrh = (wsrhstep + dwsrh);
                if (0) begin
                end
                else begin
                  tmp = pow((vbi_minus_vjsrh * __VBIRBOTinv),  0.3618);
                end
                wdep = (__wdepnulrbot * tmp);
                asrh = (__ftdbot * ((zinv -  1.0) * wdep));
                isrh = ((asrh * wsrh) *  100.0);
              end
              if (0) begin
              end
              else begin
                btat = (__btatpartbot * ((wdep * __one_minus_PBOT) / vbi_minus_vjsrh));
                twoatatoverthreebtat = ((__atatbot *  0.666666666666667) / btat);
                umaxbeforelimiting = (twoatatoverthreebtat * twoatatoverthreebtat);
                umax = sqrt(((umaxbeforelimiting * umaxbeforelimiting) / ((umaxbeforelimiting * umaxbeforelimiting) +  1.0)));
                sqrtumax = sqrt(umax);
                umaxpoweronepointfive = (umax * sqrtumax);
                if (((__one_over_one_minus_PBOT * -0.3618) == -1.0)) begin
                  wgamma = ( 1.0 / ((btat * umaxpoweronepointfive) +  1.0));
                end
                else begin
                  wgamma = pow(((btat * umaxpoweronepointfive) +  1.0), (__one_over_one_minus_PBOT * -0.3618));
                end
                wtat = ((wsrh * wgamma) / (wsrh + wgamma));
                ktat = sqrt(((btat / sqrtumax) *  0.375));
                ltat = (((twoatatoverthreebtat * sqrtumax) *  2.0) - umax);
                mtat = ((((__atatbot * twoatatoverthreebtat) * sqrtumax) - (__atatbot * umax)) + ((btat * umaxpoweronepointfive) *  0.5));
                xerfc = ((ltat -  1.0) * ktat);
                ysq = (xerfc * xerfc);
                if ((xerfc >  0.0)) begin
                  terfc = ( 1.0 / ((__perfc * xerfc) +  1.0));
                end
                else begin
                  terfc = ( 1.0 / ( 1.0 - (__perfc * xerfc)));
                end
                if ((((- ysq) + mtat) > -230.258509299405)) begin
                  tmp = exp(((- ysq) + mtat));
                end
                else begin
                  tmp = ( 100.0e-102 / (((-230.258509299405 - ((- ysq) + mtat)) * ((((-230.258509299405 - ((- ysq) + mtat)) * (((-230.258509299405 - ((- ysq) + mtat)) *  0.333333333333333) +  1.0)) *  0.5) +  1.0)) +  1.0));
                end
                erfcpos = ((((terfc *  0.29214664) + (__berfc * (terfc * terfc))) + (__cerfc * ((terfc * terfc) * terfc))) * tmp);
                if ((xerfc >  0.0)) begin
                  erfctimesexpmtat = erfcpos;
                end
                else begin
                  if ((mtat > -230.258509299405)) begin
                    tmp = exp(mtat);
                  end
                  else begin
                    tmp = ( 100.0e-102 / (((-230.258509299405 - mtat) * ((((-230.258509299405 - mtat) * (((-230.258509299405 - mtat) *  0.333333333333333) +  1.0)) *  0.5) +  1.0)) +  1.0));
                  end
                  erfctimesexpmtat = ((tmp *  2.0) - erfcpos);
                end
                gammamax = (((__atatbot * erfctimesexpmtat) / ktat) *  0.886226925452758);
                itat = (((asrh * gammamax) * wtat) *  100.0);
              end
              if (0) begin
              end
              else begin
                if (0) begin
                end
                else begin
                  tmp = pow((( 0.7686 - vbbt) * __VBIRBOTinv),  0.3618);
                end
                Fmaxr = (__one_over_one_minus_PBOT * ((( 0.7686 - vbbt) * __wdepnulrinvbot) / tmp));
                if ((abs(((- __fbbtbot) / Fmaxr)) <  230.258509299405)) begin
                  tmp = exp(((- __fbbtbot) / Fmaxr));
                end
                else begin
                  if ((((- __fbbtbot) / Fmaxr) <  0.0)) begin
                    tmp = ( 100.0e-102 / (((-230.258509299405 - ((- __fbbtbot) / Fmaxr)) * ((((-230.258509299405 - ((- __fbbtbot) / Fmaxr)) * (((-230.258509299405 - ((- __fbbtbot) / Fmaxr)) *  0.333333333333333) +  1.0)) *  0.5) +  1.0)) +  1.0));
                  end
                  else begin
                    tmp = ((((((- __fbbtbot) / Fmaxr) -  230.258509299405) * ((((((- __fbbtbot) / Fmaxr) -  230.258509299405) * (((((- __fbbtbot) / Fmaxr) -  230.258509299405) *  0.333333333333333) +  1.0)) *  0.5) +  1.0)) +  1.0) *  10.0e+99);
                  end
                end
                ibbt = ((((__Vjun_s * Fmaxr) * Fmaxr) * tmp) *  1.0e-12);
              end
              if (0) begin
              end
              else begin
                if ((vav > ((- __alphaav) *  10.0))) begin
                  if (1) begin
                    tmp = ((((vav * __VBRinvbot) * (vav * __VBRinvbot)) * (vav * __VBRinvbot)) * (vav * __VBRinvbot));
                  end
                  else begin
                  end
                  fbreakdown = ( 1.0 / ( 1.0 - tmp));
                end
                else begin
                  fbreakdown = (__fstopbot + ((vav + (__alphaav *  10.0)) * __slopebot));
                end
              end
              ijunbot_s = ((((id + isrh) + itat) + ibbt) * fbreakdown);
            end
            if ((__LSSOURCE_i ==  0.0)) begin
              ijunsti_s =  0.0;
              qjunsti_s =  0.0;
            end
            else begin
              if ((__one_minus_PSTI ==  0.5)) begin
                tmp = sqrt(( 1.0 - (vj * __vbiinvsti)));
              end
              else begin
                tmp = pow(( 1.0 - (vj * __vbiinvsti)), __one_minus_PSTI);
              end
              qjunsti_s = ((__qprefsti * ( 1.0 - tmp)) + (__qpref2sti * (__Vjun_s - vj)));
              id = (__idsatsti * idmult);
              if (0) begin
              end
              else begin
                vbi_minus_vjsrh = (__vbisti - vjsrh);
                wsrhstep = ( 1.0 - sqrt(( 1.0 - (two_psistar / vbi_minus_vjsrh))));
                if (0) begin
                end
                else begin
                  dwsrh = (((((wsrhstep * wsrhstep) * ln(wsrhstep)) / ( 1.0 - wsrhstep)) + wsrhstep) *  0.4904);
                end
                wsrh = (wsrhstep + dwsrh);
                if (0) begin
                end
                else begin
                  tmp = pow((vbi_minus_vjsrh * __VBIRSTIinv),  0.2548);
                end
                wdep = (__wdepnulrsti * tmp);
                asrh = (__ftdsti * ((zinv -  1.0) * wdep));
                isrh = ((asrh * wsrh) *  100.0e-6);
              end
              if (0) begin
              end
              else begin
                btat = (__btatpartsti * ((wdep * __one_minus_PSTI) / vbi_minus_vjsrh));
                twoatatoverthreebtat = ((__atatsti *  0.666666666666667) / btat);
                umaxbeforelimiting = (twoatatoverthreebtat * twoatatoverthreebtat);
                umax = sqrt(((umaxbeforelimiting * umaxbeforelimiting) / ((umaxbeforelimiting * umaxbeforelimiting) +  1.0)));
                sqrtumax = sqrt(umax);
                umaxpoweronepointfive = (umax * sqrtumax);
                if (((__one_over_one_minus_PSTI * -0.2548) == -1.0)) begin
                  wgamma = ( 1.0 / ((btat * umaxpoweronepointfive) +  1.0));
                end
                else begin
                  wgamma = pow(((btat * umaxpoweronepointfive) +  1.0), (__one_over_one_minus_PSTI * -0.2548));
                end
                wtat = ((wsrh * wgamma) / (wsrh + wgamma));
                ktat = sqrt(((btat / sqrtumax) *  0.375));
                ltat = (((twoatatoverthreebtat * sqrtumax) *  2.0) - umax);
                mtat = ((((__atatsti * twoatatoverthreebtat) * sqrtumax) - (__atatsti * umax)) + ((btat * umaxpoweronepointfive) *  0.5));
                xerfc = ((ltat -  1.0) * ktat);
                ysq = (xerfc * xerfc);
                if ((xerfc >  0.0)) begin
                  terfc = ( 1.0 / ((__perfc * xerfc) +  1.0));
                end
                else begin
                  terfc = ( 1.0 / ( 1.0 - (__perfc * xerfc)));
                end
                if ((((- ysq) + mtat) > -230.258509299405)) begin
                  tmp = exp(((- ysq) + mtat));
                end
                else begin
                  tmp = ( 100.0e-102 / (((-230.258509299405 - ((- ysq) + mtat)) * ((((-230.258509299405 - ((- ysq) + mtat)) * (((-230.258509299405 - ((- ysq) + mtat)) *  0.333333333333333) +  1.0)) *  0.5) +  1.0)) +  1.0));
                end
                erfcpos = ((((terfc *  0.29214664) + (__berfc * (terfc * terfc))) + (__cerfc * ((terfc * terfc) * terfc))) * tmp);
                if ((xerfc >  0.0)) begin
                  erfctimesexpmtat = erfcpos;
                end
                else begin
                  if ((mtat > -230.258509299405)) begin
                    tmp = exp(mtat);
                  end
                  else begin
                    tmp = ( 100.0e-102 / (((-230.258509299405 - mtat) * ((((-230.258509299405 - mtat) * (((-230.258509299405 - mtat) *  0.333333333333333) +  1.0)) *  0.5) +  1.0)) +  1.0));
                  end
                  erfctimesexpmtat = ((tmp *  2.0) - erfcpos);
                end
                gammamax = (((__atatsti * erfctimesexpmtat) / ktat) *  0.886226925452758);
                itat = (((asrh * gammamax) * wtat) *  100.0e-6);
              end
              if (0) begin
              end
              else begin
                if (0) begin
                end
                else begin
                  tmp = pow((( 1.7036 - vbbt) * __VBIRSTIinv),  0.2548);
                end
                Fmaxr = (__one_over_one_minus_PSTI * ((( 1.7036 - vbbt) * __wdepnulrinvsti) / tmp));
                if ((abs(((- __fbbtsti) / Fmaxr)) <  230.258509299405)) begin
                  tmp = exp(((- __fbbtsti) / Fmaxr));
                end
                else begin
                  if ((((- __fbbtsti) / Fmaxr) <  0.0)) begin
                    tmp = ( 100.0e-102 / (((-230.258509299405 - ((- __fbbtsti) / Fmaxr)) * ((((-230.258509299405 - ((- __fbbtsti) / Fmaxr)) * (((-230.258509299405 - ((- __fbbtsti) / Fmaxr)) *  0.333333333333333) +  1.0)) *  0.5) +  1.0)) +  1.0));
                  end
                  else begin
                    tmp = ((((((- __fbbtsti) / Fmaxr) -  230.258509299405) * ((((((- __fbbtsti) / Fmaxr) -  230.258509299405) * (((((- __fbbtsti) / Fmaxr) -  230.258509299405) *  0.333333333333333) +  1.0)) *  0.5) +  1.0)) +  1.0) *  10.0e+99);
                  end
                end
                ibbt = ((((__Vjun_s * Fmaxr) * Fmaxr) * tmp) *  1.0e-21);
              end
              if (0) begin
              end
              else begin
                if ((vav > ((- __alphaav) *  10.0))) begin
                  if (1) begin
                    tmp = ((((vav * __VBRinvsti) * (vav * __VBRinvsti)) * (vav * __VBRinvsti)) * (vav * __VBRinvsti));
                  end
                  else begin
                  end
                  fbreakdown = ( 1.0 / ( 1.0 - tmp));
                end
                else begin
                  fbreakdown = (__fstopsti + ((vav + (__alphaav *  10.0)) * __slopesti));
                end
              end
              ijunsti_s = ((((id + isrh) + itat) + ibbt) * fbreakdown);
            end
            if ((__LGSOURCE_i ==  0.0)) begin
              ijungat_s =  0.0;
              qjungat_s =  0.0;
            end
            else begin
              if ((__one_minus_PGAT ==  0.5)) begin
                tmp = sqrt(( 1.0 - (vj * __vbiinvgat)));
              end
              else begin
                tmp = pow(( 1.0 - (vj * __vbiinvgat)), __one_minus_PGAT);
              end
              qjungat_s = ((__qprefgat * ( 1.0 - tmp)) + (__qpref2gat * (__Vjun_s - vj)));
              id = (__idsatgat * idmult);
              if (0) begin
              end
              else begin
                vbi_minus_vjsrh = (__vbigat - vjsrh);
                wsrhstep = ( 1.0 - sqrt(( 1.0 - (two_psistar / vbi_minus_vjsrh))));
                if (0) begin
                end
                else begin
                  dwsrh = (((((wsrhstep * wsrhstep) * ln(wsrhstep)) / ( 1.0 - wsrhstep)) + wsrhstep) * -0.295);
                end
                wsrh = (wsrhstep + dwsrh);
                if (0) begin
                end
                else begin
                  tmp = pow((vbi_minus_vjsrh * __VBIRGATinv),  0.6475);
                end
                wdep = (__wdepnulrgat * tmp);
                asrh = (__ftdgat * ((zinv -  1.0) * wdep));
                isrh = ((asrh * wsrh) *  100.0e-6);
              end
              if (0) begin
              end
              else begin
                btat = (__btatpartgat * ((wdep * __one_minus_PGAT) / vbi_minus_vjsrh));
                twoatatoverthreebtat = ((__atatgat *  0.666666666666667) / btat);
                umaxbeforelimiting = (twoatatoverthreebtat * twoatatoverthreebtat);
                umax = sqrt(((umaxbeforelimiting * umaxbeforelimiting) / ((umaxbeforelimiting * umaxbeforelimiting) +  1.0)));
                sqrtumax = sqrt(umax);
                umaxpoweronepointfive = (umax * sqrtumax);
                if (((__one_over_one_minus_PGAT * -0.6475) == -1.0)) begin
                  wgamma = ( 1.0 / ((btat * umaxpoweronepointfive) +  1.0));
                end
                else begin
                  wgamma = pow(((btat * umaxpoweronepointfive) +  1.0), (__one_over_one_minus_PGAT * -0.6475));
                end
                wtat = ((wsrh * wgamma) / (wsrh + wgamma));
                ktat = sqrt(((btat / sqrtumax) *  0.375));
                ltat = (((twoatatoverthreebtat * sqrtumax) *  2.0) - umax);
                mtat = ((((__atatgat * twoatatoverthreebtat) * sqrtumax) - (__atatgat * umax)) + ((btat * umaxpoweronepointfive) *  0.5));
                xerfc = ((ltat -  1.0) * ktat);
                ysq = (xerfc * xerfc);
                if ((xerfc >  0.0)) begin
                  terfc = ( 1.0 / ((__perfc * xerfc) +  1.0));
                end
                else begin
                  terfc = ( 1.0 / ( 1.0 - (__perfc * xerfc)));
                end
                if ((((- ysq) + mtat) > -230.258509299405)) begin
                  tmp = exp(((- ysq) + mtat));
                end
                else begin
                  tmp = ( 100.0e-102 / (((-230.258509299405 - ((- ysq) + mtat)) * ((((-230.258509299405 - ((- ysq) + mtat)) * (((-230.258509299405 - ((- ysq) + mtat)) *  0.333333333333333) +  1.0)) *  0.5) +  1.0)) +  1.0));
                end
                erfcpos = ((((terfc *  0.29214664) + (__berfc * (terfc * terfc))) + (__cerfc * ((terfc * terfc) * terfc))) * tmp);
                if ((xerfc >  0.0)) begin
                  erfctimesexpmtat = erfcpos;
                end
                else begin
                  if ((mtat > -230.258509299405)) begin
                    tmp = exp(mtat);
                  end
                  else begin
                    tmp = ( 100.0e-102 / (((-230.258509299405 - mtat) * ((((-230.258509299405 - mtat) * (((-230.258509299405 - mtat) *  0.333333333333333) +  1.0)) *  0.5) +  1.0)) +  1.0));
                  end
                  erfctimesexpmtat = ((tmp *  2.0) - erfcpos);
                end
                gammamax = (((__atatgat * erfctimesexpmtat) / ktat) *  0.886226925452758);
                itat = (((asrh * gammamax) * wtat) *  100.0e-6);
              end
              if (0) begin
              end
              else begin
                if (0) begin
                end
                else begin
                  tmp = pow((( 1.399 - vbbt) * __VBIRGATinv),  0.6475);
                end
                Fmaxr = (__one_over_one_minus_PGAT * ((( 1.399 - vbbt) * __wdepnulrinvgat) / tmp));
                if ((abs(((- __fbbtgat) / Fmaxr)) <  230.258509299405)) begin
                  tmp = exp(((- __fbbtgat) / Fmaxr));
                end
                else begin
                  if ((((- __fbbtgat) / Fmaxr) <  0.0)) begin
                    tmp = ( 100.0e-102 / (((-230.258509299405 - ((- __fbbtgat) / Fmaxr)) * ((((-230.258509299405 - ((- __fbbtgat) / Fmaxr)) * (((-230.258509299405 - ((- __fbbtgat) / Fmaxr)) *  0.333333333333333) +  1.0)) *  0.5) +  1.0)) +  1.0));
                  end
                  else begin
                    tmp = ((((((- __fbbtgat) / Fmaxr) -  230.258509299405) * ((((((- __fbbtgat) / Fmaxr) -  230.258509299405) * (((((- __fbbtgat) / Fmaxr) -  230.258509299405) *  0.333333333333333) +  1.0)) *  0.5) +  1.0)) +  1.0) *  10.0e+99);
                  end
                end
                ibbt = ((((__Vjun_s * Fmaxr) * Fmaxr) * tmp) *  1.0e-18);
              end
              if (0) begin
              end
              else begin
                if ((vav > ((- __alphaav) *  10.0))) begin
                  if (1) begin
                    tmp = ((((vav * __VBRinvgat) * (vav * __VBRinvgat)) * (vav * __VBRinvgat)) * (vav * __VBRinvgat));
                  end
                  else begin
                  end
                  fbreakdown = ( 1.0 / ( 1.0 - tmp));
                end
                else begin
                  fbreakdown = (__fstopgat + ((vav + (__alphaav *  10.0)) * __slopegat));
                end
              end
              ijungat_s = ((((id + isrh) + itat) + ibbt) * fbreakdown);
            end
            ijun_s = (((__ABSOURCE_i * ijunbot_s) + (__LSSOURCE_i * ijunsti_s)) + (__LGSOURCE_i * ijungat_s));
            vbbt =  0.0;
            two_psistar =  0.0;
            if ((! (((__ABDRAIN_i ==  0.0) && (__LSDRAIN_i ==  0.0)) && (__LGDRAIN_i ==  0.0)))) begin
              h1 = ((__vch_d *  4.0) * __vch_d);
              h2 = (__vch_d / __vfmin_d);
              h2d = (__Vjun_d + (__vch_d * h2));
              h3 = (__vfmin_d + h2d);
              h4 = (__vfmin_d - h2d);
              h5 = sqrt(((h4 * h4) + h1));
              vj = (((__Vjun_d * __vfmin_d) / (h3 + h5)) *  2.0);
              if ((__Vjun_d < __VMAX_d)) begin
                if ((abs(((__Vjun_d * __phitdinv) *  0.5)) <  230.258509299405)) begin
                  zinv = exp(((__Vjun_d * __phitdinv) *  0.5));
                end
                else begin
                  if ((((__Vjun_d * __phitdinv) *  0.5) <  0.0)) begin
                    zinv = ( 100.0e-102 / (((-230.258509299405 - ((__Vjun_d * __phitdinv) *  0.5)) * ((((-230.258509299405 - ((__Vjun_d * __phitdinv) *  0.5)) * (((-230.258509299405 - ((__Vjun_d * __phitdinv) *  0.5)) *  0.333333333333333) +  1.0)) *  0.5) +  1.0)) +  1.0));
                  end
                  else begin
                    zinv = ((((((__Vjun_d * __phitdinv) *  0.5) -  230.258509299405) * ((((((__Vjun_d * __phitdinv) *  0.5) -  230.258509299405) * (((((__Vjun_d * __phitdinv) *  0.5) -  230.258509299405) *  0.333333333333333) +  1.0)) *  0.5) +  1.0)) +  1.0) *  10.0e+99);
                  end
                end
                idmult = (zinv * zinv);
              end
              else begin
                idmult = ((((__Vjun_d - __VMAX_d) * __phitdinv) +  1.0) * __exp_VMAX_over_phitd_d);
                zinv = sqrt(idmult);
              end
              idmult = (idmult -  1.0);
              z = ( 1.0 / zinv);
              if ((__Vjun_d >  0.0)) begin
                two_psistar = ((__phitd * ln(((z +  2.0) + sqrt(((z +  1.0) * (z +  3.0)))))) *  2.0);
              end
              else begin
                two_psistar = ((- __Vjun_d) + ((__phitd * ln((((zinv *  2.0) +  1.0) + sqrt(((zinv +  1.0) * ((zinv *  3.0) +  1.0)))))) *  2.0));
              end
              vjlim = (__vbimin_d - two_psistar);
              vjsrh = (((__Vjun_d + vjlim) - sqrt((((__Vjun_d - vjlim) * (__Vjun_d - vjlim)) + ((__phitd *  4.0) * __phitd)))) *  0.5);
              vbbt = (((__Vjun_d + __vbbtlim_d) - sqrt((((__Vjun_d - __vbbtlim_d) * (__Vjun_d - __vbbtlim_d)) + ((__phitr *  4.0) * __phitr)))) *  0.5);
              vav = ((__Vjun_d - sqrt(((__Vjun_d * __Vjun_d) +  4.0e-12))) *  0.5);
            end
            if ((__ABDRAIN_i ==  0.0)) begin
              ijunbot_d =  0.0;
              qjunbot_d =  0.0;
            end
            else begin
              if ((__one_minus_PBOT_d ==  0.5)) begin
                tmp = sqrt(( 1.0 - (vj * __vbiinvbot_d)));
              end
              else begin
                tmp = pow(( 1.0 - (vj * __vbiinvbot_d)), __one_minus_PBOT_d);
              end
              qjunbot_d = ((__qprefbot_d * ( 1.0 - tmp)) + (__qpref2bot_d * (__Vjun_d - vj)));
              id = (__idsatbot_d * idmult);
              if (((__CSRHBOTD_i ==  0.0) && (__CTATBOTD_i ==  0.0))) begin
                isrh =  0.0;
              end
              else begin
                vbi_minus_vjsrh = (__vbibot_d - vjsrh);
                wsrhstep = ( 1.0 - sqrt(( 1.0 - (two_psistar / vbi_minus_vjsrh))));
                if ((__PBOTD_i ==  0.5)) begin
                  dwsrh =  0.0;
                end
                else begin
                  dwsrh = (((((wsrhstep * wsrhstep) * ln(wsrhstep)) / ( 1.0 - wsrhstep)) + wsrhstep) * ( 1.0 - (__PBOTD_i *  2.0)));
                end
                wsrh = (wsrhstep + dwsrh);
                if ((__PBOTD_i ==  0.5)) begin
                  tmp = sqrt((vbi_minus_vjsrh * __VBIRBOTinv_d));
                end
                else begin
                  tmp = pow((vbi_minus_vjsrh * __VBIRBOTinv_d), __PBOTD_i);
                end
                wdep = (__wdepnulrbot_d * tmp);
                asrh = (__ftdbot_d * ((zinv -  1.0) * wdep));
                isrh = (__CSRHBOTD_i * (asrh * wsrh));
              end
              if ((__CTATBOTD_i ==  0.0)) begin
                itat =  0.0;
              end
              else begin
                btat = (__btatpartbot_d * ((wdep * __one_minus_PBOT_d) / vbi_minus_vjsrh));
                twoatatoverthreebtat = ((__atatbot_d *  0.666666666666667) / btat);
                umaxbeforelimiting = (twoatatoverthreebtat * twoatatoverthreebtat);
                umax = sqrt(((umaxbeforelimiting * umaxbeforelimiting) / ((umaxbeforelimiting * umaxbeforelimiting) +  1.0)));
                sqrtumax = sqrt(umax);
                umaxpoweronepointfive = (umax * sqrtumax);
                if ((((- __PBOTD_i) * __one_over_one_minus_PBOT_d) == -1.0)) begin
                  wgamma = ( 1.0 / ((btat * umaxpoweronepointfive) +  1.0));
                end
                else begin
                  wgamma = pow(((btat * umaxpoweronepointfive) +  1.0), ((- __PBOTD_i) * __one_over_one_minus_PBOT_d));
                end
                wtat = ((wsrh * wgamma) / (wsrh + wgamma));
                ktat = sqrt(((btat / sqrtumax) *  0.375));
                ltat = (((twoatatoverthreebtat * sqrtumax) *  2.0) - umax);
                mtat = ((((__atatbot_d * twoatatoverthreebtat) * sqrtumax) - (__atatbot_d * umax)) + ((btat * umaxpoweronepointfive) *  0.5));
                xerfc = ((ltat -  1.0) * ktat);
                ysq = (xerfc * xerfc);
                if ((xerfc >  0.0)) begin
                  terfc = ( 1.0 / ((__perfc * xerfc) +  1.0));
                end
                else begin
                  terfc = ( 1.0 / ( 1.0 - (__perfc * xerfc)));
                end
                if ((((- ysq) + mtat) > -230.258509299405)) begin
                  tmp = exp(((- ysq) + mtat));
                end
                else begin
                  tmp = ( 100.0e-102 / (((-230.258509299405 - ((- ysq) + mtat)) * ((((-230.258509299405 - ((- ysq) + mtat)) * (((-230.258509299405 - ((- ysq) + mtat)) *  0.333333333333333) +  1.0)) *  0.5) +  1.0)) +  1.0));
                end
                erfcpos = ((((terfc *  0.29214664) + (__berfc * (terfc * terfc))) + (__cerfc * ((terfc * terfc) * terfc))) * tmp);
                if ((xerfc >  0.0)) begin
                  erfctimesexpmtat = erfcpos;
                end
                else begin
                  if ((mtat > -230.258509299405)) begin
                    tmp = exp(mtat);
                  end
                  else begin
                    tmp = ( 100.0e-102 / (((-230.258509299405 - mtat) * ((((-230.258509299405 - mtat) * (((-230.258509299405 - mtat) *  0.333333333333333) +  1.0)) *  0.5) +  1.0)) +  1.0));
                  end
                  erfctimesexpmtat = ((tmp *  2.0) - erfcpos);
                end
                gammamax = (((__atatbot_d * erfctimesexpmtat) / ktat) *  0.886226925452758);
                itat = (__CTATBOTD_i * ((asrh * gammamax) * wtat));
              end
              if ((__CBBTBOTD_i ==  0.0)) begin
                ibbt =  0.0;
              end
              else begin
                if ((__PBOTD_i ==  0.5)) begin
                  tmp = sqrt(((__VBIRBOTD_i - vbbt) * __VBIRBOTinv_d));
                end
                else begin
                  tmp = pow(((__VBIRBOTD_i - vbbt) * __VBIRBOTinv_d), __PBOTD_i);
                end
                Fmaxr = (__one_over_one_minus_PBOT_d * (((__VBIRBOTD_i - vbbt) * __wdepnulrinvbot_d) / tmp));
                if ((abs(((- __fbbtbot_d) / Fmaxr)) <  230.258509299405)) begin
                  tmp = exp(((- __fbbtbot_d) / Fmaxr));
                end
                else begin
                  if ((((- __fbbtbot_d) / Fmaxr) <  0.0)) begin
                    tmp = ( 100.0e-102 / (((-230.258509299405 - ((- __fbbtbot_d) / Fmaxr)) * ((((-230.258509299405 - ((- __fbbtbot_d) / Fmaxr)) * (((-230.258509299405 - ((- __fbbtbot_d) / Fmaxr)) *  0.333333333333333) +  1.0)) *  0.5) +  1.0)) +  1.0));
                  end
                  else begin
                    tmp = ((((((- __fbbtbot_d) / Fmaxr) -  230.258509299405) * ((((((- __fbbtbot_d) / Fmaxr) -  230.258509299405) * (((((- __fbbtbot_d) / Fmaxr) -  230.258509299405) *  0.333333333333333) +  1.0)) *  0.5) +  1.0)) +  1.0) *  10.0e+99);
                  end
                end
                ibbt = (__CBBTBOTD_i * (((__Vjun_d * Fmaxr) * Fmaxr) * tmp));
              end
              if ((__VBRBOTD_i >  1.0e+3)) begin
                fbreakdown =  1.0;
              end
              else begin
                if ((vav > ((- __alphaav) * __VBRBOTD_i))) begin
                  if ((__PBRBOTD_i ==  4.0)) begin
                    tmp = ((((vav * __VBRinvbot_d) * (vav * __VBRinvbot_d)) * (vav * __VBRinvbot_d)) * (vav * __VBRinvbot_d));
                  end
                  else begin
                    tmp = pow(abs((vav * __VBRinvbot_d)), __PBRBOTD_i);
                  end
                  fbreakdown = ( 1.0 / ( 1.0 - tmp));
                end
                else begin
                  fbreakdown = (__fstopbot_d + ((vav + (__alphaav * __VBRBOTD_i)) * __slopebot_d));
                end
              end
              ijunbot_d = ((((id + isrh) + itat) + ibbt) * fbreakdown);
            end
            if ((__LSDRAIN_i ==  0.0)) begin
              ijunsti_d =  0.0;
              qjunsti_d =  0.0;
            end
            else begin
              if ((__one_minus_PSTI_d ==  0.5)) begin
                tmp = sqrt(( 1.0 - (vj * __vbiinvsti_d)));
              end
              else begin
                tmp = pow(( 1.0 - (vj * __vbiinvsti_d)), __one_minus_PSTI_d);
              end
              qjunsti_d = ((__qprefsti_d * ( 1.0 - tmp)) + (__qpref2sti_d * (__Vjun_d - vj)));
              id = (__idsatsti_d * idmult);
              if (((__CSRHSTID_i ==  0.0) && (__CTATSTID_i ==  0.0))) begin
                isrh =  0.0;
              end
              else begin
                vbi_minus_vjsrh = (__vbisti_d - vjsrh);
                wsrhstep = ( 1.0 - sqrt(( 1.0 - (two_psistar / vbi_minus_vjsrh))));
                if ((__PSTID_i ==  0.5)) begin
                  dwsrh =  0.0;
                end
                else begin
                  dwsrh = (((((wsrhstep * wsrhstep) * ln(wsrhstep)) / ( 1.0 - wsrhstep)) + wsrhstep) * ( 1.0 - (__PSTID_i *  2.0)));
                end
                wsrh = (wsrhstep + dwsrh);
                if ((__PSTID_i ==  0.5)) begin
                  tmp = sqrt((vbi_minus_vjsrh * __VBIRSTIinv_d));
                end
                else begin
                  tmp = pow((vbi_minus_vjsrh * __VBIRSTIinv_d), __PSTID_i);
                end
                wdep = (__wdepnulrsti_d * tmp);
                asrh = (__ftdsti_d * ((zinv -  1.0) * wdep));
                isrh = (__CSRHSTID_i * (asrh * wsrh));
              end
              if ((__CTATSTID_i ==  0.0)) begin
                itat =  0.0;
              end
              else begin
                btat = (__btatpartsti_d * ((wdep * __one_minus_PSTI_d) / vbi_minus_vjsrh));
                twoatatoverthreebtat = ((__atatsti_d *  0.666666666666667) / btat);
                umaxbeforelimiting = (twoatatoverthreebtat * twoatatoverthreebtat);
                umax = sqrt(((umaxbeforelimiting * umaxbeforelimiting) / ((umaxbeforelimiting * umaxbeforelimiting) +  1.0)));
                sqrtumax = sqrt(umax);
                umaxpoweronepointfive = (umax * sqrtumax);
                if ((((- __PSTID_i) * __one_over_one_minus_PSTI_d) == -1.0)) begin
                  wgamma = ( 1.0 / ((btat * umaxpoweronepointfive) +  1.0));
                end
                else begin
                  wgamma = pow(((btat * umaxpoweronepointfive) +  1.0), ((- __PSTID_i) * __one_over_one_minus_PSTI_d));
                end
                wtat = ((wsrh * wgamma) / (wsrh + wgamma));
                ktat = sqrt(((btat / sqrtumax) *  0.375));
                ltat = (((twoatatoverthreebtat * sqrtumax) *  2.0) - umax);
                mtat = ((((__atatsti_d * twoatatoverthreebtat) * sqrtumax) - (__atatsti_d * umax)) + ((btat * umaxpoweronepointfive) *  0.5));
                xerfc = ((ltat -  1.0) * ktat);
                ysq = (xerfc * xerfc);
                if ((xerfc >  0.0)) begin
                  terfc = ( 1.0 / ((__perfc * xerfc) +  1.0));
                end
                else begin
                  terfc = ( 1.0 / ( 1.0 - (__perfc * xerfc)));
                end
                if ((((- ysq) + mtat) > -230.258509299405)) begin
                  tmp = exp(((- ysq) + mtat));
                end
                else begin
                  tmp = ( 100.0e-102 / (((-230.258509299405 - ((- ysq) + mtat)) * ((((-230.258509299405 - ((- ysq) + mtat)) * (((-230.258509299405 - ((- ysq) + mtat)) *  0.333333333333333) +  1.0)) *  0.5) +  1.0)) +  1.0));
                end
                erfcpos = ((((terfc *  0.29214664) + (__berfc * (terfc * terfc))) + (__cerfc * ((terfc * terfc) * terfc))) * tmp);
                if ((xerfc >  0.0)) begin
                  erfctimesexpmtat = erfcpos;
                end
                else begin
                  if ((mtat > -230.258509299405)) begin
                    tmp = exp(mtat);
                  end
                  else begin
                    tmp = ( 100.0e-102 / (((-230.258509299405 - mtat) * ((((-230.258509299405 - mtat) * (((-230.258509299405 - mtat) *  0.333333333333333) +  1.0)) *  0.5) +  1.0)) +  1.0));
                  end
                  erfctimesexpmtat = ((tmp *  2.0) - erfcpos);
                end
                gammamax = (((__atatsti_d * erfctimesexpmtat) / ktat) *  0.886226925452758);
                itat = (__CTATSTID_i * ((asrh * gammamax) * wtat));
              end
              if ((__CBBTSTID_i ==  0.0)) begin
                ibbt =  0.0;
              end
              else begin
                if ((__PSTID_i ==  0.5)) begin
                  tmp = sqrt(((__VBIRSTID_i - vbbt) * __VBIRSTIinv_d));
                end
                else begin
                  tmp = pow(((__VBIRSTID_i - vbbt) * __VBIRSTIinv_d), __PSTID_i);
                end
                Fmaxr = (__one_over_one_minus_PSTI_d * (((__VBIRSTID_i - vbbt) * __wdepnulrinvsti_d) / tmp));
                if ((abs(((- __fbbtsti_d) / Fmaxr)) <  230.258509299405)) begin
                  tmp = exp(((- __fbbtsti_d) / Fmaxr));
                end
                else begin
                  if ((((- __fbbtsti_d) / Fmaxr) <  0.0)) begin
                    tmp = ( 100.0e-102 / (((-230.258509299405 - ((- __fbbtsti_d) / Fmaxr)) * ((((-230.258509299405 - ((- __fbbtsti_d) / Fmaxr)) * (((-230.258509299405 - ((- __fbbtsti_d) / Fmaxr)) *  0.333333333333333) +  1.0)) *  0.5) +  1.0)) +  1.0));
                  end
                  else begin
                    tmp = ((((((- __fbbtsti_d) / Fmaxr) -  230.258509299405) * ((((((- __fbbtsti_d) / Fmaxr) -  230.258509299405) * (((((- __fbbtsti_d) / Fmaxr) -  230.258509299405) *  0.333333333333333) +  1.0)) *  0.5) +  1.0)) +  1.0) *  10.0e+99);
                  end
                end
                ibbt = (__CBBTSTID_i * (((__Vjun_d * Fmaxr) * Fmaxr) * tmp));
              end
              if ((__VBRSTID_i >  1.0e+3)) begin
                fbreakdown =  1.0;
              end
              else begin
                if ((vav > ((- __alphaav) * __VBRSTID_i))) begin
                  if ((__PBRSTID_i ==  4.0)) begin
                    tmp = ((((vav * __VBRinvsti_d) * (vav * __VBRinvsti_d)) * (vav * __VBRinvsti_d)) * (vav * __VBRinvsti_d));
                  end
                  else begin
                    tmp = pow(abs((vav * __VBRinvsti_d)), __PBRSTID_i);
                  end
                  fbreakdown = ( 1.0 / ( 1.0 - tmp));
                end
                else begin
                  fbreakdown = (__fstopsti_d + ((vav + (__alphaav * __VBRSTID_i)) * __slopesti_d));
                end
              end
              ijunsti_d = ((((id + isrh) + itat) + ibbt) * fbreakdown);
            end
            if ((__LGDRAIN_i ==  0.0)) begin
              ijungat_d =  0.0;
              qjungat_d =  0.0;
            end
            else begin
              if ((__one_minus_PGAT_d ==  0.5)) begin
                tmp = sqrt(( 1.0 - (vj * __vbiinvgat_d)));
              end
              else begin
                tmp = pow(( 1.0 - (vj * __vbiinvgat_d)), __one_minus_PGAT_d);
              end
              qjungat_d = ((__qprefgat_d * ( 1.0 - tmp)) + (__qpref2gat_d * (__Vjun_d - vj)));
              id = (__idsatgat_d * idmult);
              if (((__CSRHGATD_i ==  0.0) && (__CTATGATD_i ==  0.0))) begin
                isrh =  0.0;
              end
              else begin
                vbi_minus_vjsrh = (__vbigat_d - vjsrh);
                wsrhstep = ( 1.0 - sqrt(( 1.0 - (two_psistar / vbi_minus_vjsrh))));
                if ((__PGATD_i ==  0.5)) begin
                  dwsrh =  0.0;
                end
                else begin
                  dwsrh = (((((wsrhstep * wsrhstep) * ln(wsrhstep)) / ( 1.0 - wsrhstep)) + wsrhstep) * ( 1.0 - (__PGATD_i *  2.0)));
                end
                wsrh = (wsrhstep + dwsrh);
                if ((__PGATD_i ==  0.5)) begin
                  tmp = sqrt((vbi_minus_vjsrh * __VBIRGATinv_d));
                end
                else begin
                  tmp = pow((vbi_minus_vjsrh * __VBIRGATinv_d), __PGATD_i);
                end
                wdep = (__wdepnulrgat_d * tmp);
                asrh = (__ftdgat_d * ((zinv -  1.0) * wdep));
                isrh = (__CSRHGATD_i * (asrh * wsrh));
              end
              if ((__CTATGATD_i ==  0.0)) begin
                itat =  0.0;
              end
              else begin
                btat = (__btatpartgat_d * ((wdep * __one_minus_PGAT_d) / vbi_minus_vjsrh));
                twoatatoverthreebtat = ((__atatgat_d *  0.666666666666667) / btat);
                umaxbeforelimiting = (twoatatoverthreebtat * twoatatoverthreebtat);
                umax = sqrt(((umaxbeforelimiting * umaxbeforelimiting) / ((umaxbeforelimiting * umaxbeforelimiting) +  1.0)));
                sqrtumax = sqrt(umax);
                umaxpoweronepointfive = (umax * sqrtumax);
                if ((((- __PGATD_i) * __one_over_one_minus_PGAT_d) == -1.0)) begin
                  wgamma = ( 1.0 / ((btat * umaxpoweronepointfive) +  1.0));
                end
                else begin
                  wgamma = pow(((btat * umaxpoweronepointfive) +  1.0), ((- __PGATD_i) * __one_over_one_minus_PGAT_d));
                end
                wtat = ((wsrh * wgamma) / (wsrh + wgamma));
                ktat = sqrt(((btat / sqrtumax) *  0.375));
                ltat = (((twoatatoverthreebtat * sqrtumax) *  2.0) - umax);
                mtat = ((((__atatgat_d * twoatatoverthreebtat) * sqrtumax) - (__atatgat_d * umax)) + ((btat * umaxpoweronepointfive) *  0.5));
                xerfc = ((ltat -  1.0) * ktat);
                ysq = (xerfc * xerfc);
                if ((xerfc >  0.0)) begin
                  terfc = ( 1.0 / ((__perfc * xerfc) +  1.0));
                end
                else begin
                  terfc = ( 1.0 / ( 1.0 - (__perfc * xerfc)));
                end
                if ((((- ysq) + mtat) > -230.258509299405)) begin
                  tmp = exp(((- ysq) + mtat));
                end
                else begin
                  tmp = ( 100.0e-102 / (((-230.258509299405 - ((- ysq) + mtat)) * ((((-230.258509299405 - ((- ysq) + mtat)) * (((-230.258509299405 - ((- ysq) + mtat)) *  0.333333333333333) +  1.0)) *  0.5) +  1.0)) +  1.0));
                end
                erfcpos = ((((terfc *  0.29214664) + (__berfc * (terfc * terfc))) + (__cerfc * ((terfc * terfc) * terfc))) * tmp);
                if ((xerfc >  0.0)) begin
                  erfctimesexpmtat = erfcpos;
                end
                else begin
                  if ((mtat > -230.258509299405)) begin
                    tmp = exp(mtat);
                  end
                  else begin
                    tmp = ( 100.0e-102 / (((-230.258509299405 - mtat) * ((((-230.258509299405 - mtat) * (((-230.258509299405 - mtat) *  0.333333333333333) +  1.0)) *  0.5) +  1.0)) +  1.0));
                  end
                  erfctimesexpmtat = ((tmp *  2.0) - erfcpos);
                end
                gammamax = (((__atatgat_d * erfctimesexpmtat) / ktat) *  0.886226925452758);
                itat = (__CTATGATD_i * ((asrh * gammamax) * wtat));
              end
              if ((__CBBTGATD_i ==  0.0)) begin
                ibbt =  0.0;
              end
              else begin
                if ((__PGATD_i ==  0.5)) begin
                  tmp = sqrt(((__VBIRGATD_i - vbbt) * __VBIRGATinv_d));
                end
                else begin
                  tmp = pow(((__VBIRGATD_i - vbbt) * __VBIRGATinv_d), __PGATD_i);
                end
                Fmaxr = (__one_over_one_minus_PGAT_d * (((__VBIRGATD_i - vbbt) * __wdepnulrinvgat_d) / tmp));
                if ((abs(((- __fbbtgat_d) / Fmaxr)) <  230.258509299405)) begin
                  tmp = exp(((- __fbbtgat_d) / Fmaxr));
                end
                else begin
                  if ((((- __fbbtgat_d) / Fmaxr) <  0.0)) begin
                    tmp = ( 100.0e-102 / (((-230.258509299405 - ((- __fbbtgat_d) / Fmaxr)) * ((((-230.258509299405 - ((- __fbbtgat_d) / Fmaxr)) * (((-230.258509299405 - ((- __fbbtgat_d) / Fmaxr)) *  0.333333333333333) +  1.0)) *  0.5) +  1.0)) +  1.0));
                  end
                  else begin
                    tmp = ((((((- __fbbtgat_d) / Fmaxr) -  230.258509299405) * ((((((- __fbbtgat_d) / Fmaxr) -  230.258509299405) * (((((- __fbbtgat_d) / Fmaxr) -  230.258509299405) *  0.333333333333333) +  1.0)) *  0.5) +  1.0)) +  1.0) *  10.0e+99);
                  end
                end
                ibbt = (__CBBTGATD_i * (((__Vjun_d * Fmaxr) * Fmaxr) * tmp));
              end
              if ((__VBRGATD_i >  1.0e+3)) begin
                fbreakdown =  1.0;
              end
              else begin
                if ((vav > ((- __alphaav) * __VBRGATD_i))) begin
                  if ((__PBRGATD_i ==  4.0)) begin
                    tmp = ((((vav * __VBRinvgat_d) * (vav * __VBRinvgat_d)) * (vav * __VBRinvgat_d)) * (vav * __VBRinvgat_d));
                  end
                  else begin
                    tmp = pow(abs((vav * __VBRinvgat_d)), __PBRGATD_i);
                  end
                  fbreakdown = ( 1.0 / ( 1.0 - tmp));
                end
                else begin
                  fbreakdown = (__fstopgat_d + ((vav + (__alphaav * __VBRGATD_i)) * __slopegat_d));
                end
              end
              ijungat_d = ((((id + isrh) + itat) + ibbt) * fbreakdown);
            end
            ijun_d = (((__ABDRAIN_i * ijunbot_d) + (__LSDRAIN_i * ijunsti_d)) + (__LGDRAIN_i * ijungat_d));
          end
        end
        __Qp1_0 =  0.0;
        __Qp2_0 =  0.0;
        __Qp3_0 =  0.0;
        __Qp4_0 =  0.0;
        __Qp5_0 =  0.0;
        __Qp6_0 =  0.0;
        __Qp7_0 =  0.0;
        __Qp8_0 =  0.0;
        __Qp9_0 =  0.0;
        __fk1 =  0.0;
        __fk2 =  0.0;
        __fk3 =  0.0;
        __fk4 =  0.0;
        __fk5 =  0.0;
        __fk6 =  0.0;
        __fk7 =  0.0;
        __fk8 =  0.0;
        __fk9 =  0.0;
        if ((__SWNQS_i != 0)) begin
          __dQis =  0.0;
          __dQy =  0.0;
          __dfQi =  0.0;
          __fQi =  0.0;
          __d2Qy =  0.0;
          __Qp1 =  0.0;
          __Qp2 =  0.0;
          __Qp3 =  0.0;
          __Qp4 =  0.0;
          __Qp5 =  0.0;
          __Qp6 =  0.0;
          __Qp7 =  0.0;
          __Qp8 =  0.0;
          __Qp9 =  0.0;
          __phi_p1 =  0.0;
          __phi_p2 =  0.0;
          __phi_p3 =  0.0;
          __phi_p4 =  0.0;
          __phi_p5 =  0.0;
          __phi_p6 =  0.0;
          __phi_p7 =  0.0;
          __phi_p8 =  0.0;
          __phi_p9 =  0.0;
          if ((__xg_ac >  0.0)) begin
            if ((__SWNQS_i == 1)) begin
              __phi_p1 = (__x_m_ac + ((__H_ac * ( 1.0 - sqrt(( 1.0 - (((__dps_ac *  2.0) / __H_ac) * ( 0.5 - __ym)))))) * inv_phit1));
              if ((abs(__phi_p1) <= __margin_ac)) begin
                __Qb_tmp = (((__phi_p1 * -0.70710678) * __Gf_ac) * ( 1.0 - ((__phi_p1 *  0.166666666666667) * ( 1.0 - (__phi_p1 *  0.166666666666667)))));
              end
              else begin
                if ((abs((- __phi_p1)) <  230.258509299405)) begin
                  temp = exp((- __phi_p1));
                end
                else begin
                  if (((- __phi_p1) <  0.0)) begin
                    temp = ( 100.0e-102 / (((-230.258509299405 - (- __phi_p1)) * ((((-230.258509299405 - (- __phi_p1)) * (((-230.258509299405 - (- __phi_p1)) *  0.333333333333333) +  1.0)) *  0.5) +  1.0)) +  1.0));
                  end
                  else begin
                    temp = (((((- __phi_p1) -  230.258509299405) * (((((- __phi_p1) -  230.258509299405) * ((((- __phi_p1) -  230.258509299405) *  0.333333333333333) +  1.0)) *  0.5) +  1.0)) +  1.0) *  10.0e+99);
                  end
                end
                __Qb_tmp = (__Gf_ac * sqrt(((temp + __phi_p1) -  1.0)));
                if ((__phi_p1 > __margin_ac)) begin
                  __Qb_tmp = (- __Qb_tmp);
                end
              end
              __Qp1_0 = (((- __pd) * (__xg_ac - __phi_p1)) - __Qb_tmp);
            end
            else begin
              if ((__SWNQS_i == 2)) begin
                __phi_p1 = (__x_m_ac + ((__H_ac * ( 1.0 - sqrt(( 1.0 - (((__dps_ac *  2.0) / __H_ac) * ( 0.333333333333333 - __ym)))))) * inv_phit1));
                if ((abs(__phi_p1) <= __margin_ac)) begin
                  __Qb_tmp = (((__phi_p1 * -0.70710678) * __Gf_ac) * ( 1.0 - ((__phi_p1 *  0.166666666666667) * ( 1.0 - (__phi_p1 *  0.166666666666667)))));
                end
                else begin
                  if ((abs((- __phi_p1)) <  230.258509299405)) begin
                    temp = exp((- __phi_p1));
                  end
                  else begin
                    if (((- __phi_p1) <  0.0)) begin
                      temp = ( 100.0e-102 / (((-230.258509299405 - (- __phi_p1)) * ((((-230.258509299405 - (- __phi_p1)) * (((-230.258509299405 - (- __phi_p1)) *  0.333333333333333) +  1.0)) *  0.5) +  1.0)) +  1.0));
                    end
                    else begin
                      temp = (((((- __phi_p1) -  230.258509299405) * (((((- __phi_p1) -  230.258509299405) * ((((- __phi_p1) -  230.258509299405) *  0.333333333333333) +  1.0)) *  0.5) +  1.0)) +  1.0) *  10.0e+99);
                    end
                  end
                  __Qb_tmp = (__Gf_ac * sqrt(((temp + __phi_p1) -  1.0)));
                  if ((__phi_p1 > __margin_ac)) begin
                    __Qb_tmp = (- __Qb_tmp);
                  end
                end
                __Qp1_0 = (((- __pd) * (__xg_ac - __phi_p1)) - __Qb_tmp);
                __phi_p2 = (__x_m_ac + ((__H_ac * ( 1.0 - sqrt(( 1.0 - (((__dps_ac *  2.0) / __H_ac) * ( 0.666666666666667 - __ym)))))) * inv_phit1));
                if ((abs(__phi_p2) <= __margin_ac)) begin
                  __Qb_tmp = (((__phi_p2 * -0.70710678) * __Gf_ac) * ( 1.0 - ((__phi_p2 *  0.166666666666667) * ( 1.0 - (__phi_p2 *  0.166666666666667)))));
                end
                else begin
                  if ((abs((- __phi_p2)) <  230.258509299405)) begin
                    temp = exp((- __phi_p2));
                  end
                  else begin
                    if (((- __phi_p2) <  0.0)) begin
                      temp = ( 100.0e-102 / (((-230.258509299405 - (- __phi_p2)) * ((((-230.258509299405 - (- __phi_p2)) * (((-230.258509299405 - (- __phi_p2)) *  0.333333333333333) +  1.0)) *  0.5) +  1.0)) +  1.0));
                    end
                    else begin
                      temp = (((((- __phi_p2) -  230.258509299405) * (((((- __phi_p2) -  230.258509299405) * ((((- __phi_p2) -  230.258509299405) *  0.333333333333333) +  1.0)) *  0.5) +  1.0)) +  1.0) *  10.0e+99);
                    end
                  end
                  __Qb_tmp = (__Gf_ac * sqrt(((temp + __phi_p2) -  1.0)));
                  if ((__phi_p2 > __margin_ac)) begin
                    __Qb_tmp = (- __Qb_tmp);
                  end
                end
                __Qp2_0 = (((- __pd) * (__xg_ac - __phi_p2)) - __Qb_tmp);
                if ((sigVds < 0)) begin
                  temp = __Qp1_0;
                  __Qp1_0 = __Qp2_0;
                  __Qp2_0 = temp;
                end
              end
              else begin
                if ((__SWNQS_i == 3)) begin
                  __phi_p1 = (__x_m_ac + ((__H_ac * ( 1.0 - sqrt(( 1.0 - (((__dps_ac *  2.0) / __H_ac) * ( 0.25 - __ym)))))) * inv_phit1));
                  if ((abs(__phi_p1) <= __margin_ac)) begin
                    __Qb_tmp = (((__phi_p1 * -0.70710678) * __Gf_ac) * ( 1.0 - ((__phi_p1 *  0.166666666666667) * ( 1.0 - (__phi_p1 *  0.166666666666667)))));
                  end
                  else begin
                    if ((abs((- __phi_p1)) <  230.258509299405)) begin
                      temp = exp((- __phi_p1));
                    end
                    else begin
                      if (((- __phi_p1) <  0.0)) begin
                        temp = ( 100.0e-102 / (((-230.258509299405 - (- __phi_p1)) * ((((-230.258509299405 - (- __phi_p1)) * (((-230.258509299405 - (- __phi_p1)) *  0.333333333333333) +  1.0)) *  0.5) +  1.0)) +  1.0));
                      end
                      else begin
                        temp = (((((- __phi_p1) -  230.258509299405) * (((((- __phi_p1) -  230.258509299405) * ((((- __phi_p1) -  230.258509299405) *  0.333333333333333) +  1.0)) *  0.5) +  1.0)) +  1.0) *  10.0e+99);
                      end
                    end
                    __Qb_tmp = (__Gf_ac * sqrt(((temp + __phi_p1) -  1.0)));
                    if ((__phi_p1 > __margin_ac)) begin
                      __Qb_tmp = (- __Qb_tmp);
                    end
                  end
                  __Qp1_0 = (((- __pd) * (__xg_ac - __phi_p1)) - __Qb_tmp);
                  __phi_p2 = (__x_m_ac + ((__H_ac * ( 1.0 - sqrt(( 1.0 - (((__dps_ac *  2.0) / __H_ac) * ( 0.5 - __ym)))))) * inv_phit1));
                  if ((abs(__phi_p2) <= __margin_ac)) begin
                    __Qb_tmp = (((__phi_p2 * -0.70710678) * __Gf_ac) * ( 1.0 - ((__phi_p2 *  0.166666666666667) * ( 1.0 - (__phi_p2 *  0.166666666666667)))));
                  end
                  else begin
                    if ((abs((- __phi_p2)) <  230.258509299405)) begin
                      temp = exp((- __phi_p2));
                    end
                    else begin
                      if (((- __phi_p2) <  0.0)) begin
                        temp = ( 100.0e-102 / (((-230.258509299405 - (- __phi_p2)) * ((((-230.258509299405 - (- __phi_p2)) * (((-230.258509299405 - (- __phi_p2)) *  0.333333333333333) +  1.0)) *  0.5) +  1.0)) +  1.0));
                      end
                      else begin
                        temp = (((((- __phi_p2) -  230.258509299405) * (((((- __phi_p2) -  230.258509299405) * ((((- __phi_p2) -  230.258509299405) *  0.333333333333333) +  1.0)) *  0.5) +  1.0)) +  1.0) *  10.0e+99);
                      end
                    end
                    __Qb_tmp = (__Gf_ac * sqrt(((temp + __phi_p2) -  1.0)));
                    if ((__phi_p2 > __margin_ac)) begin
                      __Qb_tmp = (- __Qb_tmp);
                    end
                  end
                  __Qp2_0 = (((- __pd) * (__xg_ac - __phi_p2)) - __Qb_tmp);
                  __phi_p3 = (__x_m_ac + ((__H_ac * ( 1.0 - sqrt(( 1.0 - (((__dps_ac *  2.0) / __H_ac) * ( 0.75 - __ym)))))) * inv_phit1));
                  if ((abs(__phi_p3) <= __margin_ac)) begin
                    __Qb_tmp = (((__phi_p3 * -0.70710678) * __Gf_ac) * ( 1.0 - ((__phi_p3 *  0.166666666666667) * ( 1.0 - (__phi_p3 *  0.166666666666667)))));
                  end
                  else begin
                    if ((abs((- __phi_p3)) <  230.258509299405)) begin
                      temp = exp((- __phi_p3));
                    end
                    else begin
                      if (((- __phi_p3) <  0.0)) begin
                        temp = ( 100.0e-102 / (((-230.258509299405 - (- __phi_p3)) * ((((-230.258509299405 - (- __phi_p3)) * (((-230.258509299405 - (- __phi_p3)) *  0.333333333333333) +  1.0)) *  0.5) +  1.0)) +  1.0));
                      end
                      else begin
                        temp = (((((- __phi_p3) -  230.258509299405) * (((((- __phi_p3) -  230.258509299405) * ((((- __phi_p3) -  230.258509299405) *  0.333333333333333) +  1.0)) *  0.5) +  1.0)) +  1.0) *  10.0e+99);
                      end
                    end
                    __Qb_tmp = (__Gf_ac * sqrt(((temp + __phi_p3) -  1.0)));
                    if ((__phi_p3 > __margin_ac)) begin
                      __Qb_tmp = (- __Qb_tmp);
                    end
                  end
                  __Qp3_0 = (((- __pd) * (__xg_ac - __phi_p3)) - __Qb_tmp);
                  if ((sigVds < 0)) begin
                    temp = __Qp1_0;
                    __Qp1_0 = __Qp3_0;
                    __Qp3_0 = temp;
                  end
                end
                else begin
                  if ((__SWNQS_i == 5)) begin
                    __phi_p1 = (__x_m_ac + ((__H_ac * ( 1.0 - sqrt(( 1.0 - (((__dps_ac *  2.0) / __H_ac) * ( 0.166666666666667 - __ym)))))) * inv_phit1));
                    if ((abs(__phi_p1) <= __margin_ac)) begin
                      __Qb_tmp = (((__phi_p1 * -0.70710678) * __Gf_ac) * ( 1.0 - ((__phi_p1 *  0.166666666666667) * ( 1.0 - (__phi_p1 *  0.166666666666667)))));
                    end
                    else begin
                      if ((abs((- __phi_p1)) <  230.258509299405)) begin
                        temp = exp((- __phi_p1));
                      end
                      else begin
                        if (((- __phi_p1) <  0.0)) begin
                          temp = ( 100.0e-102 / (((-230.258509299405 - (- __phi_p1)) * ((((-230.258509299405 - (- __phi_p1)) * (((-230.258509299405 - (- __phi_p1)) *  0.333333333333333) +  1.0)) *  0.5) +  1.0)) +  1.0));
                        end
                        else begin
                          temp = (((((- __phi_p1) -  230.258509299405) * (((((- __phi_p1) -  230.258509299405) * ((((- __phi_p1) -  230.258509299405) *  0.333333333333333) +  1.0)) *  0.5) +  1.0)) +  1.0) *  10.0e+99);
                        end
                      end
                      __Qb_tmp = (__Gf_ac * sqrt(((temp + __phi_p1) -  1.0)));
                      if ((__phi_p1 > __margin_ac)) begin
                        __Qb_tmp = (- __Qb_tmp);
                      end
                    end
                    __Qp1_0 = (((- __pd) * (__xg_ac - __phi_p1)) - __Qb_tmp);
                    __phi_p2 = (__x_m_ac + ((__H_ac * ( 1.0 - sqrt(( 1.0 - (((__dps_ac *  2.0) / __H_ac) * ( 0.333333333333333 - __ym)))))) * inv_phit1));
                    if ((abs(__phi_p2) <= __margin_ac)) begin
                      __Qb_tmp = (((__phi_p2 * -0.70710678) * __Gf_ac) * ( 1.0 - ((__phi_p2 *  0.166666666666667) * ( 1.0 - (__phi_p2 *  0.166666666666667)))));
                    end
                    else begin
                      if ((abs((- __phi_p2)) <  230.258509299405)) begin
                        temp = exp((- __phi_p2));
                      end
                      else begin
                        if (((- __phi_p2) <  0.0)) begin
                          temp = ( 100.0e-102 / (((-230.258509299405 - (- __phi_p2)) * ((((-230.258509299405 - (- __phi_p2)) * (((-230.258509299405 - (- __phi_p2)) *  0.333333333333333) +  1.0)) *  0.5) +  1.0)) +  1.0));
                        end
                        else begin
                          temp = (((((- __phi_p2) -  230.258509299405) * (((((- __phi_p2) -  230.258509299405) * ((((- __phi_p2) -  230.258509299405) *  0.333333333333333) +  1.0)) *  0.5) +  1.0)) +  1.0) *  10.0e+99);
                        end
                      end
                      __Qb_tmp = (__Gf_ac * sqrt(((temp + __phi_p2) -  1.0)));
                      if ((__phi_p2 > __margin_ac)) begin
                        __Qb_tmp = (- __Qb_tmp);
                      end
                    end
                    __Qp2_0 = (((- __pd) * (__xg_ac - __phi_p2)) - __Qb_tmp);
                    __phi_p3 = (__x_m_ac + ((__H_ac * ( 1.0 - sqrt(( 1.0 - (((__dps_ac *  2.0) / __H_ac) * ( 0.5 - __ym)))))) * inv_phit1));
                    if ((abs(__phi_p3) <= __margin_ac)) begin
                      __Qb_tmp = (((__phi_p3 * -0.70710678) * __Gf_ac) * ( 1.0 - ((__phi_p3 *  0.166666666666667) * ( 1.0 - (__phi_p3 *  0.166666666666667)))));
                    end
                    else begin
                      if ((abs((- __phi_p3)) <  230.258509299405)) begin
                        temp = exp((- __phi_p3));
                      end
                      else begin
                        if (((- __phi_p3) <  0.0)) begin
                          temp = ( 100.0e-102 / (((-230.258509299405 - (- __phi_p3)) * ((((-230.258509299405 - (- __phi_p3)) * (((-230.258509299405 - (- __phi_p3)) *  0.333333333333333) +  1.0)) *  0.5) +  1.0)) +  1.0));
                        end
                        else begin
                          temp = (((((- __phi_p3) -  230.258509299405) * (((((- __phi_p3) -  230.258509299405) * ((((- __phi_p3) -  230.258509299405) *  0.333333333333333) +  1.0)) *  0.5) +  1.0)) +  1.0) *  10.0e+99);
                        end
                      end
                      __Qb_tmp = (__Gf_ac * sqrt(((temp + __phi_p3) -  1.0)));
                      if ((__phi_p3 > __margin_ac)) begin
                        __Qb_tmp = (- __Qb_tmp);
                      end
                    end
                    __Qp3_0 = (((- __pd) * (__xg_ac - __phi_p3)) - __Qb_tmp);
                    __phi_p4 = (__x_m_ac + ((__H_ac * ( 1.0 - sqrt(( 1.0 - (((__dps_ac *  2.0) / __H_ac) * ( 0.666666666666667 - __ym)))))) * inv_phit1));
                    if ((abs(__phi_p4) <= __margin_ac)) begin
                      __Qb_tmp = (((__phi_p4 * -0.70710678) * __Gf_ac) * ( 1.0 - ((__phi_p4 *  0.166666666666667) * ( 1.0 - (__phi_p4 *  0.166666666666667)))));
                    end
                    else begin
                      if ((abs((- __phi_p4)) <  230.258509299405)) begin
                        temp = exp((- __phi_p4));
                      end
                      else begin
                        if (((- __phi_p4) <  0.0)) begin
                          temp = ( 100.0e-102 / (((-230.258509299405 - (- __phi_p4)) * ((((-230.258509299405 - (- __phi_p4)) * (((-230.258509299405 - (- __phi_p4)) *  0.333333333333333) +  1.0)) *  0.5) +  1.0)) +  1.0));
                        end
                        else begin
                          temp = (((((- __phi_p4) -  230.258509299405) * (((((- __phi_p4) -  230.258509299405) * ((((- __phi_p4) -  230.258509299405) *  0.333333333333333) +  1.0)) *  0.5) +  1.0)) +  1.0) *  10.0e+99);
                        end
                      end
                      __Qb_tmp = (__Gf_ac * sqrt(((temp + __phi_p4) -  1.0)));
                      if ((__phi_p4 > __margin_ac)) begin
                        __Qb_tmp = (- __Qb_tmp);
                      end
                    end
                    __Qp4_0 = (((- __pd) * (__xg_ac - __phi_p4)) - __Qb_tmp);
                    __phi_p5 = (__x_m_ac + ((__H_ac * ( 1.0 - sqrt(( 1.0 - (((__dps_ac *  2.0) / __H_ac) * ( 0.833333333333333 - __ym)))))) * inv_phit1));
                    if ((abs(__phi_p5) <= __margin_ac)) begin
                      __Qb_tmp = (((__phi_p5 * -0.70710678) * __Gf_ac) * ( 1.0 - ((__phi_p5 *  0.166666666666667) * ( 1.0 - (__phi_p5 *  0.166666666666667)))));
                    end
                    else begin
                      if ((abs((- __phi_p5)) <  230.258509299405)) begin
                        temp = exp((- __phi_p5));
                      end
                      else begin
                        if (((- __phi_p5) <  0.0)) begin
                          temp = ( 100.0e-102 / (((-230.258509299405 - (- __phi_p5)) * ((((-230.258509299405 - (- __phi_p5)) * (((-230.258509299405 - (- __phi_p5)) *  0.333333333333333) +  1.0)) *  0.5) +  1.0)) +  1.0));
                        end
                        else begin
                          temp = (((((- __phi_p5) -  230.258509299405) * (((((- __phi_p5) -  230.258509299405) * ((((- __phi_p5) -  230.258509299405) *  0.333333333333333) +  1.0)) *  0.5) +  1.0)) +  1.0) *  10.0e+99);
                        end
                      end
                      __Qb_tmp = (__Gf_ac * sqrt(((temp + __phi_p5) -  1.0)));
                      if ((__phi_p5 > __margin_ac)) begin
                        __Qb_tmp = (- __Qb_tmp);
                      end
                    end
                    __Qp5_0 = (((- __pd) * (__xg_ac - __phi_p5)) - __Qb_tmp);
                    if ((sigVds <  0.0)) begin
                      temp = __Qp1_0;
                      __Qp1_0 = __Qp5_0;
                      __Qp5_0 = temp;
                      temp = __Qp2_0;
                      __Qp2_0 = __Qp4_0;
                      __Qp4_0 = temp;
                    end
                  end
                  else begin
                    if ((__SWNQS_i == 9)) begin
                      __phi_p1 = (__x_m_ac + ((__H_ac * ( 1.0 - sqrt(( 1.0 - (((__dps_ac *  2.0) / __H_ac) * ( 0.1 - __ym)))))) * inv_phit1));
                      if ((abs(__phi_p1) <= __margin_ac)) begin
                        __Qb_tmp = (((__phi_p1 * -0.70710678) * __Gf_ac) * ( 1.0 - ((__phi_p1 *  0.166666666666667) * ( 1.0 - (__phi_p1 *  0.166666666666667)))));
                      end
                      else begin
                        if ((abs((- __phi_p1)) <  230.258509299405)) begin
                          temp = exp((- __phi_p1));
                        end
                        else begin
                          if (((- __phi_p1) <  0.0)) begin
                            temp = ( 100.0e-102 / (((-230.258509299405 - (- __phi_p1)) * ((((-230.258509299405 - (- __phi_p1)) * (((-230.258509299405 - (- __phi_p1)) *  0.333333333333333) +  1.0)) *  0.5) +  1.0)) +  1.0));
                          end
                          else begin
                            temp = (((((- __phi_p1) -  230.258509299405) * (((((- __phi_p1) -  230.258509299405) * ((((- __phi_p1) -  230.258509299405) *  0.333333333333333) +  1.0)) *  0.5) +  1.0)) +  1.0) *  10.0e+99);
                          end
                        end
                        __Qb_tmp = (__Gf_ac * sqrt(((temp + __phi_p1) -  1.0)));
                        if ((__phi_p1 > __margin_ac)) begin
                          __Qb_tmp = (- __Qb_tmp);
                        end
                      end
                      __Qp1_0 = (((- __pd) * (__xg_ac - __phi_p1)) - __Qb_tmp);
                      __phi_p2 = (__x_m_ac + ((__H_ac * ( 1.0 - sqrt(( 1.0 - (((__dps_ac *  2.0) / __H_ac) * ( 0.2 - __ym)))))) * inv_phit1));
                      if ((abs(__phi_p2) <= __margin_ac)) begin
                        __Qb_tmp = (((__phi_p2 * -0.70710678) * __Gf_ac) * ( 1.0 - ((__phi_p2 *  0.166666666666667) * ( 1.0 - (__phi_p2 *  0.166666666666667)))));
                      end
                      else begin
                        if ((abs((- __phi_p2)) <  230.258509299405)) begin
                          temp = exp((- __phi_p2));
                        end
                        else begin
                          if (((- __phi_p2) <  0.0)) begin
                            temp = ( 100.0e-102 / (((-230.258509299405 - (- __phi_p2)) * ((((-230.258509299405 - (- __phi_p2)) * (((-230.258509299405 - (- __phi_p2)) *  0.333333333333333) +  1.0)) *  0.5) +  1.0)) +  1.0));
                          end
                          else begin
                            temp = (((((- __phi_p2) -  230.258509299405) * (((((- __phi_p2) -  230.258509299405) * ((((- __phi_p2) -  230.258509299405) *  0.333333333333333) +  1.0)) *  0.5) +  1.0)) +  1.0) *  10.0e+99);
                          end
                        end
                        __Qb_tmp = (__Gf_ac * sqrt(((temp + __phi_p2) -  1.0)));
                        if ((__phi_p2 > __margin_ac)) begin
                          __Qb_tmp = (- __Qb_tmp);
                        end
                      end
                      __Qp2_0 = (((- __pd) * (__xg_ac - __phi_p2)) - __Qb_tmp);
                      __phi_p3 = (__x_m_ac + ((__H_ac * ( 1.0 - sqrt(( 1.0 - (((__dps_ac *  2.0) / __H_ac) * ( 0.3 - __ym)))))) * inv_phit1));
                      if ((abs(__phi_p3) <= __margin_ac)) begin
                        __Qb_tmp = (((__phi_p3 * -0.70710678) * __Gf_ac) * ( 1.0 - ((__phi_p3 *  0.166666666666667) * ( 1.0 - (__phi_p3 *  0.166666666666667)))));
                      end
                      else begin
                        if ((abs((- __phi_p3)) <  230.258509299405)) begin
                          temp = exp((- __phi_p3));
                        end
                        else begin
                          if (((- __phi_p3) <  0.0)) begin
                            temp = ( 100.0e-102 / (((-230.258509299405 - (- __phi_p3)) * ((((-230.258509299405 - (- __phi_p3)) * (((-230.258509299405 - (- __phi_p3)) *  0.333333333333333) +  1.0)) *  0.5) +  1.0)) +  1.0));
                          end
                          else begin
                            temp = (((((- __phi_p3) -  230.258509299405) * (((((- __phi_p3) -  230.258509299405) * ((((- __phi_p3) -  230.258509299405) *  0.333333333333333) +  1.0)) *  0.5) +  1.0)) +  1.0) *  10.0e+99);
                          end
                        end
                        __Qb_tmp = (__Gf_ac * sqrt(((temp + __phi_p3) -  1.0)));
                        if ((__phi_p3 > __margin_ac)) begin
                          __Qb_tmp = (- __Qb_tmp);
                        end
                      end
                      __Qp3_0 = (((- __pd) * (__xg_ac - __phi_p3)) - __Qb_tmp);
                      __phi_p4 = (__x_m_ac + ((__H_ac * ( 1.0 - sqrt(( 1.0 - (((__dps_ac *  2.0) / __H_ac) * ( 0.4 - __ym)))))) * inv_phit1));
                      if ((abs(__phi_p4) <= __margin_ac)) begin
                        __Qb_tmp = (((__phi_p4 * -0.70710678) * __Gf_ac) * ( 1.0 - ((__phi_p4 *  0.166666666666667) * ( 1.0 - (__phi_p4 *  0.166666666666667)))));
                      end
                      else begin
                        if ((abs((- __phi_p4)) <  230.258509299405)) begin
                          temp = exp((- __phi_p4));
                        end
                        else begin
                          if (((- __phi_p4) <  0.0)) begin
                            temp = ( 100.0e-102 / (((-230.258509299405 - (- __phi_p4)) * ((((-230.258509299405 - (- __phi_p4)) * (((-230.258509299405 - (- __phi_p4)) *  0.333333333333333) +  1.0)) *  0.5) +  1.0)) +  1.0));
                          end
                          else begin
                            temp = (((((- __phi_p4) -  230.258509299405) * (((((- __phi_p4) -  230.258509299405) * ((((- __phi_p4) -  230.258509299405) *  0.333333333333333) +  1.0)) *  0.5) +  1.0)) +  1.0) *  10.0e+99);
                          end
                        end
                        __Qb_tmp = (__Gf_ac * sqrt(((temp + __phi_p4) -  1.0)));
                        if ((__phi_p4 > __margin_ac)) begin
                          __Qb_tmp = (- __Qb_tmp);
                        end
                      end
                      __Qp4_0 = (((- __pd) * (__xg_ac - __phi_p4)) - __Qb_tmp);
                      __phi_p5 = (__x_m_ac + ((__H_ac * ( 1.0 - sqrt(( 1.0 - (((__dps_ac *  2.0) / __H_ac) * ( 0.5 - __ym)))))) * inv_phit1));
                      if ((abs(__phi_p5) <= __margin_ac)) begin
                        __Qb_tmp = (((__phi_p5 * -0.70710678) * __Gf_ac) * ( 1.0 - ((__phi_p5 *  0.166666666666667) * ( 1.0 - (__phi_p5 *  0.166666666666667)))));
                      end
                      else begin
                        if ((abs((- __phi_p5)) <  230.258509299405)) begin
                          temp = exp((- __phi_p5));
                        end
                        else begin
                          if (((- __phi_p5) <  0.0)) begin
                            temp = ( 100.0e-102 / (((-230.258509299405 - (- __phi_p5)) * ((((-230.258509299405 - (- __phi_p5)) * (((-230.258509299405 - (- __phi_p5)) *  0.333333333333333) +  1.0)) *  0.5) +  1.0)) +  1.0));
                          end
                          else begin
                            temp = (((((- __phi_p5) -  230.258509299405) * (((((- __phi_p5) -  230.258509299405) * ((((- __phi_p5) -  230.258509299405) *  0.333333333333333) +  1.0)) *  0.5) +  1.0)) +  1.0) *  10.0e+99);
                          end
                        end
                        __Qb_tmp = (__Gf_ac * sqrt(((temp + __phi_p5) -  1.0)));
                        if ((__phi_p5 > __margin_ac)) begin
                          __Qb_tmp = (- __Qb_tmp);
                        end
                      end
                      __Qp5_0 = (((- __pd) * (__xg_ac - __phi_p5)) - __Qb_tmp);
                      __phi_p6 = (__x_m_ac + ((__H_ac * ( 1.0 - sqrt(( 1.0 - (((__dps_ac *  2.0) / __H_ac) * ( 0.6 - __ym)))))) * inv_phit1));
                      if ((abs(__phi_p6) <= __margin_ac)) begin
                        __Qb_tmp = (((__phi_p6 * -0.70710678) * __Gf_ac) * ( 1.0 - ((__phi_p6 *  0.166666666666667) * ( 1.0 - (__phi_p6 *  0.166666666666667)))));
                      end
                      else begin
                        if ((abs((- __phi_p6)) <  230.258509299405)) begin
                          temp = exp((- __phi_p6));
                        end
                        else begin
                          if (((- __phi_p6) <  0.0)) begin
                            temp = ( 100.0e-102 / (((-230.258509299405 - (- __phi_p6)) * ((((-230.258509299405 - (- __phi_p6)) * (((-230.258509299405 - (- __phi_p6)) *  0.333333333333333) +  1.0)) *  0.5) +  1.0)) +  1.0));
                          end
                          else begin
                            temp = (((((- __phi_p6) -  230.258509299405) * (((((- __phi_p6) -  230.258509299405) * ((((- __phi_p6) -  230.258509299405) *  0.333333333333333) +  1.0)) *  0.5) +  1.0)) +  1.0) *  10.0e+99);
                          end
                        end
                        __Qb_tmp = (__Gf_ac * sqrt(((temp + __phi_p6) -  1.0)));
                        if ((__phi_p6 > __margin_ac)) begin
                          __Qb_tmp = (- __Qb_tmp);
                        end
                      end
                      __Qp6_0 = (((- __pd) * (__xg_ac - __phi_p6)) - __Qb_tmp);
                      __phi_p7 = (__x_m_ac + ((__H_ac * ( 1.0 - sqrt(( 1.0 - (((__dps_ac *  2.0) / __H_ac) * ( 0.7 - __ym)))))) * inv_phit1));
                      if ((abs(__phi_p7) <= __margin_ac)) begin
                        __Qb_tmp = (((__phi_p7 * -0.70710678) * __Gf_ac) * ( 1.0 - ((__phi_p7 *  0.166666666666667) * ( 1.0 - (__phi_p7 *  0.166666666666667)))));
                      end
                      else begin
                        if ((abs((- __phi_p7)) <  230.258509299405)) begin
                          temp = exp((- __phi_p7));
                        end
                        else begin
                          if (((- __phi_p7) <  0.0)) begin
                            temp = ( 100.0e-102 / (((-230.258509299405 - (- __phi_p7)) * ((((-230.258509299405 - (- __phi_p7)) * (((-230.258509299405 - (- __phi_p7)) *  0.333333333333333) +  1.0)) *  0.5) +  1.0)) +  1.0));
                          end
                          else begin
                            temp = (((((- __phi_p7) -  230.258509299405) * (((((- __phi_p7) -  230.258509299405) * ((((- __phi_p7) -  230.258509299405) *  0.333333333333333) +  1.0)) *  0.5) +  1.0)) +  1.0) *  10.0e+99);
                          end
                        end
                        __Qb_tmp = (__Gf_ac * sqrt(((temp + __phi_p7) -  1.0)));
                        if ((__phi_p7 > __margin_ac)) begin
                          __Qb_tmp = (- __Qb_tmp);
                        end
                      end
                      __Qp7_0 = (((- __pd) * (__xg_ac - __phi_p7)) - __Qb_tmp);
                      __phi_p8 = (__x_m_ac + ((__H_ac * ( 1.0 - sqrt(( 1.0 - (((__dps_ac *  2.0) / __H_ac) * ( 0.8 - __ym)))))) * inv_phit1));
                      if ((abs(__phi_p8) <= __margin_ac)) begin
                        __Qb_tmp = (((__phi_p8 * -0.70710678) * __Gf_ac) * ( 1.0 - ((__phi_p8 *  0.166666666666667) * ( 1.0 - (__phi_p8 *  0.166666666666667)))));
                      end
                      else begin
                        if ((abs((- __phi_p8)) <  230.258509299405)) begin
                          temp = exp((- __phi_p8));
                        end
                        else begin
                          if (((- __phi_p8) <  0.0)) begin
                            temp = ( 100.0e-102 / (((-230.258509299405 - (- __phi_p8)) * ((((-230.258509299405 - (- __phi_p8)) * (((-230.258509299405 - (- __phi_p8)) *  0.333333333333333) +  1.0)) *  0.5) +  1.0)) +  1.0));
                          end
                          else begin
                            temp = (((((- __phi_p8) -  230.258509299405) * (((((- __phi_p8) -  230.258509299405) * ((((- __phi_p8) -  230.258509299405) *  0.333333333333333) +  1.0)) *  0.5) +  1.0)) +  1.0) *  10.0e+99);
                          end
                        end
                        __Qb_tmp = (__Gf_ac * sqrt(((temp + __phi_p8) -  1.0)));
                        if ((__phi_p8 > __margin_ac)) begin
                          __Qb_tmp = (- __Qb_tmp);
                        end
                      end
                      __Qp8_0 = (((- __pd) * (__xg_ac - __phi_p8)) - __Qb_tmp);
                      __phi_p9 = (__x_m_ac + ((__H_ac * ( 1.0 - sqrt(( 1.0 - (((__dps_ac *  2.0) / __H_ac) * ( 0.9 - __ym)))))) * inv_phit1));
                      if ((abs(__phi_p9) <= __margin_ac)) begin
                        __Qb_tmp = (((__phi_p9 * -0.70710678) * __Gf_ac) * ( 1.0 - ((__phi_p9 *  0.166666666666667) * ( 1.0 - (__phi_p9 *  0.166666666666667)))));
                      end
                      else begin
                        if ((abs((- __phi_p9)) <  230.258509299405)) begin
                          temp = exp((- __phi_p9));
                        end
                        else begin
                          if (((- __phi_p9) <  0.0)) begin
                            temp = ( 100.0e-102 / (((-230.258509299405 - (- __phi_p9)) * ((((-230.258509299405 - (- __phi_p9)) * (((-230.258509299405 - (- __phi_p9)) *  0.333333333333333) +  1.0)) *  0.5) +  1.0)) +  1.0));
                          end
                          else begin
                            temp = (((((- __phi_p9) -  230.258509299405) * (((((- __phi_p9) -  230.258509299405) * ((((- __phi_p9) -  230.258509299405) *  0.333333333333333) +  1.0)) *  0.5) +  1.0)) +  1.0) *  10.0e+99);
                          end
                        end
                        __Qb_tmp = (__Gf_ac * sqrt(((temp + __phi_p9) -  1.0)));
                        if ((__phi_p9 > __margin_ac)) begin
                          __Qb_tmp = (- __Qb_tmp);
                        end
                      end
                      __Qp9_0 = (((- __pd) * (__xg_ac - __phi_p9)) - __Qb_tmp);
                      if ((sigVds <  0.0)) begin
                        temp = __Qp1_0;
                        __Qp1_0 = __Qp9_0;
                        __Qp9_0 = temp;
                        temp = __Qp2_0;
                        __Qp2_0 = __Qp8_0;
                        __Qp8_0 = temp;
                        temp = __Qp3_0;
                        __Qp3_0 = __Qp7_0;
                        __Qp7_0 = temp;
                        temp = __Qp4_0;
                        __Qp4_0 = __Qp6_0;
                        __Qp6_0 = temp;
                      end
                    end
                  end
                end
              end
            end
          end
        end
        __x_sp =  0.0;
        __x_dp =  0.0;
        __Qp0 =  0.0;
        __QpN =  0.0;
        if ((__SWNQS_i != 0)) begin
          __x_sp = (__x_m_ac - (((sigVds *  0.5) * __dps_ac) * inv_phit1));
          __x_dp = (__x_m_ac + (((sigVds *  0.5) * __dps_ac) * inv_phit1));
          __Qp0 =  0.0;
          __QpN =  0.0;
          if ((__x_sp >  0.0)) begin
            if ((abs(__x_sp) <= __margin_ac)) begin
              __QbSIGN = (((__x_sp * -0.70710678) * __Gf_ac) * ( 1.0 - ((__x_sp *  0.166666666666667) * ( 1.0 - (__x_sp *  0.166666666666667)))));
            end
            else begin
              if ((abs((- __x_sp)) <  230.258509299405)) begin
                temp = exp((- __x_sp));
              end
              else begin
                if (((- __x_sp) <  0.0)) begin
                  temp = ( 100.0e-102 / (((-230.258509299405 - (- __x_sp)) * ((((-230.258509299405 - (- __x_sp)) * (((-230.258509299405 - (- __x_sp)) *  0.333333333333333) +  1.0)) *  0.5) +  1.0)) +  1.0));
                end
                else begin
                  temp = (((((- __x_sp) -  230.258509299405) * (((((- __x_sp) -  230.258509299405) * ((((- __x_sp) -  230.258509299405) *  0.333333333333333) +  1.0)) *  0.5) +  1.0)) +  1.0) *  10.0e+99);
                end
              end
              __QbSIGN = (__Gf_ac * sqrt(((temp + __x_sp) -  1.0)));
              if ((__x_sp > __margin_ac)) begin
                __QbSIGN = (- __QbSIGN);
              end
            end
            __Qp0 = (((- __pd) * (__xg_ac - __x_sp)) - __QbSIGN);
          end
          if ((__x_dp >  0.0)) begin
            if ((abs(__x_dp) <= __margin_ac)) begin
              __QbSIGN = (((__x_dp * -0.70710678) * __Gf_ac) * ( 1.0 - ((__x_dp *  0.166666666666667) * ( 1.0 - (__x_dp *  0.166666666666667)))));
            end
            else begin
              if ((abs((- __x_dp)) <  230.258509299405)) begin
                temp = exp((- __x_dp));
              end
              else begin
                if (((- __x_dp) <  0.0)) begin
                  temp = ( 100.0e-102 / (((-230.258509299405 - (- __x_dp)) * ((((-230.258509299405 - (- __x_dp)) * (((-230.258509299405 - (- __x_dp)) *  0.333333333333333) +  1.0)) *  0.5) +  1.0)) +  1.0));
                end
                else begin
                  temp = (((((- __x_dp) -  230.258509299405) * (((((- __x_dp) -  230.258509299405) * ((((- __x_dp) -  230.258509299405) *  0.333333333333333) +  1.0)) *  0.5) +  1.0)) +  1.0) *  10.0e+99);
                end
              end
              __QbSIGN = (__Gf_ac * sqrt(((temp + __x_dp) -  1.0)));
              if ((__x_dp > __margin_ac)) begin
                __QbSIGN = (- __QbSIGN);
              end
            end
            __QpN = (((- __pd) * (__xg_ac - __x_dp)) - __QbSIGN);
          end
        end
        __rgatenoise = (__nt0 * __ggate);
        __rsourcenoise = (__nt0 * __gsource);
        __rdrainnoise = (__nt0 * __gdrain);
        __rbulknoise = (__nt0 * __gbulk);
        __rjunsnoise = (__nt0 * __gjuns);
        __rjundnoise = (__nt0 * __gjund);
        __rwellnoise = (__nt0 * __gwell);
      end
      begin : loadStatic
        if ((sigVds >  0.0)) begin
          I(DI, BP) <+ ((__CHNL_TYPE * __MULT_i) * Iimpact);
          I(DI, SI) <+ ((__CHNL_TYPE * __MULT_i) * (Ids + Idsedge));
          I(GP, SI) <+ ((__CHNL_TYPE * __MULT_i) * Igcs);
          I(GP, DI) <+ ((__CHNL_TYPE * __MULT_i) * Igcd);
        end
        else begin
          I(SI, BP) <+ ((__CHNL_TYPE * __MULT_i) * Iimpact);
          I(SI, DI) <+ ((__CHNL_TYPE * __MULT_i) * (Ids + Idsedge));
          I(GP, DI) <+ ((__CHNL_TYPE * __MULT_i) * Igcs);
          I(GP, SI) <+ ((__CHNL_TYPE * __MULT_i) * Igcd);
        end
        I(GP, BP) <+ ((__CHNL_TYPE * __MULT_i) * __Igb);
        I(GP, SI) <+ ((__CHNL_TYPE * __MULT_i) * Igsov);
        I(GP, DI) <+ ((__CHNL_TYPE * __MULT_i) * Igdov);
        I(SI, BP) <+ ((__CHNL_TYPE * __MULT_i) * __Igisl);
        I(DI, BP) <+ ((__CHNL_TYPE * __MULT_i) * __Igidl);
        I(BS, SI) <+ ((__CHNL_TYPE * __MULT_i) * ijun_s);
        I(BD, DI) <+ ((__CHNL_TYPE * __MULT_i) * ijun_d);
        if ((__RG_i >  0.0)) begin
          I(G, GP) <+ ((__MULT_i * __ggate) * V(G, GP));
          I(G, GP) <+ white_noise((__MULT_i * __rgatenoise), "rgate");
        end
        else begin
          V(G, GP) <+  0.0;
        end
        if ((__RSE_i >  0.0)) begin
          I(S, SI) <+ ((__MULT_i * __gsource) * V(S, SI));
          I(S, SI) <+ white_noise((__MULT_i * __rsourcenoise), "rsource");
        end
        else begin
          V(S, SI) <+  0.0;
        end
        if ((__RDE_i >  0.0)) begin
          I(D, DI) <+ ((__MULT_i * __gdrain) * V(D, DI));
          I(D, DI) <+ white_noise((__MULT_i * __rdrainnoise), "rdrain");
        end
        else begin
          V(D, DI) <+  0.0;
        end
        if ((__RBULK_i >  0.0)) begin
          I(BP, BI) <+ ((__MULT_i * __gbulk) * V(BP, BI));
          I(BP, BI) <+ white_noise((__MULT_i * __rbulknoise), "rbulk");
        end
        else begin
          V(BP, BI) <+  0.0;
        end
        if ((__RJUNS_i >  0.0)) begin
          I(BS, BI) <+ ((__MULT_i * __gjuns) * V(BS, BI));
          I(BS, BI) <+ white_noise((__MULT_i * __rjunsnoise), "rjuns");
        end
        else begin
          V(BS, BI) <+  0.0;
        end
        if ((__RJUND_i >  0.0)) begin
          I(BD, BI) <+ ((__MULT_i * __gjund) * V(BD, BI));
          I(BD, BI) <+ white_noise((__MULT_i * __rjundnoise), "rjund");
        end
        else begin
          V(BD, BI) <+  0.0;
        end
        if ((__RWELL_i >  0.0)) begin
          I(B, BI) <+ ((__MULT_i * __gwell) * V(B, BI));
          I(B, BI) <+ white_noise((__MULT_i * __rwellnoise), "rwell");
        end
        else begin
          V(B, BI) <+  0.0;
        end
        I(DI, BP) <+ (__gmin * V(DI, BP));
        I(SI, BP) <+ (__gmin * V(SI, BP));
      end
      begin : loadStaticDynamic
        __Qp1 = (__vnorm * V(SPLINE1));
        __Qp2 = (__vnorm * V(SPLINE2));
        __Qp3 = (__vnorm * V(SPLINE3));
        __Qp4 = (__vnorm * V(SPLINE4));
        __Qp5 = (__vnorm * V(SPLINE5));
        __Qp6 = (__vnorm * V(SPLINE6));
        __Qp7 = (__vnorm * V(SPLINE7));
        __Qp8 = (__vnorm * V(SPLINE8));
        __Qp9 = (__vnorm * V(SPLINE9));
        __Tnorm =  0.0;
        if ((__SWNQS_i != 0)) begin
          __Tnorm = (((__MUNQS_i * phit1) * __BET_i) / (COX_qm * Gmob_dL_ac));
          __thesat2 = (((__thesat1_ac * __thesat1_ac) * phit1) * phit1);
          if ((__SWNQS_i == 1)) begin
            __dQy = (__QpN - __Qp0);
            __d2Qy = (((__Qp0 + __QpN) *  6.0) - (__Qp1 *  12.0));
          end
          else begin
            if ((__SWNQS_i == 2)) begin
              __dQy = (((((__Qp0 * -7.0) - (__Qp1 *  3.0)) + (__Qp2 *  12.0)) - (__QpN *  2.0)) /  5.0);
              __d2Qy = (((((__Qp0 * -4.0) + (__Qp1 *  9.0)) - (__Qp2 *  6.0)) + __QpN) * -3.6);
            end
            else begin
              if ((__SWNQS_i == 3)) begin
                __dQy = ((((((__Qp0 * -13.0) - (__Qp1 *  6.0)) + (__Qp2 *  24.0)) - (__Qp3 *  6.0)) + __QpN) /  7.0);
                __d2Qy = ((((((__Qp0 *  180.0) - (__Qp1 *  408.0)) + (__Qp2 *  288.0)) - (__Qp3 *  72.0)) + (__QpN *  12.0)) /  7.0);
              end
              else begin
                if ((__SWNQS_i == 5)) begin
                  __dQy = ((((((((__Qp0 * -181.0) - (__Qp1 *  84.0)) + (__Qp4 *  24.0)) - (__Qp5 *  6.0)) - (__Qp3 *  90.0)) + __QpN) + (__Qp2 *  336.0)) /  65.0);
                  __d2Qy = ((((((((__Qp4 *  432.0) - (__Qp5 *  108.0)) - (__Qp3 *  1.62e+3)) + (__QpN *  18.0)) + (__Qp0 *  3.762e+3)) - (__Qp1 *  8.532e+3)) + (__Qp2 *  6.048e+3)) /  65.0);
                end
                else begin
                  if ((__SWNQS_i == 9)) begin
                    __dQy = ((((((((((((__Qp6 *  1.68e+3) + (__Qp4 *  23.4e+3)) + (__QpN *  5.0)) - (__Qp3 *  87.33e+3)) + (__Qp8 *  120.0)) - (__Qp7 *  450.0)) - (__Qp1 *  81.48e+3)) + (__Qp2 *  325.92e+3)) - (__Qp0 *  175.565e+3)) - (__Qp9 *  30.0)) /  37.829e+3) - (__Qp5 *  0.165745856353591));
                    __d2Qy = ((((((((((((__Qp7 * -13.5e+3) + (__Qp4 *  702.0e+3)) - (__Qp3 * 2619900)) - (__Qp1 *  13.7931e+6)) + (__Qp2 *  9.7776e+6)) + (__Qp0 *  6.08175e+6)) + (__QpN *  150.0)) + (__Qp8 *  3.6e+3)) - (__Qp9 *  900.0)) + (__Qp6 *  50.4e+3)) /  37.829e+3) - (__Qp5 *  4.97237569060773));
                  end
                  else begin
                    __dQy =  0.0;
                    __d2Qy =  0.0;
                  end
                end
              end
            end
          end
          temp = ((__Qp1 / __pd) + __xg_ac);
          if ((abs(temp) <= __marginp)) begin
            __xphi = (temp / __a_factrp);
          end
          else begin
            if ((temp < (- __marginp))) begin
              __NQS_yg = (- temp);
              __NQS_z = ((__NQS_yg *  1.25) / __a_factrp);
              __NQS_eta = (((__NQS_z +  10.0) - sqrt((((__NQS_z -  6.0) * (__NQS_z -  6.0)) +  64.0))) *  0.5);
              __NQS_a = (((__NQS_yg - __NQS_eta) * (__NQS_yg - __NQS_eta)) + (__Gp2 * (__NQS_eta +  1.0)));
              __NQS_c = (((__NQS_yg - __NQS_eta) *  2.0) - __Gp2);
              __NQS_tau = (ln((__NQS_a / __Gp2)) - __NQS_eta);
              __nu = (__NQS_a + __NQS_c);
              __mutau = ((__nu * __nu) + (__NQS_tau * (((__NQS_c * __NQS_c) *  0.5) - __NQS_a)));
              __NQS_y0 = (__NQS_eta + (((__NQS_a * __nu) * __NQS_tau) / (__mutau + (((((__nu / __mutau) * __NQS_tau) * __NQS_tau) * __NQS_c) * (((__NQS_c * __NQS_c) *  0.333333333333333) - __NQS_a)))));
              if ((abs(__NQS_y0) <  230.258509299405)) begin
                __NQS_D0 = exp(__NQS_y0);
              end
              else begin
                if ((__NQS_y0 <  0.0)) begin
                  __NQS_D0 = ( 100.0e-102 / (((-230.258509299405 - __NQS_y0) * ((((-230.258509299405 - __NQS_y0) * (((-230.258509299405 - __NQS_y0) *  0.333333333333333) +  1.0)) *  0.5) +  1.0)) +  1.0));
                end
                else begin
                  __NQS_D0 = ((((__NQS_y0 -  230.258509299405) * ((((__NQS_y0 -  230.258509299405) * (((__NQS_y0 -  230.258509299405) *  0.333333333333333) +  1.0)) *  0.5) +  1.0)) +  1.0) *  10.0e+99);
                end
              end
              __NQS_xi = ( 1.0 - ((__Gp2 * __NQS_D0) *  0.5));
              __NQS_p = (((__NQS_yg - __NQS_y0) *  2.0) + (__Gp2 * (__NQS_D0 -  1.0)));
              __NQS_q = (((__NQS_yg - __NQS_y0) * (__NQS_yg - __NQS_y0)) + (__Gp2 * ((__NQS_y0 +  1.0) - __NQS_D0)));
              __NQS_temp = ((__NQS_p * __NQS_p) - ((__NQS_xi *  4.0) * __NQS_q));
              __NQS_w = ((__NQS_q *  2.0) / (__NQS_p + sqrt(__NQS_temp)));
              __xphi = (- (__NQS_y0 + __NQS_w));
            end
            else begin
              __NQS_xg1 = ( 1.0 / ((__Gp *  0.732464877560822) +  1.25));
              __NQS_A_fac = ((((__a_factrp *  1.25) * __NQS_xg1) -  1.0) * __NQS_xg1);
              __NQS_xbar = ((temp / __a_factrp) * ((__NQS_A_fac * temp) +  1.0));
              if ((abs((- __NQS_xbar)) <  230.258509299405)) begin
                __NQS_temp = exp((- __NQS_xbar));
              end
              else begin
                if (((- __NQS_xbar) <  0.0)) begin
                  __NQS_temp = ( 100.0e-102 / (((-230.258509299405 - (- __NQS_xbar)) * ((((-230.258509299405 - (- __NQS_xbar)) * (((-230.258509299405 - (- __NQS_xbar)) *  0.333333333333333) +  1.0)) *  0.5) +  1.0)) +  1.0));
                end
                else begin
                  __NQS_temp = (((((- __NQS_xbar) -  230.258509299405) * (((((- __NQS_xbar) -  230.258509299405) * ((((- __NQS_xbar) -  230.258509299405) *  0.333333333333333) +  1.0)) *  0.5) +  1.0)) +  1.0) *  10.0e+99);
                end
              end
              __NQS_w = ( 1.0 - __NQS_temp);
              __NQS_x0 = ((temp + (__Gp2 *  0.5)) - (__Gp * sqrt(((temp + (__Gp2 *  0.25)) - __NQS_w))));
              if ((abs((- __NQS_x0)) <  230.258509299405)) begin
                __NQS_D0 = exp((- __NQS_x0));
              end
              else begin
                if (((- __NQS_x0) <  0.0)) begin
                  __NQS_D0 = ( 100.0e-102 / (((-230.258509299405 - (- __NQS_x0)) * ((((-230.258509299405 - (- __NQS_x0)) * (((-230.258509299405 - (- __NQS_x0)) *  0.333333333333333) +  1.0)) *  0.5) +  1.0)) +  1.0));
                end
                else begin
                  __NQS_D0 = (((((- __NQS_x0) -  230.258509299405) * (((((- __NQS_x0) -  230.258509299405) * ((((- __NQS_x0) -  230.258509299405) *  0.333333333333333) +  1.0)) *  0.5) +  1.0)) +  1.0) *  10.0e+99);
                end
              end
              __NQS_xi = ( 1.0 - ((__Gp2 *  0.5) * __NQS_D0));
              __NQS_p = (((temp - __NQS_x0) *  2.0) + (__Gp2 * ( 1.0 - __NQS_D0)));
              __NQS_q = (((temp - __NQS_x0) * (temp - __NQS_x0)) - (__Gp2 * ((__NQS_x0 -  1.0) + __NQS_D0)));
              __NQS_temp = ((__NQS_p * __NQS_p) - ((__NQS_xi *  4.0) * __NQS_q));
              __NQS_u = ((__NQS_q *  2.0) / (__NQS_p + sqrt(__NQS_temp)));
              __xphi = (__NQS_x0 + __NQS_u);
            end
          end
          if ((abs(__xphi) <= __margin_ac)) begin
            __Qb_tmp = (((__xphi * -0.70710678) * __Gf_ac) * ( 1.0 - ((__xphi *  0.166666666666667) * ( 1.0 - (__xphi *  0.166666666666667)))));
            __dQbs = ((__Gf_ac * -0.70710678) * ( 1.0 - ((__xphi *  0.333333333333333) * ( 1.0 - (__xphi *  0.25)))));
            __d2Qis = ((__Gf_ac * -0.235702) * ( 1.0 - (__xphi *  0.5)));
          end
          else begin
            if ((abs((- __xphi)) <  230.258509299405)) begin
              temp = exp((- __xphi));
            end
            else begin
              if (((- __xphi) <  0.0)) begin
                temp = ( 100.0e-102 / (((-230.258509299405 - (- __xphi)) * ((((-230.258509299405 - (- __xphi)) * (((-230.258509299405 - (- __xphi)) *  0.333333333333333) +  1.0)) *  0.5) +  1.0)) +  1.0));
              end
              else begin
                temp = (((((- __xphi) -  230.258509299405) * (((((- __xphi) -  230.258509299405) * ((((- __xphi) -  230.258509299405) *  0.333333333333333) +  1.0)) *  0.5) +  1.0)) +  1.0) *  10.0e+99);
              end
            end
            __Qb_tmp = (__Gf_ac * sqrt(((temp + __xphi) -  1.0)));
            if ((__xphi > __margin_ac)) begin
              __Qb_tmp = (- __Qb_tmp);
            end
            __dQbs = ((((__Gf_ac *  0.5) * __Gf_ac) * ( 1.0 - temp)) / __Qb_tmp);
            __d2Qis = ((((__dQbs * __dQbs) - ((__Gf_ac *  0.5) * __Gf_ac)) / __Qb_tmp) + __dQbs);
          end
          __dQis = (__pd - __dQbs);
          __dQis_1 = ( 1.0 / __dQis);
          __fQi = ((__Qp1 * __dQis_1) -  1.0);
          __dfQi = (( 1.0 - (((__Qp1 * __d2Qis) * __dQis_1) * __dQis_1)) * __dQis_1);
          __fk0 = (((__dfQi * __dQy) * __dQy) + (__fQi * __d2Qy));
          __dpsy2 = (((__dQy * __dQy) * __dQis_1) * __dQis_1);
          __zsat_nqs = (__thesat2 * __dpsy2);
          if ((__CHNL_TYPE == -1)) begin
            __zsat_nqs = (__zsat_nqs / ((__thesat1_ac * __dps_ac) +  1.0));
          end
          temp = sqrt(((__zsat_nqs *  2.0) +  1.0));
          __Fvsat = ( 2.0 / (temp +  1.0));
          temp1 = (__d2Qy - (__dpsy2 * __d2Qis));
          __fk1 = (__Fvsat * (__fk0 - ((((__zsat_nqs * __fQi) * temp1) * __Fvsat) / temp)));
        end
        else begin
          __thesat2 =  0.0;
        end
        if ((__SWNQS_i >= 2)) begin
          if ((__SWNQS_i == 2)) begin
            __dQy = (((((__Qp0 *  2.0) - (__Qp1 *  12.0)) + (__Qp2 *  3.0)) + (__QpN *  7.0)) /  5.0);
            __d2Qy = (((((__QpN * -4.0) + (__Qp2 *  9.0)) - (__Qp1 *  6.0)) + __Qp0) * -3.6);
          end
          else begin
            if ((__SWNQS_i == 3)) begin
              __dQy = ((((__Qp0 *  0.5) - (__Qp1 *  3.0)) + (__Qp3 *  3.0)) - (__QpN *  0.5));
              __d2Qy = ((((((__Qp0 * -48.0) + (__Qp1 *  288.0)) - (__Qp2 *  480.0)) + (__Qp3 *  288.0)) - (__QpN *  48.0)) /  7.0);
            end
            else begin
              if ((__SWNQS_i == 5)) begin
                __dQy = ((((((__Qp1 * -291.0) - (__Qp2 *  6.0)) - (__Qp4 *  84.0)) + (__Qp5 *  21.0)) /  65.0) + ((((__Qp3 *  630.0) - (__QpN *  7.0)) + (__Qp0 *  97.0)) /  130.0));
                __d2Qy = ((((((((__Qp4 * -1.728e+3) + (__Qp5 *  432.0)) + (__Qp3 *  6.48e+3)) - (__QpN *  72.0)) - (__Qp0 *  1.008e+3)) + (__Qp1 *  6.048e+3)) - (__Qp2 *  10.152e+3)) /  65.0);
              end
              else begin
                if ((__SWNQS_i == 9)) begin
                  __dQy = (((((((((((__Qp6 * -5.88e+3) - (__Qp4 *  81.9e+3)) + (__Qp3 *  305.655e+3)) - (__Qp8 *  420.0)) + (__Qp9 *  105.0)) - (__Qp1 *  282.255e+3)) + (__Qp7 *  1.575e+3)) - (__Qp2 *  5.85e+3)) /  37.829e+3) + (__Qp5 *  0.580110497237569)) + (((__Qp0 *  94.085e+3) - (__QpN *  35.0)) /  75.658e+3));
                  __d2Qy = ((((((((((((__Qp1 *  9.7776e+6) + (__Qp7 *  54.0e+3)) - (__Qp4 *  2.808e+6)) + (__Qp3 *  10.4796e+6)) - (__Qp2 *  16.413e+6)) - (__Qp0 *  1.6296e+6)) - (__QpN *  600.0)) - (__Qp8 *  14.4e+3)) + (__Qp9 *  3.6e+3)) - (__Qp6 *  201.6e+3)) /  37.829e+3) + (__Qp5 *  19.8895027624309));
                end
                else begin
                  __dQy =  0.0;
                  __d2Qy =  0.0;
                end
              end
            end
          end
          temp = ((__Qp2 / __pd) + __xg_ac);
          if ((abs(temp) <= __marginp)) begin
            __xphi = (temp / __a_factrp);
          end
          else begin
            if ((temp < (- __marginp))) begin
              __NQS_yg = (- temp);
              __NQS_z = ((__NQS_yg *  1.25) / __a_factrp);
              __NQS_eta = (((__NQS_z +  10.0) - sqrt((((__NQS_z -  6.0) * (__NQS_z -  6.0)) +  64.0))) *  0.5);
              __NQS_a = (((__NQS_yg - __NQS_eta) * (__NQS_yg - __NQS_eta)) + (__Gp2 * (__NQS_eta +  1.0)));
              __NQS_c = (((__NQS_yg - __NQS_eta) *  2.0) - __Gp2);
              __NQS_tau = (ln((__NQS_a / __Gp2)) - __NQS_eta);
              __nu = (__NQS_a + __NQS_c);
              __mutau = ((__nu * __nu) + (__NQS_tau * (((__NQS_c * __NQS_c) *  0.5) - __NQS_a)));
              __NQS_y0 = (__NQS_eta + (((__NQS_a * __nu) * __NQS_tau) / (__mutau + (((((__nu / __mutau) * __NQS_tau) * __NQS_tau) * __NQS_c) * (((__NQS_c * __NQS_c) *  0.333333333333333) - __NQS_a)))));
              if ((abs(__NQS_y0) <  230.258509299405)) begin
                __NQS_D0 = exp(__NQS_y0);
              end
              else begin
                if ((__NQS_y0 <  0.0)) begin
                  __NQS_D0 = ( 100.0e-102 / (((-230.258509299405 - __NQS_y0) * ((((-230.258509299405 - __NQS_y0) * (((-230.258509299405 - __NQS_y0) *  0.333333333333333) +  1.0)) *  0.5) +  1.0)) +  1.0));
                end
                else begin
                  __NQS_D0 = ((((__NQS_y0 -  230.258509299405) * ((((__NQS_y0 -  230.258509299405) * (((__NQS_y0 -  230.258509299405) *  0.333333333333333) +  1.0)) *  0.5) +  1.0)) +  1.0) *  10.0e+99);
                end
              end
              __NQS_xi = ( 1.0 - ((__Gp2 * __NQS_D0) *  0.5));
              __NQS_p = (((__NQS_yg - __NQS_y0) *  2.0) + (__Gp2 * (__NQS_D0 -  1.0)));
              __NQS_q = (((__NQS_yg - __NQS_y0) * (__NQS_yg - __NQS_y0)) + (__Gp2 * ((__NQS_y0 +  1.0) - __NQS_D0)));
              __NQS_temp = ((__NQS_p * __NQS_p) - ((__NQS_xi *  4.0) * __NQS_q));
              __NQS_w = ((__NQS_q *  2.0) / (__NQS_p + sqrt(__NQS_temp)));
              __xphi = (- (__NQS_y0 + __NQS_w));
            end
            else begin
              __NQS_xg1 = ( 1.0 / ((__Gp *  0.732464877560822) +  1.25));
              __NQS_A_fac = ((((__a_factrp *  1.25) * __NQS_xg1) -  1.0) * __NQS_xg1);
              __NQS_xbar = ((temp / __a_factrp) * ((__NQS_A_fac * temp) +  1.0));
              if ((abs((- __NQS_xbar)) <  230.258509299405)) begin
                __NQS_temp = exp((- __NQS_xbar));
              end
              else begin
                if (((- __NQS_xbar) <  0.0)) begin
                  __NQS_temp = ( 100.0e-102 / (((-230.258509299405 - (- __NQS_xbar)) * ((((-230.258509299405 - (- __NQS_xbar)) * (((-230.258509299405 - (- __NQS_xbar)) *  0.333333333333333) +  1.0)) *  0.5) +  1.0)) +  1.0));
                end
                else begin
                  __NQS_temp = (((((- __NQS_xbar) -  230.258509299405) * (((((- __NQS_xbar) -  230.258509299405) * ((((- __NQS_xbar) -  230.258509299405) *  0.333333333333333) +  1.0)) *  0.5) +  1.0)) +  1.0) *  10.0e+99);
                end
              end
              __NQS_w = ( 1.0 - __NQS_temp);
              __NQS_x0 = ((temp + (__Gp2 *  0.5)) - (__Gp * sqrt(((temp + (__Gp2 *  0.25)) - __NQS_w))));
              if ((abs((- __NQS_x0)) <  230.258509299405)) begin
                __NQS_D0 = exp((- __NQS_x0));
              end
              else begin
                if (((- __NQS_x0) <  0.0)) begin
                  __NQS_D0 = ( 100.0e-102 / (((-230.258509299405 - (- __NQS_x0)) * ((((-230.258509299405 - (- __NQS_x0)) * (((-230.258509299405 - (- __NQS_x0)) *  0.333333333333333) +  1.0)) *  0.5) +  1.0)) +  1.0));
                end
                else begin
                  __NQS_D0 = (((((- __NQS_x0) -  230.258509299405) * (((((- __NQS_x0) -  230.258509299405) * ((((- __NQS_x0) -  230.258509299405) *  0.333333333333333) +  1.0)) *  0.5) +  1.0)) +  1.0) *  10.0e+99);
                end
              end
              __NQS_xi = ( 1.0 - ((__Gp2 *  0.5) * __NQS_D0));
              __NQS_p = (((temp - __NQS_x0) *  2.0) + (__Gp2 * ( 1.0 - __NQS_D0)));
              __NQS_q = (((temp - __NQS_x0) * (temp - __NQS_x0)) - (__Gp2 * ((__NQS_x0 -  1.0) + __NQS_D0)));
              __NQS_temp = ((__NQS_p * __NQS_p) - ((__NQS_xi *  4.0) * __NQS_q));
              __NQS_u = ((__NQS_q *  2.0) / (__NQS_p + sqrt(__NQS_temp)));
              __xphi = (__NQS_x0 + __NQS_u);
            end
          end
          if ((abs(__xphi) <= __margin_ac)) begin
            __Qb_tmp = (((__xphi * -0.70710678) * __Gf_ac) * ( 1.0 - ((__xphi *  0.166666666666667) * ( 1.0 - (__xphi *  0.166666666666667)))));
            __dQbs = ((__Gf_ac * -0.70710678) * ( 1.0 - ((__xphi *  0.333333333333333) * ( 1.0 - (__xphi *  0.25)))));
            __d2Qis = ((__Gf_ac * -0.235702) * ( 1.0 - (__xphi *  0.5)));
          end
          else begin
            if ((abs((- __xphi)) <  230.258509299405)) begin
              temp = exp((- __xphi));
            end
            else begin
              if (((- __xphi) <  0.0)) begin
                temp = ( 100.0e-102 / (((-230.258509299405 - (- __xphi)) * ((((-230.258509299405 - (- __xphi)) * (((-230.258509299405 - (- __xphi)) *  0.333333333333333) +  1.0)) *  0.5) +  1.0)) +  1.0));
              end
              else begin
                temp = (((((- __xphi) -  230.258509299405) * (((((- __xphi) -  230.258509299405) * ((((- __xphi) -  230.258509299405) *  0.333333333333333) +  1.0)) *  0.5) +  1.0)) +  1.0) *  10.0e+99);
              end
            end
            __Qb_tmp = (__Gf_ac * sqrt(((temp + __xphi) -  1.0)));
            if ((__xphi > __margin_ac)) begin
              __Qb_tmp = (- __Qb_tmp);
            end
            __dQbs = ((((__Gf_ac *  0.5) * __Gf_ac) * ( 1.0 - temp)) / __Qb_tmp);
            __d2Qis = ((((__dQbs * __dQbs) - ((__Gf_ac *  0.5) * __Gf_ac)) / __Qb_tmp) + __dQbs);
          end
          __dQis = (__pd - __dQbs);
          __dQis_1 = ( 1.0 / __dQis);
          __fQi = ((__Qp2 * __dQis_1) -  1.0);
          __dfQi = (( 1.0 - (((__Qp2 * __d2Qis) * __dQis_1) * __dQis_1)) * __dQis_1);
          __fk0 = (((__dfQi * __dQy) * __dQy) + (__fQi * __d2Qy));
          __dpsy2 = (((__dQy * __dQy) * __dQis_1) * __dQis_1);
          __zsat_nqs = (__thesat2 * __dpsy2);
          if ((__CHNL_TYPE == -1)) begin
            __zsat_nqs = (__zsat_nqs / ((__thesat1_ac * __dps_ac) +  1.0));
          end
          temp = sqrt(((__zsat_nqs *  2.0) +  1.0));
          __Fvsat = ( 2.0 / (temp +  1.0));
          temp1 = (__d2Qy - (__dpsy2 * __d2Qis));
          __fk2 = (__Fvsat * (__fk0 - ((((__zsat_nqs * __fQi) * temp1) * __Fvsat) / temp)));
        end
        if ((__SWNQS_i >= 3)) begin
          if ((__SWNQS_i == 3)) begin
            __dQy = ((((((__QpN *  13.0) + (__Qp3 *  6.0)) - (__Qp2 *  24.0)) + (__Qp1 *  6.0)) - __Qp0) /  7.0);
            __d2Qy = ((((((__QpN *  180.0) - (__Qp3 *  408.0)) + (__Qp2 *  288.0)) - (__Qp1 *  72.0)) + (__Qp0 *  12.0)) /  7.0);
          end
          else begin
            if ((__SWNQS_i == 5)) begin
              __dQy = ((((((__QpN - (__Qp5 *  6.0)) + (__Qp4 *  24.0)) - (__Qp2 *  24.0)) + (__Qp1 *  6.0)) - __Qp0) /  5.0);
              __d2Qy = ((((((__Qp4 + __Qp2) *  1.296e+3) - ((__Qp5 + __Qp1) *  324.0)) - (__Qp3 *  2.052e+3)) + ((__QpN + __Qp0) *  54.0)) /  13.0);
            end
            else begin
              if ((__SWNQS_i == 9)) begin
                __dQy = ((((((((((((__Qp6 *  21.84e+3) + (__Qp4 *  304.2e+3)) + (__QpN *  65.0)) - (__Qp3 *  420.0)) + (__Qp8 *  1.56e+3)) - (__Qp0 *  12.605e+3)) - (__Qp9 *  390.0)) + (__Qp1 *  75.63e+3)) - (__Qp7 *  5.85e+3)) - (__Qp2 *  302.52e+3)) /  37.829e+3) - (__Qp5 *  2.15469613259669));
                __d2Qy = ((((((((((((__Qp1 * -2.6199e+6) - (__Qp7 *  202.5e+3)) + (__Qp4 *  10.53e+6)) - (__Qp3 *  16.6011e+6)) + (__Qp2 *  10.4796e+6)) + (__Qp0 *  436.65e+3)) + (__QpN *  2.25e+3)) + (__Qp8 *  54.0e+3)) - (__Qp9 *  13.5e+3)) + (__Qp6 *  756.0e+3)) /  37.829e+3) - (__Qp5 *  74.585635359116));
              end
              else begin
                __dQy =  0.0;
                __d2Qy =  0.0;
              end
            end
          end
          temp = ((__Qp3 / __pd) + __xg_ac);
          if ((abs(temp) <= __marginp)) begin
            __xphi = (temp / __a_factrp);
          end
          else begin
            if ((temp < (- __marginp))) begin
              __NQS_yg = (- temp);
              __NQS_z = ((__NQS_yg *  1.25) / __a_factrp);
              __NQS_eta = (((__NQS_z +  10.0) - sqrt((((__NQS_z -  6.0) * (__NQS_z -  6.0)) +  64.0))) *  0.5);
              __NQS_a = (((__NQS_yg - __NQS_eta) * (__NQS_yg - __NQS_eta)) + (__Gp2 * (__NQS_eta +  1.0)));
              __NQS_c = (((__NQS_yg - __NQS_eta) *  2.0) - __Gp2);
              __NQS_tau = (ln((__NQS_a / __Gp2)) - __NQS_eta);
              __nu = (__NQS_a + __NQS_c);
              __mutau = ((__nu * __nu) + (__NQS_tau * (((__NQS_c * __NQS_c) *  0.5) - __NQS_a)));
              __NQS_y0 = (__NQS_eta + (((__NQS_a * __nu) * __NQS_tau) / (__mutau + (((((__nu / __mutau) * __NQS_tau) * __NQS_tau) * __NQS_c) * (((__NQS_c * __NQS_c) *  0.333333333333333) - __NQS_a)))));
              if ((abs(__NQS_y0) <  230.258509299405)) begin
                __NQS_D0 = exp(__NQS_y0);
              end
              else begin
                if ((__NQS_y0 <  0.0)) begin
                  __NQS_D0 = ( 100.0e-102 / (((-230.258509299405 - __NQS_y0) * ((((-230.258509299405 - __NQS_y0) * (((-230.258509299405 - __NQS_y0) *  0.333333333333333) +  1.0)) *  0.5) +  1.0)) +  1.0));
                end
                else begin
                  __NQS_D0 = ((((__NQS_y0 -  230.258509299405) * ((((__NQS_y0 -  230.258509299405) * (((__NQS_y0 -  230.258509299405) *  0.333333333333333) +  1.0)) *  0.5) +  1.0)) +  1.0) *  10.0e+99);
                end
              end
              __NQS_xi = ( 1.0 - ((__Gp2 * __NQS_D0) *  0.5));
              __NQS_p = (((__NQS_yg - __NQS_y0) *  2.0) + (__Gp2 * (__NQS_D0 -  1.0)));
              __NQS_q = (((__NQS_yg - __NQS_y0) * (__NQS_yg - __NQS_y0)) + (__Gp2 * ((__NQS_y0 +  1.0) - __NQS_D0)));
              __NQS_temp = ((__NQS_p * __NQS_p) - ((__NQS_xi *  4.0) * __NQS_q));
              __NQS_w = ((__NQS_q *  2.0) / (__NQS_p + sqrt(__NQS_temp)));
              __xphi = (- (__NQS_y0 + __NQS_w));
            end
            else begin
              __NQS_xg1 = ( 1.0 / ((__Gp *  0.732464877560822) +  1.25));
              __NQS_A_fac = ((((__a_factrp *  1.25) * __NQS_xg1) -  1.0) * __NQS_xg1);
              __NQS_xbar = ((temp / __a_factrp) * ((__NQS_A_fac * temp) +  1.0));
              if ((abs((- __NQS_xbar)) <  230.258509299405)) begin
                __NQS_temp = exp((- __NQS_xbar));
              end
              else begin
                if (((- __NQS_xbar) <  0.0)) begin
                  __NQS_temp = ( 100.0e-102 / (((-230.258509299405 - (- __NQS_xbar)) * ((((-230.258509299405 - (- __NQS_xbar)) * (((-230.258509299405 - (- __NQS_xbar)) *  0.333333333333333) +  1.0)) *  0.5) +  1.0)) +  1.0));
                end
                else begin
                  __NQS_temp = (((((- __NQS_xbar) -  230.258509299405) * (((((- __NQS_xbar) -  230.258509299405) * ((((- __NQS_xbar) -  230.258509299405) *  0.333333333333333) +  1.0)) *  0.5) +  1.0)) +  1.0) *  10.0e+99);
                end
              end
              __NQS_w = ( 1.0 - __NQS_temp);
              __NQS_x0 = ((temp + (__Gp2 *  0.5)) - (__Gp * sqrt(((temp + (__Gp2 *  0.25)) - __NQS_w))));
              if ((abs((- __NQS_x0)) <  230.258509299405)) begin
                __NQS_D0 = exp((- __NQS_x0));
              end
              else begin
                if (((- __NQS_x0) <  0.0)) begin
                  __NQS_D0 = ( 100.0e-102 / (((-230.258509299405 - (- __NQS_x0)) * ((((-230.258509299405 - (- __NQS_x0)) * (((-230.258509299405 - (- __NQS_x0)) *  0.333333333333333) +  1.0)) *  0.5) +  1.0)) +  1.0));
                end
                else begin
                  __NQS_D0 = (((((- __NQS_x0) -  230.258509299405) * (((((- __NQS_x0) -  230.258509299405) * ((((- __NQS_x0) -  230.258509299405) *  0.333333333333333) +  1.0)) *  0.5) +  1.0)) +  1.0) *  10.0e+99);
                end
              end
              __NQS_xi = ( 1.0 - ((__Gp2 *  0.5) * __NQS_D0));
              __NQS_p = (((temp - __NQS_x0) *  2.0) + (__Gp2 * ( 1.0 - __NQS_D0)));
              __NQS_q = (((temp - __NQS_x0) * (temp - __NQS_x0)) - (__Gp2 * ((__NQS_x0 -  1.0) + __NQS_D0)));
              __NQS_temp = ((__NQS_p * __NQS_p) - ((__NQS_xi *  4.0) * __NQS_q));
              __NQS_u = ((__NQS_q *  2.0) / (__NQS_p + sqrt(__NQS_temp)));
              __xphi = (__NQS_x0 + __NQS_u);
            end
          end
          if ((abs(__xphi) <= __margin_ac)) begin
            __Qb_tmp = (((__xphi * -0.70710678) * __Gf_ac) * ( 1.0 - ((__xphi *  0.166666666666667) * ( 1.0 - (__xphi *  0.166666666666667)))));
            __dQbs = ((__Gf_ac * -0.70710678) * ( 1.0 - ((__xphi *  0.333333333333333) * ( 1.0 - (__xphi *  0.25)))));
            __d2Qis = ((__Gf_ac * -0.235702) * ( 1.0 - (__xphi *  0.5)));
          end
          else begin
            if ((abs((- __xphi)) <  230.258509299405)) begin
              temp = exp((- __xphi));
            end
            else begin
              if (((- __xphi) <  0.0)) begin
                temp = ( 100.0e-102 / (((-230.258509299405 - (- __xphi)) * ((((-230.258509299405 - (- __xphi)) * (((-230.258509299405 - (- __xphi)) *  0.333333333333333) +  1.0)) *  0.5) +  1.0)) +  1.0));
              end
              else begin
                temp = (((((- __xphi) -  230.258509299405) * (((((- __xphi) -  230.258509299405) * ((((- __xphi) -  230.258509299405) *  0.333333333333333) +  1.0)) *  0.5) +  1.0)) +  1.0) *  10.0e+99);
              end
            end
            __Qb_tmp = (__Gf_ac * sqrt(((temp + __xphi) -  1.0)));
            if ((__xphi > __margin_ac)) begin
              __Qb_tmp = (- __Qb_tmp);
            end
            __dQbs = ((((__Gf_ac *  0.5) * __Gf_ac) * ( 1.0 - temp)) / __Qb_tmp);
            __d2Qis = ((((__dQbs * __dQbs) - ((__Gf_ac *  0.5) * __Gf_ac)) / __Qb_tmp) + __dQbs);
          end
          __dQis = (__pd - __dQbs);
          __dQis_1 = ( 1.0 / __dQis);
          __fQi = ((__Qp3 * __dQis_1) -  1.0);
          __dfQi = (( 1.0 - (((__Qp3 * __d2Qis) * __dQis_1) * __dQis_1)) * __dQis_1);
          __fk0 = (((__dfQi * __dQy) * __dQy) + (__fQi * __d2Qy));
          __dpsy2 = (((__dQy * __dQy) * __dQis_1) * __dQis_1);
          __zsat_nqs = (__thesat2 * __dpsy2);
          if ((__CHNL_TYPE == -1)) begin
            __zsat_nqs = (__zsat_nqs / ((__thesat1_ac * __dps_ac) +  1.0));
          end
          temp = sqrt(((__zsat_nqs *  2.0) +  1.0));
          __Fvsat = ( 2.0 / (temp +  1.0));
          temp1 = (__d2Qy - (__dpsy2 * __d2Qis));
          __fk3 = (__Fvsat * (__fk0 - ((((__zsat_nqs * __fQi) * temp1) * __Fvsat) / temp)));
        end
        if ((__SWNQS_i >= 4)) begin
          if ((__SWNQS_i == 5)) begin
            __dQy = ((((((((__Qp3 * -630.0) + (__Qp4 *  12.0)) + (__Qp5 *  582.0)) - (__QpN *  97.0)) + (__Qp0 *  7.0)) - (__Qp1 *  42.0)) + (__Qp2 *  168.0)) /  130.0);
            __d2Qy = ((((((((__Qp4 * -10.152e+3) + (__Qp5 *  6.048e+3)) + (__Qp3 *  6.48e+3)) - (__QpN *  1.008e+3)) - (__Qp0 *  72.0)) + (__Qp1 *  432.0)) - (__Qp2 *  1.728e+3)) /  65.0);
          end
          else begin
            if ((__SWNQS_i == 9)) begin
              __dQy = ((((((((((((__Qp6 * -81.48e+3) - (__Qp4 *  30.0)) - (__Qp3 *  303.975e+3)) - (__Qp8 *  5.82e+3)) + (__Qp9 *  1.455e+3)) - (__Qp1 *  20.265e+3)) + (__Qp7 *  21.825e+3)) + (__Qp2 *  81.06e+3)) /  37.829e+3) - (__QpN *  0.00641042586375532)) + (__Qp5 *  8.03867403314917)) + (__Qp0 *  0.0892833540405509));
              __d2Qy = ((((((((((((__Qp1 *  702.0e+3) + (__Qp7 *  756.0e+3)) - (__Qp4 *  16.6146e+6)) + (__Qp3 *  10.53e+6)) - (__Qp2 *  2.808e+6)) - (__Qp0 *  117.0e+3)) - (__QpN *  8.4e+3)) - (__Qp8 *  201.6e+3)) + (__Qp9 *  50.4e+3)) - (__Qp6 *  2.8224e+6)) /  37.829e+3) + (__Qp5 *  278.453038674033));
            end
            else begin
              __dQy =  0.0;
              __d2Qy =  0.0;
            end
          end
          temp = ((__Qp4 / __pd) + __xg_ac);
          if ((abs(temp) <= __marginp)) begin
            __xphi = (temp / __a_factrp);
          end
          else begin
            if ((temp < (- __marginp))) begin
              __NQS_yg = (- temp);
              __NQS_z = ((__NQS_yg *  1.25) / __a_factrp);
              __NQS_eta = (((__NQS_z +  10.0) - sqrt((((__NQS_z -  6.0) * (__NQS_z -  6.0)) +  64.0))) *  0.5);
              __NQS_a = (((__NQS_yg - __NQS_eta) * (__NQS_yg - __NQS_eta)) + (__Gp2 * (__NQS_eta +  1.0)));
              __NQS_c = (((__NQS_yg - __NQS_eta) *  2.0) - __Gp2);
              __NQS_tau = (ln((__NQS_a / __Gp2)) - __NQS_eta);
              __nu = (__NQS_a + __NQS_c);
              __mutau = ((__nu * __nu) + (__NQS_tau * (((__NQS_c * __NQS_c) *  0.5) - __NQS_a)));
              __NQS_y0 = (__NQS_eta + (((__NQS_a * __nu) * __NQS_tau) / (__mutau + (((((__nu / __mutau) * __NQS_tau) * __NQS_tau) * __NQS_c) * (((__NQS_c * __NQS_c) *  0.333333333333333) - __NQS_a)))));
              if ((abs(__NQS_y0) <  230.258509299405)) begin
                __NQS_D0 = exp(__NQS_y0);
              end
              else begin
                if ((__NQS_y0 <  0.0)) begin
                  __NQS_D0 = ( 100.0e-102 / (((-230.258509299405 - __NQS_y0) * ((((-230.258509299405 - __NQS_y0) * (((-230.258509299405 - __NQS_y0) *  0.333333333333333) +  1.0)) *  0.5) +  1.0)) +  1.0));
                end
                else begin
                  __NQS_D0 = ((((__NQS_y0 -  230.258509299405) * ((((__NQS_y0 -  230.258509299405) * (((__NQS_y0 -  230.258509299405) *  0.333333333333333) +  1.0)) *  0.5) +  1.0)) +  1.0) *  10.0e+99);
                end
              end
              __NQS_xi = ( 1.0 - ((__Gp2 * __NQS_D0) *  0.5));
              __NQS_p = (((__NQS_yg - __NQS_y0) *  2.0) + (__Gp2 * (__NQS_D0 -  1.0)));
              __NQS_q = (((__NQS_yg - __NQS_y0) * (__NQS_yg - __NQS_y0)) + (__Gp2 * ((__NQS_y0 +  1.0) - __NQS_D0)));
              __NQS_temp = ((__NQS_p * __NQS_p) - ((__NQS_xi *  4.0) * __NQS_q));
              __NQS_w = ((__NQS_q *  2.0) / (__NQS_p + sqrt(__NQS_temp)));
              __xphi = (- (__NQS_y0 + __NQS_w));
            end
            else begin
              __NQS_xg1 = ( 1.0 / ((__Gp *  0.732464877560822) +  1.25));
              __NQS_A_fac = ((((__a_factrp *  1.25) * __NQS_xg1) -  1.0) * __NQS_xg1);
              __NQS_xbar = ((temp / __a_factrp) * ((__NQS_A_fac * temp) +  1.0));
              if ((abs((- __NQS_xbar)) <  230.258509299405)) begin
                __NQS_temp = exp((- __NQS_xbar));
              end
              else begin
                if (((- __NQS_xbar) <  0.0)) begin
                  __NQS_temp = ( 100.0e-102 / (((-230.258509299405 - (- __NQS_xbar)) * ((((-230.258509299405 - (- __NQS_xbar)) * (((-230.258509299405 - (- __NQS_xbar)) *  0.333333333333333) +  1.0)) *  0.5) +  1.0)) +  1.0));
                end
                else begin
                  __NQS_temp = (((((- __NQS_xbar) -  230.258509299405) * (((((- __NQS_xbar) -  230.258509299405) * ((((- __NQS_xbar) -  230.258509299405) *  0.333333333333333) +  1.0)) *  0.5) +  1.0)) +  1.0) *  10.0e+99);
                end
              end
              __NQS_w = ( 1.0 - __NQS_temp);
              __NQS_x0 = ((temp + (__Gp2 *  0.5)) - (__Gp * sqrt(((temp + (__Gp2 *  0.25)) - __NQS_w))));
              if ((abs((- __NQS_x0)) <  230.258509299405)) begin
                __NQS_D0 = exp((- __NQS_x0));
              end
              else begin
                if (((- __NQS_x0) <  0.0)) begin
                  __NQS_D0 = ( 100.0e-102 / (((-230.258509299405 - (- __NQS_x0)) * ((((-230.258509299405 - (- __NQS_x0)) * (((-230.258509299405 - (- __NQS_x0)) *  0.333333333333333) +  1.0)) *  0.5) +  1.0)) +  1.0));
                end
                else begin
                  __NQS_D0 = (((((- __NQS_x0) -  230.258509299405) * (((((- __NQS_x0) -  230.258509299405) * ((((- __NQS_x0) -  230.258509299405) *  0.333333333333333) +  1.0)) *  0.5) +  1.0)) +  1.0) *  10.0e+99);
                end
              end
              __NQS_xi = ( 1.0 - ((__Gp2 *  0.5) * __NQS_D0));
              __NQS_p = (((temp - __NQS_x0) *  2.0) + (__Gp2 * ( 1.0 - __NQS_D0)));
              __NQS_q = (((temp - __NQS_x0) * (temp - __NQS_x0)) - (__Gp2 * ((__NQS_x0 -  1.0) + __NQS_D0)));
              __NQS_temp = ((__NQS_p * __NQS_p) - ((__NQS_xi *  4.0) * __NQS_q));
              __NQS_u = ((__NQS_q *  2.0) / (__NQS_p + sqrt(__NQS_temp)));
              __xphi = (__NQS_x0 + __NQS_u);
            end
          end
          if ((abs(__xphi) <= __margin_ac)) begin
            __Qb_tmp = (((__xphi * -0.70710678) * __Gf_ac) * ( 1.0 - ((__xphi *  0.166666666666667) * ( 1.0 - (__xphi *  0.166666666666667)))));
            __dQbs = ((__Gf_ac * -0.70710678) * ( 1.0 - ((__xphi *  0.333333333333333) * ( 1.0 - (__xphi *  0.25)))));
            __d2Qis = ((__Gf_ac * -0.235702) * ( 1.0 - (__xphi *  0.5)));
          end
          else begin
            if ((abs((- __xphi)) <  230.258509299405)) begin
              temp = exp((- __xphi));
            end
            else begin
              if (((- __xphi) <  0.0)) begin
                temp = ( 100.0e-102 / (((-230.258509299405 - (- __xphi)) * ((((-230.258509299405 - (- __xphi)) * (((-230.258509299405 - (- __xphi)) *  0.333333333333333) +  1.0)) *  0.5) +  1.0)) +  1.0));
              end
              else begin
                temp = (((((- __xphi) -  230.258509299405) * (((((- __xphi) -  230.258509299405) * ((((- __xphi) -  230.258509299405) *  0.333333333333333) +  1.0)) *  0.5) +  1.0)) +  1.0) *  10.0e+99);
              end
            end
            __Qb_tmp = (__Gf_ac * sqrt(((temp + __xphi) -  1.0)));
            if ((__xphi > __margin_ac)) begin
              __Qb_tmp = (- __Qb_tmp);
            end
            __dQbs = ((((__Gf_ac *  0.5) * __Gf_ac) * ( 1.0 - temp)) / __Qb_tmp);
            __d2Qis = ((((__dQbs * __dQbs) - ((__Gf_ac *  0.5) * __Gf_ac)) / __Qb_tmp) + __dQbs);
          end
          __dQis = (__pd - __dQbs);
          __dQis_1 = ( 1.0 / __dQis);
          __fQi = ((__Qp4 * __dQis_1) -  1.0);
          __dfQi = (( 1.0 - (((__Qp4 * __d2Qis) * __dQis_1) * __dQis_1)) * __dQis_1);
          __fk0 = (((__dfQi * __dQy) * __dQy) + (__fQi * __d2Qy));
          __dpsy2 = (((__dQy * __dQy) * __dQis_1) * __dQis_1);
          __zsat_nqs = (__thesat2 * __dpsy2);
          if ((__CHNL_TYPE == -1)) begin
            __zsat_nqs = (__zsat_nqs / ((__thesat1_ac * __dps_ac) +  1.0));
          end
          temp = sqrt(((__zsat_nqs *  2.0) +  1.0));
          __Fvsat = ( 2.0 / (temp +  1.0));
          temp1 = (__d2Qy - (__dpsy2 * __d2Qis));
          __fk4 = (__Fvsat * (__fk0 - ((((__zsat_nqs * __fQi) * temp1) * __Fvsat) / temp)));
        end
        if ((__SWNQS_i >= 5)) begin
          if ((__SWNQS_i == 5)) begin
            __dQy = ((((((((__Qp4 * -336.0) + (__Qp5 *  84.0)) + (__Qp3 *  90.0)) + (__QpN *  181.0)) - __Qp0) + (__Qp1 *  6.0)) - (__Qp2 *  24.0)) /  65.0);
            __d2Qy = ((((((((__Qp0 *  18.0) + (__QpN *  3.762e+3)) + (__Qp4 *  6.048e+3)) + (__Qp2 *  432.0)) - (__Qp3 *  1.62e+3)) - (__Qp1 *  108.0)) - (__Qp5 *  8.532e+3)) /  65.0);
          end
          else begin
            if ((__SWNQS_i == 9)) begin
              __dQy = (((((((__Qp6 - __Qp4) *  1.68e+3) + ((__QpN - __Qp0) *  5.0)) + ((__Qp3 - __Qp7) *  450.0)) + ((__Qp8 - __Qp2) *  120.0)) - ((__Qp9 - __Qp1) *  30.0)) /  209.0);
              __d2Qy = ((((((((__Qp1 + __Qp9) * -900.0) - ((__Qp7 + __Qp3) *  13.5e+3)) - (__Qp5 *  79.5e+3)) + ((__Qp4 + __Qp6) *  50.4e+3)) + ((__Qp2 + __Qp8) *  3.6e+3)) + ((__Qp0 + __QpN) *  150.0)) /  181.0);
            end
            else begin
              __dQy =  0.0;
              __d2Qy =  0.0;
            end
          end
          temp = ((__Qp5 / __pd) + __xg_ac);
          if ((abs(temp) <= __marginp)) begin
            __xphi = (temp / __a_factrp);
          end
          else begin
            if ((temp < (- __marginp))) begin
              __NQS_yg = (- temp);
              __NQS_z = ((__NQS_yg *  1.25) / __a_factrp);
              __NQS_eta = (((__NQS_z +  10.0) - sqrt((((__NQS_z -  6.0) * (__NQS_z -  6.0)) +  64.0))) *  0.5);
              __NQS_a = (((__NQS_yg - __NQS_eta) * (__NQS_yg - __NQS_eta)) + (__Gp2 * (__NQS_eta +  1.0)));
              __NQS_c = (((__NQS_yg - __NQS_eta) *  2.0) - __Gp2);
              __NQS_tau = (ln((__NQS_a / __Gp2)) - __NQS_eta);
              __nu = (__NQS_a + __NQS_c);
              __mutau = ((__nu * __nu) + (__NQS_tau * (((__NQS_c * __NQS_c) *  0.5) - __NQS_a)));
              __NQS_y0 = (__NQS_eta + (((__NQS_a * __nu) * __NQS_tau) / (__mutau + (((((__nu / __mutau) * __NQS_tau) * __NQS_tau) * __NQS_c) * (((__NQS_c * __NQS_c) *  0.333333333333333) - __NQS_a)))));
              if ((abs(__NQS_y0) <  230.258509299405)) begin
                __NQS_D0 = exp(__NQS_y0);
              end
              else begin
                if ((__NQS_y0 <  0.0)) begin
                  __NQS_D0 = ( 100.0e-102 / (((-230.258509299405 - __NQS_y0) * ((((-230.258509299405 - __NQS_y0) * (((-230.258509299405 - __NQS_y0) *  0.333333333333333) +  1.0)) *  0.5) +  1.0)) +  1.0));
                end
                else begin
                  __NQS_D0 = ((((__NQS_y0 -  230.258509299405) * ((((__NQS_y0 -  230.258509299405) * (((__NQS_y0 -  230.258509299405) *  0.333333333333333) +  1.0)) *  0.5) +  1.0)) +  1.0) *  10.0e+99);
                end
              end
              __NQS_xi = ( 1.0 - ((__Gp2 * __NQS_D0) *  0.5));
              __NQS_p = (((__NQS_yg - __NQS_y0) *  2.0) + (__Gp2 * (__NQS_D0 -  1.0)));
              __NQS_q = (((__NQS_yg - __NQS_y0) * (__NQS_yg - __NQS_y0)) + (__Gp2 * ((__NQS_y0 +  1.0) - __NQS_D0)));
              __NQS_temp = ((__NQS_p * __NQS_p) - ((__NQS_xi *  4.0) * __NQS_q));
              __NQS_w = ((__NQS_q *  2.0) / (__NQS_p + sqrt(__NQS_temp)));
              __xphi = (- (__NQS_y0 + __NQS_w));
            end
            else begin
              __NQS_xg1 = ( 1.0 / ((__Gp *  0.732464877560822) +  1.25));
              __NQS_A_fac = ((((__a_factrp *  1.25) * __NQS_xg1) -  1.0) * __NQS_xg1);
              __NQS_xbar = ((temp / __a_factrp) * ((__NQS_A_fac * temp) +  1.0));
              if ((abs((- __NQS_xbar)) <  230.258509299405)) begin
                __NQS_temp = exp((- __NQS_xbar));
              end
              else begin
                if (((- __NQS_xbar) <  0.0)) begin
                  __NQS_temp = ( 100.0e-102 / (((-230.258509299405 - (- __NQS_xbar)) * ((((-230.258509299405 - (- __NQS_xbar)) * (((-230.258509299405 - (- __NQS_xbar)) *  0.333333333333333) +  1.0)) *  0.5) +  1.0)) +  1.0));
                end
                else begin
                  __NQS_temp = (((((- __NQS_xbar) -  230.258509299405) * (((((- __NQS_xbar) -  230.258509299405) * ((((- __NQS_xbar) -  230.258509299405) *  0.333333333333333) +  1.0)) *  0.5) +  1.0)) +  1.0) *  10.0e+99);
                end
              end
              __NQS_w = ( 1.0 - __NQS_temp);
              __NQS_x0 = ((temp + (__Gp2 *  0.5)) - (__Gp * sqrt(((temp + (__Gp2 *  0.25)) - __NQS_w))));
              if ((abs((- __NQS_x0)) <  230.258509299405)) begin
                __NQS_D0 = exp((- __NQS_x0));
              end
              else begin
                if (((- __NQS_x0) <  0.0)) begin
                  __NQS_D0 = ( 100.0e-102 / (((-230.258509299405 - (- __NQS_x0)) * ((((-230.258509299405 - (- __NQS_x0)) * (((-230.258509299405 - (- __NQS_x0)) *  0.333333333333333) +  1.0)) *  0.5) +  1.0)) +  1.0));
                end
                else begin
                  __NQS_D0 = (((((- __NQS_x0) -  230.258509299405) * (((((- __NQS_x0) -  230.258509299405) * ((((- __NQS_x0) -  230.258509299405) *  0.333333333333333) +  1.0)) *  0.5) +  1.0)) +  1.0) *  10.0e+99);
                end
              end
              __NQS_xi = ( 1.0 - ((__Gp2 *  0.5) * __NQS_D0));
              __NQS_p = (((temp - __NQS_x0) *  2.0) + (__Gp2 * ( 1.0 - __NQS_D0)));
              __NQS_q = (((temp - __NQS_x0) * (temp - __NQS_x0)) - (__Gp2 * ((__NQS_x0 -  1.0) + __NQS_D0)));
              __NQS_temp = ((__NQS_p * __NQS_p) - ((__NQS_xi *  4.0) * __NQS_q));
              __NQS_u = ((__NQS_q *  2.0) / (__NQS_p + sqrt(__NQS_temp)));
              __xphi = (__NQS_x0 + __NQS_u);
            end
          end
          if ((abs(__xphi) <= __margin_ac)) begin
            __Qb_tmp = (((__xphi * -0.70710678) * __Gf_ac) * ( 1.0 - ((__xphi *  0.166666666666667) * ( 1.0 - (__xphi *  0.166666666666667)))));
            __dQbs = ((__Gf_ac * -0.70710678) * ( 1.0 - ((__xphi *  0.333333333333333) * ( 1.0 - (__xphi *  0.25)))));
            __d2Qis = ((__Gf_ac * -0.235702) * ( 1.0 - (__xphi *  0.5)));
          end
          else begin
            if ((abs((- __xphi)) <  230.258509299405)) begin
              temp = exp((- __xphi));
            end
            else begin
              if (((- __xphi) <  0.0)) begin
                temp = ( 100.0e-102 / (((-230.258509299405 - (- __xphi)) * ((((-230.258509299405 - (- __xphi)) * (((-230.258509299405 - (- __xphi)) *  0.333333333333333) +  1.0)) *  0.5) +  1.0)) +  1.0));
              end
              else begin
                temp = (((((- __xphi) -  230.258509299405) * (((((- __xphi) -  230.258509299405) * ((((- __xphi) -  230.258509299405) *  0.333333333333333) +  1.0)) *  0.5) +  1.0)) +  1.0) *  10.0e+99);
              end
            end
            __Qb_tmp = (__Gf_ac * sqrt(((temp + __xphi) -  1.0)));
            if ((__xphi > __margin_ac)) begin
              __Qb_tmp = (- __Qb_tmp);
            end
            __dQbs = ((((__Gf_ac *  0.5) * __Gf_ac) * ( 1.0 - temp)) / __Qb_tmp);
            __d2Qis = ((((__dQbs * __dQbs) - ((__Gf_ac *  0.5) * __Gf_ac)) / __Qb_tmp) + __dQbs);
          end
          __dQis = (__pd - __dQbs);
          __dQis_1 = ( 1.0 / __dQis);
          __fQi = ((__Qp5 * __dQis_1) -  1.0);
          __dfQi = (( 1.0 - (((__Qp5 * __d2Qis) * __dQis_1) * __dQis_1)) * __dQis_1);
          __fk0 = (((__dfQi * __dQy) * __dQy) + (__fQi * __d2Qy));
          __dpsy2 = (((__dQy * __dQy) * __dQis_1) * __dQis_1);
          __zsat_nqs = (__thesat2 * __dpsy2);
          if ((__CHNL_TYPE == -1)) begin
            __zsat_nqs = (__zsat_nqs / ((__thesat1_ac * __dps_ac) +  1.0));
          end
          temp = sqrt(((__zsat_nqs *  2.0) +  1.0));
          __Fvsat = ( 2.0 / (temp +  1.0));
          temp1 = (__d2Qy - (__dpsy2 * __d2Qis));
          __fk5 = (__Fvsat * (__fk0 - ((((__zsat_nqs * __fQi) * temp1) * __Fvsat) / temp)));
        end
        if ((__SWNQS_i >= 6)) begin
          if ((__SWNQS_i == 9)) begin
            __dQy = (((((((((((__Qp6 *  30.0) + (__Qp4 *  81.48e+3)) - (__Qp3 *  21.825e+3)) - (__Qp8 *  81.06e+3)) + (__Qp9 *  20.265e+3)) - (__Qp1 *  1.455e+3)) + (__Qp7 *  303.975e+3)) + (__Qp2 *  5.82e+3)) /  37.829e+3) - (((__QpN *  6.755e+3) - (__Qp0 *  485.0)) /  75.658e+3)) - (__Qp5 *  8.03867403314917));
            __d2Qy = ((((((((((((__Qp1 *  50.4e+3) + (__Qp7 *  10.53e+6)) - (__Qp4 *  2.8224e+6)) + (__Qp3 *  756.0e+3)) - (__Qp2 *  201.6e+3)) - (__Qp0 *  8.4e+3)) - (__QpN *  117.0e+3)) - (__Qp8 *  2.808e+6)) + (__Qp9 *  702.0e+3)) - (__Qp6 *  16.6146e+6)) /  37.829e+3) + (__Qp5 *  278.453038674033));
          end
          else begin
            __dQy =  0.0;
            __d2Qy =  0.0;
          end
          temp = ((__Qp6 / __pd) + __xg_ac);
          if ((abs(temp) <= __marginp)) begin
            __xphi = (temp / __a_factrp);
          end
          else begin
            if ((temp < (- __marginp))) begin
              __NQS_yg = (- temp);
              __NQS_z = ((__NQS_yg *  1.25) / __a_factrp);
              __NQS_eta = (((__NQS_z +  10.0) - sqrt((((__NQS_z -  6.0) * (__NQS_z -  6.0)) +  64.0))) *  0.5);
              __NQS_a = (((__NQS_yg - __NQS_eta) * (__NQS_yg - __NQS_eta)) + (__Gp2 * (__NQS_eta +  1.0)));
              __NQS_c = (((__NQS_yg - __NQS_eta) *  2.0) - __Gp2);
              __NQS_tau = (ln((__NQS_a / __Gp2)) - __NQS_eta);
              __nu = (__NQS_a + __NQS_c);
              __mutau = ((__nu * __nu) + (__NQS_tau * (((__NQS_c * __NQS_c) *  0.5) - __NQS_a)));
              __NQS_y0 = (__NQS_eta + (((__NQS_a * __nu) * __NQS_tau) / (__mutau + (((((__nu / __mutau) * __NQS_tau) * __NQS_tau) * __NQS_c) * (((__NQS_c * __NQS_c) *  0.333333333333333) - __NQS_a)))));
              if ((abs(__NQS_y0) <  230.258509299405)) begin
                __NQS_D0 = exp(__NQS_y0);
              end
              else begin
                if ((__NQS_y0 <  0.0)) begin
                  __NQS_D0 = ( 100.0e-102 / (((-230.258509299405 - __NQS_y0) * ((((-230.258509299405 - __NQS_y0) * (((-230.258509299405 - __NQS_y0) *  0.333333333333333) +  1.0)) *  0.5) +  1.0)) +  1.0));
                end
                else begin
                  __NQS_D0 = ((((__NQS_y0 -  230.258509299405) * ((((__NQS_y0 -  230.258509299405) * (((__NQS_y0 -  230.258509299405) *  0.333333333333333) +  1.0)) *  0.5) +  1.0)) +  1.0) *  10.0e+99);
                end
              end
              __NQS_xi = ( 1.0 - ((__Gp2 * __NQS_D0) *  0.5));
              __NQS_p = (((__NQS_yg - __NQS_y0) *  2.0) + (__Gp2 * (__NQS_D0 -  1.0)));
              __NQS_q = (((__NQS_yg - __NQS_y0) * (__NQS_yg - __NQS_y0)) + (__Gp2 * ((__NQS_y0 +  1.0) - __NQS_D0)));
              __NQS_temp = ((__NQS_p * __NQS_p) - ((__NQS_xi *  4.0) * __NQS_q));
              __NQS_w = ((__NQS_q *  2.0) / (__NQS_p + sqrt(__NQS_temp)));
              __xphi = (- (__NQS_y0 + __NQS_w));
            end
            else begin
              __NQS_xg1 = ( 1.0 / ((__Gp *  0.732464877560822) +  1.25));
              __NQS_A_fac = ((((__a_factrp *  1.25) * __NQS_xg1) -  1.0) * __NQS_xg1);
              __NQS_xbar = ((temp / __a_factrp) * ((__NQS_A_fac * temp) +  1.0));
              if ((abs((- __NQS_xbar)) <  230.258509299405)) begin
                __NQS_temp = exp((- __NQS_xbar));
              end
              else begin
                if (((- __NQS_xbar) <  0.0)) begin
                  __NQS_temp = ( 100.0e-102 / (((-230.258509299405 - (- __NQS_xbar)) * ((((-230.258509299405 - (- __NQS_xbar)) * (((-230.258509299405 - (- __NQS_xbar)) *  0.333333333333333) +  1.0)) *  0.5) +  1.0)) +  1.0));
                end
                else begin
                  __NQS_temp = (((((- __NQS_xbar) -  230.258509299405) * (((((- __NQS_xbar) -  230.258509299405) * ((((- __NQS_xbar) -  230.258509299405) *  0.333333333333333) +  1.0)) *  0.5) +  1.0)) +  1.0) *  10.0e+99);
                end
              end
              __NQS_w = ( 1.0 - __NQS_temp);
              __NQS_x0 = ((temp + (__Gp2 *  0.5)) - (__Gp * sqrt(((temp + (__Gp2 *  0.25)) - __NQS_w))));
              if ((abs((- __NQS_x0)) <  230.258509299405)) begin
                __NQS_D0 = exp((- __NQS_x0));
              end
              else begin
                if (((- __NQS_x0) <  0.0)) begin
                  __NQS_D0 = ( 100.0e-102 / (((-230.258509299405 - (- __NQS_x0)) * ((((-230.258509299405 - (- __NQS_x0)) * (((-230.258509299405 - (- __NQS_x0)) *  0.333333333333333) +  1.0)) *  0.5) +  1.0)) +  1.0));
                end
                else begin
                  __NQS_D0 = (((((- __NQS_x0) -  230.258509299405) * (((((- __NQS_x0) -  230.258509299405) * ((((- __NQS_x0) -  230.258509299405) *  0.333333333333333) +  1.0)) *  0.5) +  1.0)) +  1.0) *  10.0e+99);
                end
              end
              __NQS_xi = ( 1.0 - ((__Gp2 *  0.5) * __NQS_D0));
              __NQS_p = (((temp - __NQS_x0) *  2.0) + (__Gp2 * ( 1.0 - __NQS_D0)));
              __NQS_q = (((temp - __NQS_x0) * (temp - __NQS_x0)) - (__Gp2 * ((__NQS_x0 -  1.0) + __NQS_D0)));
              __NQS_temp = ((__NQS_p * __NQS_p) - ((__NQS_xi *  4.0) * __NQS_q));
              __NQS_u = ((__NQS_q *  2.0) / (__NQS_p + sqrt(__NQS_temp)));
              __xphi = (__NQS_x0 + __NQS_u);
            end
          end
          if ((abs(__xphi) <= __margin_ac)) begin
            __Qb_tmp = (((__xphi * -0.70710678) * __Gf_ac) * ( 1.0 - ((__xphi *  0.166666666666667) * ( 1.0 - (__xphi *  0.166666666666667)))));
            __dQbs = ((__Gf_ac * -0.70710678) * ( 1.0 - ((__xphi *  0.333333333333333) * ( 1.0 - (__xphi *  0.25)))));
            __d2Qis = ((__Gf_ac * -0.235702) * ( 1.0 - (__xphi *  0.5)));
          end
          else begin
            if ((abs((- __xphi)) <  230.258509299405)) begin
              temp = exp((- __xphi));
            end
            else begin
              if (((- __xphi) <  0.0)) begin
                temp = ( 100.0e-102 / (((-230.258509299405 - (- __xphi)) * ((((-230.258509299405 - (- __xphi)) * (((-230.258509299405 - (- __xphi)) *  0.333333333333333) +  1.0)) *  0.5) +  1.0)) +  1.0));
              end
              else begin
                temp = (((((- __xphi) -  230.258509299405) * (((((- __xphi) -  230.258509299405) * ((((- __xphi) -  230.258509299405) *  0.333333333333333) +  1.0)) *  0.5) +  1.0)) +  1.0) *  10.0e+99);
              end
            end
            __Qb_tmp = (__Gf_ac * sqrt(((temp + __xphi) -  1.0)));
            if ((__xphi > __margin_ac)) begin
              __Qb_tmp = (- __Qb_tmp);
            end
            __dQbs = ((((__Gf_ac *  0.5) * __Gf_ac) * ( 1.0 - temp)) / __Qb_tmp);
            __d2Qis = ((((__dQbs * __dQbs) - ((__Gf_ac *  0.5) * __Gf_ac)) / __Qb_tmp) + __dQbs);
          end
          __dQis = (__pd - __dQbs);
          __dQis_1 = ( 1.0 / __dQis);
          __fQi = ((__Qp6 * __dQis_1) -  1.0);
          __dfQi = (( 1.0 - (((__Qp6 * __d2Qis) * __dQis_1) * __dQis_1)) * __dQis_1);
          __fk0 = (((__dfQi * __dQy) * __dQy) + (__fQi * __d2Qy));
          __dpsy2 = (((__dQy * __dQy) * __dQis_1) * __dQis_1);
          __zsat_nqs = (__thesat2 * __dpsy2);
          if ((__CHNL_TYPE == -1)) begin
            __zsat_nqs = (__zsat_nqs / ((__thesat1_ac * __dps_ac) +  1.0));
          end
          temp = sqrt(((__zsat_nqs *  2.0) +  1.0));
          __Fvsat = ( 2.0 / (temp +  1.0));
          temp1 = (__d2Qy - (__dpsy2 * __d2Qis));
          __fk6 = (__Fvsat * (__fk0 - ((((__zsat_nqs * __fQi) * temp1) * __Fvsat) / temp)));
        end
        if ((__SWNQS_i >= 7)) begin
          if ((__SWNQS_i == 9)) begin
            __dQy = ((((((((((((__Qp6 * -304.2e+3) - (__Qp4 *  21.84e+3)) + (__QpN *  12.605e+3)) + (__Qp3 *  5.85e+3)) + (__Qp8 *  302.52e+3)) - (__Qp0 *  65.0)) - (__Qp9 *  75.63e+3)) + (__Qp1 *  390.0)) + (__Qp7 *  420.0)) - (__Qp2 *  1.56e+3)) /  37.829e+3) + (__Qp5 *  2.15469613259669));
            __d2Qy = ((((((((((((__Qp1 * -13.5e+3) - (__Qp7 *  16.6011e+6)) + (__Qp4 *  756.0e+3)) - (__Qp3 *  202.5e+3)) + (__Qp2 *  54.0e+3)) + (__Qp0 *  2.25e+3)) + (__QpN *  436.65e+3)) + (__Qp8 *  10.4796e+6)) - (__Qp9 *  2.6199e+6)) + (__Qp6 *  10.53e+6)) /  37.829e+3) - (__Qp5 *  74.585635359116));
          end
          else begin
            __dQy =  0.0;
            __d2Qy =  0.0;
          end
          temp = ((__Qp7 / __pd) + __xg_ac);
          if ((abs(temp) <= __marginp)) begin
            __xphi = (temp / __a_factrp);
          end
          else begin
            if ((temp < (- __marginp))) begin
              __NQS_yg = (- temp);
              __NQS_z = ((__NQS_yg *  1.25) / __a_factrp);
              __NQS_eta = (((__NQS_z +  10.0) - sqrt((((__NQS_z -  6.0) * (__NQS_z -  6.0)) +  64.0))) *  0.5);
              __NQS_a = (((__NQS_yg - __NQS_eta) * (__NQS_yg - __NQS_eta)) + (__Gp2 * (__NQS_eta +  1.0)));
              __NQS_c = (((__NQS_yg - __NQS_eta) *  2.0) - __Gp2);
              __NQS_tau = (ln((__NQS_a / __Gp2)) - __NQS_eta);
              __nu = (__NQS_a + __NQS_c);
              __mutau = ((__nu * __nu) + (__NQS_tau * (((__NQS_c * __NQS_c) *  0.5) - __NQS_a)));
              __NQS_y0 = (__NQS_eta + (((__NQS_a * __nu) * __NQS_tau) / (__mutau + (((((__nu / __mutau) * __NQS_tau) * __NQS_tau) * __NQS_c) * (((__NQS_c * __NQS_c) *  0.333333333333333) - __NQS_a)))));
              if ((abs(__NQS_y0) <  230.258509299405)) begin
                __NQS_D0 = exp(__NQS_y0);
              end
              else begin
                if ((__NQS_y0 <  0.0)) begin
                  __NQS_D0 = ( 100.0e-102 / (((-230.258509299405 - __NQS_y0) * ((((-230.258509299405 - __NQS_y0) * (((-230.258509299405 - __NQS_y0) *  0.333333333333333) +  1.0)) *  0.5) +  1.0)) +  1.0));
                end
                else begin
                  __NQS_D0 = ((((__NQS_y0 -  230.258509299405) * ((((__NQS_y0 -  230.258509299405) * (((__NQS_y0 -  230.258509299405) *  0.333333333333333) +  1.0)) *  0.5) +  1.0)) +  1.0) *  10.0e+99);
                end
              end
              __NQS_xi = ( 1.0 - ((__Gp2 * __NQS_D0) *  0.5));
              __NQS_p = (((__NQS_yg - __NQS_y0) *  2.0) + (__Gp2 * (__NQS_D0 -  1.0)));
              __NQS_q = (((__NQS_yg - __NQS_y0) * (__NQS_yg - __NQS_y0)) + (__Gp2 * ((__NQS_y0 +  1.0) - __NQS_D0)));
              __NQS_temp = ((__NQS_p * __NQS_p) - ((__NQS_xi *  4.0) * __NQS_q));
              __NQS_w = ((__NQS_q *  2.0) / (__NQS_p + sqrt(__NQS_temp)));
              __xphi = (- (__NQS_y0 + __NQS_w));
            end
            else begin
              __NQS_xg1 = ( 1.0 / ((__Gp *  0.732464877560822) +  1.25));
              __NQS_A_fac = ((((__a_factrp *  1.25) * __NQS_xg1) -  1.0) * __NQS_xg1);
              __NQS_xbar = ((temp / __a_factrp) * ((__NQS_A_fac * temp) +  1.0));
              if ((abs((- __NQS_xbar)) <  230.258509299405)) begin
                __NQS_temp = exp((- __NQS_xbar));
              end
              else begin
                if (((- __NQS_xbar) <  0.0)) begin
                  __NQS_temp = ( 100.0e-102 / (((-230.258509299405 - (- __NQS_xbar)) * ((((-230.258509299405 - (- __NQS_xbar)) * (((-230.258509299405 - (- __NQS_xbar)) *  0.333333333333333) +  1.0)) *  0.5) +  1.0)) +  1.0));
                end
                else begin
                  __NQS_temp = (((((- __NQS_xbar) -  230.258509299405) * (((((- __NQS_xbar) -  230.258509299405) * ((((- __NQS_xbar) -  230.258509299405) *  0.333333333333333) +  1.0)) *  0.5) +  1.0)) +  1.0) *  10.0e+99);
                end
              end
              __NQS_w = ( 1.0 - __NQS_temp);
              __NQS_x0 = ((temp + (__Gp2 *  0.5)) - (__Gp * sqrt(((temp + (__Gp2 *  0.25)) - __NQS_w))));
              if ((abs((- __NQS_x0)) <  230.258509299405)) begin
                __NQS_D0 = exp((- __NQS_x0));
              end
              else begin
                if (((- __NQS_x0) <  0.0)) begin
                  __NQS_D0 = ( 100.0e-102 / (((-230.258509299405 - (- __NQS_x0)) * ((((-230.258509299405 - (- __NQS_x0)) * (((-230.258509299405 - (- __NQS_x0)) *  0.333333333333333) +  1.0)) *  0.5) +  1.0)) +  1.0));
                end
                else begin
                  __NQS_D0 = (((((- __NQS_x0) -  230.258509299405) * (((((- __NQS_x0) -  230.258509299405) * ((((- __NQS_x0) -  230.258509299405) *  0.333333333333333) +  1.0)) *  0.5) +  1.0)) +  1.0) *  10.0e+99);
                end
              end
              __NQS_xi = ( 1.0 - ((__Gp2 *  0.5) * __NQS_D0));
              __NQS_p = (((temp - __NQS_x0) *  2.0) + (__Gp2 * ( 1.0 - __NQS_D0)));
              __NQS_q = (((temp - __NQS_x0) * (temp - __NQS_x0)) - (__Gp2 * ((__NQS_x0 -  1.0) + __NQS_D0)));
              __NQS_temp = ((__NQS_p * __NQS_p) - ((__NQS_xi *  4.0) * __NQS_q));
              __NQS_u = ((__NQS_q *  2.0) / (__NQS_p + sqrt(__NQS_temp)));
              __xphi = (__NQS_x0 + __NQS_u);
            end
          end
          if ((abs(__xphi) <= __margin_ac)) begin
            __Qb_tmp = (((__xphi * -0.70710678) * __Gf_ac) * ( 1.0 - ((__xphi *  0.166666666666667) * ( 1.0 - (__xphi *  0.166666666666667)))));
            __dQbs = ((__Gf_ac * -0.70710678) * ( 1.0 - ((__xphi *  0.333333333333333) * ( 1.0 - (__xphi *  0.25)))));
            __d2Qis = ((__Gf_ac * -0.235702) * ( 1.0 - (__xphi *  0.5)));
          end
          else begin
            if ((abs((- __xphi)) <  230.258509299405)) begin
              temp = exp((- __xphi));
            end
            else begin
              if (((- __xphi) <  0.0)) begin
                temp = ( 100.0e-102 / (((-230.258509299405 - (- __xphi)) * ((((-230.258509299405 - (- __xphi)) * (((-230.258509299405 - (- __xphi)) *  0.333333333333333) +  1.0)) *  0.5) +  1.0)) +  1.0));
              end
              else begin
                temp = (((((- __xphi) -  230.258509299405) * (((((- __xphi) -  230.258509299405) * ((((- __xphi) -  230.258509299405) *  0.333333333333333) +  1.0)) *  0.5) +  1.0)) +  1.0) *  10.0e+99);
              end
            end
            __Qb_tmp = (__Gf_ac * sqrt(((temp + __xphi) -  1.0)));
            if ((__xphi > __margin_ac)) begin
              __Qb_tmp = (- __Qb_tmp);
            end
            __dQbs = ((((__Gf_ac *  0.5) * __Gf_ac) * ( 1.0 - temp)) / __Qb_tmp);
            __d2Qis = ((((__dQbs * __dQbs) - ((__Gf_ac *  0.5) * __Gf_ac)) / __Qb_tmp) + __dQbs);
          end
          __dQis = (__pd - __dQbs);
          __dQis_1 = ( 1.0 / __dQis);
          __fQi = ((__Qp7 * __dQis_1) -  1.0);
          __dfQi = (( 1.0 - (((__Qp7 * __d2Qis) * __dQis_1) * __dQis_1)) * __dQis_1);
          __fk0 = (((__dfQi * __dQy) * __dQy) + (__fQi * __d2Qy));
          __dpsy2 = (((__dQy * __dQy) * __dQis_1) * __dQis_1);
          __zsat_nqs = (__thesat2 * __dpsy2);
          if ((__CHNL_TYPE == -1)) begin
            __zsat_nqs = (__zsat_nqs / ((__thesat1_ac * __dps_ac) +  1.0));
          end
          temp = sqrt(((__zsat_nqs *  2.0) +  1.0));
          __Fvsat = ( 2.0 / (temp +  1.0));
          temp1 = (__d2Qy - (__dpsy2 * __d2Qis));
          __fk7 = (__Fvsat * (__fk0 - ((((__zsat_nqs * __fQi) * temp1) * __Fvsat) / temp)));
        end
        if ((__SWNQS_i >= 8)) begin
          if ((__SWNQS_i == 9)) begin
            __dQy = (((((((((((__Qp6 *  81.9e+3) + (__Qp4 *  5.88e+3)) - (__Qp3 *  1.575e+3)) + (__Qp8 *  5.85e+3)) + (__Qp9 *  282.255e+3)) - (__Qp1 *  105.0)) - (__Qp7 *  305.655e+3)) + (__Qp2 *  420.0)) /  37.829e+3) + (((__Qp0 *  35.0) - (__QpN *  94.085e+3)) /  75.658e+3)) - (__Qp5 *  0.580110497237569));
            __d2Qy = ((((((((((((__Qp1 *  3.6e+3) + (__Qp7 *  10.4796e+6)) - (__Qp4 *  201.6e+3)) + (__Qp3 *  54.0e+3)) - (__Qp2 *  14.4e+3)) - (__Qp0 *  600.0)) - (__QpN *  1.6296e+6)) - (__Qp8 *  16.413e+6)) + (__Qp9 *  9.7776e+6)) - (__Qp6 *  2.808e+6)) /  37.829e+3) + (__Qp5 *  19.8895027624309));
          end
          else begin
            __dQy =  0.0;
            __d2Qy =  0.0;
          end
          temp = ((__Qp8 / __pd) + __xg_ac);
          if ((abs(temp) <= __marginp)) begin
            __xphi = (temp / __a_factrp);
          end
          else begin
            if ((temp < (- __marginp))) begin
              __NQS_yg = (- temp);
              __NQS_z = ((__NQS_yg *  1.25) / __a_factrp);
              __NQS_eta = (((__NQS_z +  10.0) - sqrt((((__NQS_z -  6.0) * (__NQS_z -  6.0)) +  64.0))) *  0.5);
              __NQS_a = (((__NQS_yg - __NQS_eta) * (__NQS_yg - __NQS_eta)) + (__Gp2 * (__NQS_eta +  1.0)));
              __NQS_c = (((__NQS_yg - __NQS_eta) *  2.0) - __Gp2);
              __NQS_tau = (ln((__NQS_a / __Gp2)) - __NQS_eta);
              __nu = (__NQS_a + __NQS_c);
              __mutau = ((__nu * __nu) + (__NQS_tau * (((__NQS_c * __NQS_c) *  0.5) - __NQS_a)));
              __NQS_y0 = (__NQS_eta + (((__NQS_a * __nu) * __NQS_tau) / (__mutau + (((((__nu / __mutau) * __NQS_tau) * __NQS_tau) * __NQS_c) * (((__NQS_c * __NQS_c) *  0.333333333333333) - __NQS_a)))));
              if ((abs(__NQS_y0) <  230.258509299405)) begin
                __NQS_D0 = exp(__NQS_y0);
              end
              else begin
                if ((__NQS_y0 <  0.0)) begin
                  __NQS_D0 = ( 100.0e-102 / (((-230.258509299405 - __NQS_y0) * ((((-230.258509299405 - __NQS_y0) * (((-230.258509299405 - __NQS_y0) *  0.333333333333333) +  1.0)) *  0.5) +  1.0)) +  1.0));
                end
                else begin
                  __NQS_D0 = ((((__NQS_y0 -  230.258509299405) * ((((__NQS_y0 -  230.258509299405) * (((__NQS_y0 -  230.258509299405) *  0.333333333333333) +  1.0)) *  0.5) +  1.0)) +  1.0) *  10.0e+99);
                end
              end
              __NQS_xi = ( 1.0 - ((__Gp2 * __NQS_D0) *  0.5));
              __NQS_p = (((__NQS_yg - __NQS_y0) *  2.0) + (__Gp2 * (__NQS_D0 -  1.0)));
              __NQS_q = (((__NQS_yg - __NQS_y0) * (__NQS_yg - __NQS_y0)) + (__Gp2 * ((__NQS_y0 +  1.0) - __NQS_D0)));
              __NQS_temp = ((__NQS_p * __NQS_p) - ((__NQS_xi *  4.0) * __NQS_q));
              __NQS_w = ((__NQS_q *  2.0) / (__NQS_p + sqrt(__NQS_temp)));
              __xphi = (- (__NQS_y0 + __NQS_w));
            end
            else begin
              __NQS_xg1 = ( 1.0 / ((__Gp *  0.732464877560822) +  1.25));
              __NQS_A_fac = ((((__a_factrp *  1.25) * __NQS_xg1) -  1.0) * __NQS_xg1);
              __NQS_xbar = ((temp / __a_factrp) * ((__NQS_A_fac * temp) +  1.0));
              if ((abs((- __NQS_xbar)) <  230.258509299405)) begin
                __NQS_temp = exp((- __NQS_xbar));
              end
              else begin
                if (((- __NQS_xbar) <  0.0)) begin
                  __NQS_temp = ( 100.0e-102 / (((-230.258509299405 - (- __NQS_xbar)) * ((((-230.258509299405 - (- __NQS_xbar)) * (((-230.258509299405 - (- __NQS_xbar)) *  0.333333333333333) +  1.0)) *  0.5) +  1.0)) +  1.0));
                end
                else begin
                  __NQS_temp = (((((- __NQS_xbar) -  230.258509299405) * (((((- __NQS_xbar) -  230.258509299405) * ((((- __NQS_xbar) -  230.258509299405) *  0.333333333333333) +  1.0)) *  0.5) +  1.0)) +  1.0) *  10.0e+99);
                end
              end
              __NQS_w = ( 1.0 - __NQS_temp);
              __NQS_x0 = ((temp + (__Gp2 *  0.5)) - (__Gp * sqrt(((temp + (__Gp2 *  0.25)) - __NQS_w))));
              if ((abs((- __NQS_x0)) <  230.258509299405)) begin
                __NQS_D0 = exp((- __NQS_x0));
              end
              else begin
                if (((- __NQS_x0) <  0.0)) begin
                  __NQS_D0 = ( 100.0e-102 / (((-230.258509299405 - (- __NQS_x0)) * ((((-230.258509299405 - (- __NQS_x0)) * (((-230.258509299405 - (- __NQS_x0)) *  0.333333333333333) +  1.0)) *  0.5) +  1.0)) +  1.0));
                end
                else begin
                  __NQS_D0 = (((((- __NQS_x0) -  230.258509299405) * (((((- __NQS_x0) -  230.258509299405) * ((((- __NQS_x0) -  230.258509299405) *  0.333333333333333) +  1.0)) *  0.5) +  1.0)) +  1.0) *  10.0e+99);
                end
              end
              __NQS_xi = ( 1.0 - ((__Gp2 *  0.5) * __NQS_D0));
              __NQS_p = (((temp - __NQS_x0) *  2.0) + (__Gp2 * ( 1.0 - __NQS_D0)));
              __NQS_q = (((temp - __NQS_x0) * (temp - __NQS_x0)) - (__Gp2 * ((__NQS_x0 -  1.0) + __NQS_D0)));
              __NQS_temp = ((__NQS_p * __NQS_p) - ((__NQS_xi *  4.0) * __NQS_q));
              __NQS_u = ((__NQS_q *  2.0) / (__NQS_p + sqrt(__NQS_temp)));
              __xphi = (__NQS_x0 + __NQS_u);
            end
          end
          if ((abs(__xphi) <= __margin_ac)) begin
            __Qb_tmp = (((__xphi * -0.70710678) * __Gf_ac) * ( 1.0 - ((__xphi *  0.166666666666667) * ( 1.0 - (__xphi *  0.166666666666667)))));
            __dQbs = ((__Gf_ac * -0.70710678) * ( 1.0 - ((__xphi *  0.333333333333333) * ( 1.0 - (__xphi *  0.25)))));
            __d2Qis = ((__Gf_ac * -0.235702) * ( 1.0 - (__xphi *  0.5)));
          end
          else begin
            if ((abs((- __xphi)) <  230.258509299405)) begin
              temp = exp((- __xphi));
            end
            else begin
              if (((- __xphi) <  0.0)) begin
                temp = ( 100.0e-102 / (((-230.258509299405 - (- __xphi)) * ((((-230.258509299405 - (- __xphi)) * (((-230.258509299405 - (- __xphi)) *  0.333333333333333) +  1.0)) *  0.5) +  1.0)) +  1.0));
              end
              else begin
                temp = (((((- __xphi) -  230.258509299405) * (((((- __xphi) -  230.258509299405) * ((((- __xphi) -  230.258509299405) *  0.333333333333333) +  1.0)) *  0.5) +  1.0)) +  1.0) *  10.0e+99);
              end
            end
            __Qb_tmp = (__Gf_ac * sqrt(((temp + __xphi) -  1.0)));
            if ((__xphi > __margin_ac)) begin
              __Qb_tmp = (- __Qb_tmp);
            end
            __dQbs = ((((__Gf_ac *  0.5) * __Gf_ac) * ( 1.0 - temp)) / __Qb_tmp);
            __d2Qis = ((((__dQbs * __dQbs) - ((__Gf_ac *  0.5) * __Gf_ac)) / __Qb_tmp) + __dQbs);
          end
          __dQis = (__pd - __dQbs);
          __dQis_1 = ( 1.0 / __dQis);
          __fQi = ((__Qp8 * __dQis_1) -  1.0);
          __dfQi = (( 1.0 - (((__Qp8 * __d2Qis) * __dQis_1) * __dQis_1)) * __dQis_1);
          __fk0 = (((__dfQi * __dQy) * __dQy) + (__fQi * __d2Qy));
          __dpsy2 = (((__dQy * __dQy) * __dQis_1) * __dQis_1);
          __zsat_nqs = (__thesat2 * __dpsy2);
          if ((__CHNL_TYPE == -1)) begin
            __zsat_nqs = (__zsat_nqs / ((__thesat1_ac * __dps_ac) +  1.0));
          end
          temp = sqrt(((__zsat_nqs *  2.0) +  1.0));
          __Fvsat = ( 2.0 / (temp +  1.0));
          temp1 = (__d2Qy - (__dpsy2 * __d2Qis));
          __fk8 = (__Fvsat * (__fk0 - ((((__zsat_nqs * __fQi) * temp1) * __Fvsat) / temp)));
        end
        if ((__SWNQS_i >= 9)) begin
          if ((__SWNQS_i == 9)) begin
            __dQy = ((((((((((((__Qp6 * -23.4e+3) - (__Qp4 *  1.68e+3)) + (__QpN *  175.565e+3)) + (__Qp3 *  450.0)) - (__Qp8 *  325.92e+3)) - (__Qp0 *  5.0)) + (__Qp9 *  81.48e+3)) + (__Qp1 *  30.0)) + (__Qp7 *  87.33e+3)) - (__Qp2 *  120.0)) /  37.829e+3) + (__Qp5 *  0.165745856353591));
            __d2Qy = ((((((((((((__Qp1 * -900.0) - (__Qp7 *  2.6199e+6)) + (__Qp4 *  50.4e+3)) - (__Qp3 *  13.5e+3)) + (__Qp2 *  3.6e+3)) + (__Qp0 *  150.0)) + (__QpN *  6.08175e+6)) + (__Qp8 *  9.7776e+6)) - (__Qp9 *  13.7931e+6)) + (__Qp6 *  702.0e+3)) /  37.829e+3) - (__Qp5 *  4.97237569060773));
          end
          else begin
            __dQy =  0.0;
            __d2Qy =  0.0;
          end
          temp = ((__Qp9 / __pd) + __xg_ac);
          if ((abs(temp) <= __marginp)) begin
            __xphi = (temp / __a_factrp);
          end
          else begin
            if ((temp < (- __marginp))) begin
              __NQS_yg = (- temp);
              __NQS_z = ((__NQS_yg *  1.25) / __a_factrp);
              __NQS_eta = (((__NQS_z +  10.0) - sqrt((((__NQS_z -  6.0) * (__NQS_z -  6.0)) +  64.0))) *  0.5);
              __NQS_a = (((__NQS_yg - __NQS_eta) * (__NQS_yg - __NQS_eta)) + (__Gp2 * (__NQS_eta +  1.0)));
              __NQS_c = (((__NQS_yg - __NQS_eta) *  2.0) - __Gp2);
              __NQS_tau = (ln((__NQS_a / __Gp2)) - __NQS_eta);
              __nu = (__NQS_a + __NQS_c);
              __mutau = ((__nu * __nu) + (__NQS_tau * (((__NQS_c * __NQS_c) *  0.5) - __NQS_a)));
              __NQS_y0 = (__NQS_eta + (((__NQS_a * __nu) * __NQS_tau) / (__mutau + (((((__nu / __mutau) * __NQS_tau) * __NQS_tau) * __NQS_c) * (((__NQS_c * __NQS_c) *  0.333333333333333) - __NQS_a)))));
              if ((abs(__NQS_y0) <  230.258509299405)) begin
                __NQS_D0 = exp(__NQS_y0);
              end
              else begin
                if ((__NQS_y0 <  0.0)) begin
                  __NQS_D0 = ( 100.0e-102 / (((-230.258509299405 - __NQS_y0) * ((((-230.258509299405 - __NQS_y0) * (((-230.258509299405 - __NQS_y0) *  0.333333333333333) +  1.0)) *  0.5) +  1.0)) +  1.0));
                end
                else begin
                  __NQS_D0 = ((((__NQS_y0 -  230.258509299405) * ((((__NQS_y0 -  230.258509299405) * (((__NQS_y0 -  230.258509299405) *  0.333333333333333) +  1.0)) *  0.5) +  1.0)) +  1.0) *  10.0e+99);
                end
              end
              __NQS_xi = ( 1.0 - ((__Gp2 * __NQS_D0) *  0.5));
              __NQS_p = (((__NQS_yg - __NQS_y0) *  2.0) + (__Gp2 * (__NQS_D0 -  1.0)));
              __NQS_q = (((__NQS_yg - __NQS_y0) * (__NQS_yg - __NQS_y0)) + (__Gp2 * ((__NQS_y0 +  1.0) - __NQS_D0)));
              __NQS_temp = ((__NQS_p * __NQS_p) - ((__NQS_xi *  4.0) * __NQS_q));
              __NQS_w = ((__NQS_q *  2.0) / (__NQS_p + sqrt(__NQS_temp)));
              __xphi = (- (__NQS_y0 + __NQS_w));
            end
            else begin
              __NQS_xg1 = ( 1.0 / ((__Gp *  0.732464877560822) +  1.25));
              __NQS_A_fac = ((((__a_factrp *  1.25) * __NQS_xg1) -  1.0) * __NQS_xg1);
              __NQS_xbar = ((temp / __a_factrp) * ((__NQS_A_fac * temp) +  1.0));
              if ((abs((- __NQS_xbar)) <  230.258509299405)) begin
                __NQS_temp = exp((- __NQS_xbar));
              end
              else begin
                if (((- __NQS_xbar) <  0.0)) begin
                  __NQS_temp = ( 100.0e-102 / (((-230.258509299405 - (- __NQS_xbar)) * ((((-230.258509299405 - (- __NQS_xbar)) * (((-230.258509299405 - (- __NQS_xbar)) *  0.333333333333333) +  1.0)) *  0.5) +  1.0)) +  1.0));
                end
                else begin
                  __NQS_temp = (((((- __NQS_xbar) -  230.258509299405) * (((((- __NQS_xbar) -  230.258509299405) * ((((- __NQS_xbar) -  230.258509299405) *  0.333333333333333) +  1.0)) *  0.5) +  1.0)) +  1.0) *  10.0e+99);
                end
              end
              __NQS_w = ( 1.0 - __NQS_temp);
              __NQS_x0 = ((temp + (__Gp2 *  0.5)) - (__Gp * sqrt(((temp + (__Gp2 *  0.25)) - __NQS_w))));
              if ((abs((- __NQS_x0)) <  230.258509299405)) begin
                __NQS_D0 = exp((- __NQS_x0));
              end
              else begin
                if (((- __NQS_x0) <  0.0)) begin
                  __NQS_D0 = ( 100.0e-102 / (((-230.258509299405 - (- __NQS_x0)) * ((((-230.258509299405 - (- __NQS_x0)) * (((-230.258509299405 - (- __NQS_x0)) *  0.333333333333333) +  1.0)) *  0.5) +  1.0)) +  1.0));
                end
                else begin
                  __NQS_D0 = (((((- __NQS_x0) -  230.258509299405) * (((((- __NQS_x0) -  230.258509299405) * ((((- __NQS_x0) -  230.258509299405) *  0.333333333333333) +  1.0)) *  0.5) +  1.0)) +  1.0) *  10.0e+99);
                end
              end
              __NQS_xi = ( 1.0 - ((__Gp2 *  0.5) * __NQS_D0));
              __NQS_p = (((temp - __NQS_x0) *  2.0) + (__Gp2 * ( 1.0 - __NQS_D0)));
              __NQS_q = (((temp - __NQS_x0) * (temp - __NQS_x0)) - (__Gp2 * ((__NQS_x0 -  1.0) + __NQS_D0)));
              __NQS_temp = ((__NQS_p * __NQS_p) - ((__NQS_xi *  4.0) * __NQS_q));
              __NQS_u = ((__NQS_q *  2.0) / (__NQS_p + sqrt(__NQS_temp)));
              __xphi = (__NQS_x0 + __NQS_u);
            end
          end
          if ((abs(__xphi) <= __margin_ac)) begin
            __Qb_tmp = (((__xphi * -0.70710678) * __Gf_ac) * ( 1.0 - ((__xphi *  0.166666666666667) * ( 1.0 - (__xphi *  0.166666666666667)))));
            __dQbs = ((__Gf_ac * -0.70710678) * ( 1.0 - ((__xphi *  0.333333333333333) * ( 1.0 - (__xphi *  0.25)))));
            __d2Qis = ((__Gf_ac * -0.235702) * ( 1.0 - (__xphi *  0.5)));
          end
          else begin
            if ((abs((- __xphi)) <  230.258509299405)) begin
              temp = exp((- __xphi));
            end
            else begin
              if (((- __xphi) <  0.0)) begin
                temp = ( 100.0e-102 / (((-230.258509299405 - (- __xphi)) * ((((-230.258509299405 - (- __xphi)) * (((-230.258509299405 - (- __xphi)) *  0.333333333333333) +  1.0)) *  0.5) +  1.0)) +  1.0));
              end
              else begin
                temp = (((((- __xphi) -  230.258509299405) * (((((- __xphi) -  230.258509299405) * ((((- __xphi) -  230.258509299405) *  0.333333333333333) +  1.0)) *  0.5) +  1.0)) +  1.0) *  10.0e+99);
              end
            end
            __Qb_tmp = (__Gf_ac * sqrt(((temp + __xphi) -  1.0)));
            if ((__xphi > __margin_ac)) begin
              __Qb_tmp = (- __Qb_tmp);
            end
            __dQbs = ((((__Gf_ac *  0.5) * __Gf_ac) * ( 1.0 - temp)) / __Qb_tmp);
            __d2Qis = ((((__dQbs * __dQbs) - ((__Gf_ac *  0.5) * __Gf_ac)) / __Qb_tmp) + __dQbs);
          end
          __dQis = (__pd - __dQbs);
          __dQis_1 = ( 1.0 / __dQis);
          __fQi = ((__Qp9 * __dQis_1) -  1.0);
          __dfQi = (( 1.0 - (((__Qp9 * __d2Qis) * __dQis_1) * __dQis_1)) * __dQis_1);
          __fk0 = (((__dfQi * __dQy) * __dQy) + (__fQi * __d2Qy));
          __dpsy2 = (((__dQy * __dQy) * __dQis_1) * __dQis_1);
          __zsat_nqs = (__thesat2 * __dpsy2);
          if ((__CHNL_TYPE == -1)) begin
            __zsat_nqs = (__zsat_nqs / ((__thesat1_ac * __dps_ac) +  1.0));
          end
          temp = sqrt(((__zsat_nqs *  2.0) +  1.0));
          __Fvsat = ( 2.0 / (temp +  1.0));
          temp1 = (__d2Qy - (__dpsy2 * __d2Qis));
          __fk9 = (__Fvsat * (__fk0 - ((((__zsat_nqs * __fQi) * temp1) * __Fvsat) / temp)));
        end
        __QS_NQS =  0.0;
        __QD_NQS =  0.0;
        __QG_NQS =  0.0;
        if ((__SWNQS_i != 0)) begin
          if ((__SWNQS_i == 1)) begin
            __QS_NQS = ((((__Qp0 *  17.0) + (__Qp1 *  30.0)) + __QpN) /  96.0);
            __QD_NQS = (((__Qp0 + (__Qp1 *  30.0)) + (__QpN *  17.0)) /  96.0);
            temp = ((__Qp1 / __pd) + __xg_ac);
            if ((abs(temp) <= __marginp)) begin
              temp1 = (temp / __a_factrp);
            end
            else begin
              if ((temp < (- __marginp))) begin
                __NQS_yg = (- temp);
                __NQS_z = ((__NQS_yg *  1.25) / __a_factrp);
                __NQS_eta = (((__NQS_z +  10.0) - sqrt((((__NQS_z -  6.0) * (__NQS_z -  6.0)) +  64.0))) *  0.5);
                __NQS_a = (((__NQS_yg - __NQS_eta) * (__NQS_yg - __NQS_eta)) + (__Gp2 * (__NQS_eta +  1.0)));
                __NQS_c = (((__NQS_yg - __NQS_eta) *  2.0) - __Gp2);
                __NQS_tau = (ln((__NQS_a / __Gp2)) - __NQS_eta);
                __nu = (__NQS_a + __NQS_c);
                __mutau = ((__nu * __nu) + (__NQS_tau * (((__NQS_c * __NQS_c) *  0.5) - __NQS_a)));
                __NQS_y0 = (__NQS_eta + (((__NQS_a * __nu) * __NQS_tau) / (__mutau + (((((__nu / __mutau) * __NQS_tau) * __NQS_tau) * __NQS_c) * (((__NQS_c * __NQS_c) *  0.333333333333333) - __NQS_a)))));
                if ((abs(__NQS_y0) <  230.258509299405)) begin
                  __NQS_D0 = exp(__NQS_y0);
                end
                else begin
                  if ((__NQS_y0 <  0.0)) begin
                    __NQS_D0 = ( 100.0e-102 / (((-230.258509299405 - __NQS_y0) * ((((-230.258509299405 - __NQS_y0) * (((-230.258509299405 - __NQS_y0) *  0.333333333333333) +  1.0)) *  0.5) +  1.0)) +  1.0));
                  end
                  else begin
                    __NQS_D0 = ((((__NQS_y0 -  230.258509299405) * ((((__NQS_y0 -  230.258509299405) * (((__NQS_y0 -  230.258509299405) *  0.333333333333333) +  1.0)) *  0.5) +  1.0)) +  1.0) *  10.0e+99);
                  end
                end
                __NQS_xi = ( 1.0 - ((__Gp2 * __NQS_D0) *  0.5));
                __NQS_p = (((__NQS_yg - __NQS_y0) *  2.0) + (__Gp2 * (__NQS_D0 -  1.0)));
                __NQS_q = (((__NQS_yg - __NQS_y0) * (__NQS_yg - __NQS_y0)) + (__Gp2 * ((__NQS_y0 +  1.0) - __NQS_D0)));
                __NQS_temp = ((__NQS_p * __NQS_p) - ((__NQS_xi *  4.0) * __NQS_q));
                __NQS_w = ((__NQS_q *  2.0) / (__NQS_p + sqrt(__NQS_temp)));
                temp1 = (- (__NQS_y0 + __NQS_w));
              end
              else begin
                __NQS_xg1 = ( 1.0 / ((__Gp *  0.732464877560822) +  1.25));
                __NQS_A_fac = ((((__a_factrp *  1.25) * __NQS_xg1) -  1.0) * __NQS_xg1);
                __NQS_xbar = ((temp / __a_factrp) * ((__NQS_A_fac * temp) +  1.0));
                if ((abs((- __NQS_xbar)) <  230.258509299405)) begin
                  __NQS_temp = exp((- __NQS_xbar));
                end
                else begin
                  if (((- __NQS_xbar) <  0.0)) begin
                    __NQS_temp = ( 100.0e-102 / (((-230.258509299405 - (- __NQS_xbar)) * ((((-230.258509299405 - (- __NQS_xbar)) * (((-230.258509299405 - (- __NQS_xbar)) *  0.333333333333333) +  1.0)) *  0.5) +  1.0)) +  1.0));
                  end
                  else begin
                    __NQS_temp = (((((- __NQS_xbar) -  230.258509299405) * (((((- __NQS_xbar) -  230.258509299405) * ((((- __NQS_xbar) -  230.258509299405) *  0.333333333333333) +  1.0)) *  0.5) +  1.0)) +  1.0) *  10.0e+99);
                  end
                end
                __NQS_w = ( 1.0 - __NQS_temp);
                __NQS_x0 = ((temp + (__Gp2 *  0.5)) - (__Gp * sqrt(((temp + (__Gp2 *  0.25)) - __NQS_w))));
                if ((abs((- __NQS_x0)) <  230.258509299405)) begin
                  __NQS_D0 = exp((- __NQS_x0));
                end
                else begin
                  if (((- __NQS_x0) <  0.0)) begin
                    __NQS_D0 = ( 100.0e-102 / (((-230.258509299405 - (- __NQS_x0)) * ((((-230.258509299405 - (- __NQS_x0)) * (((-230.258509299405 - (- __NQS_x0)) *  0.333333333333333) +  1.0)) *  0.5) +  1.0)) +  1.0));
                  end
                  else begin
                    __NQS_D0 = (((((- __NQS_x0) -  230.258509299405) * (((((- __NQS_x0) -  230.258509299405) * ((((- __NQS_x0) -  230.258509299405) *  0.333333333333333) +  1.0)) *  0.5) +  1.0)) +  1.0) *  10.0e+99);
                  end
                end
                __NQS_xi = ( 1.0 - ((__Gp2 *  0.5) * __NQS_D0));
                __NQS_p = (((temp - __NQS_x0) *  2.0) + (__Gp2 * ( 1.0 - __NQS_D0)));
                __NQS_q = (((temp - __NQS_x0) * (temp - __NQS_x0)) - (__Gp2 * ((__NQS_x0 -  1.0) + __NQS_D0)));
                __NQS_temp = ((__NQS_p * __NQS_p) - ((__NQS_xi *  4.0) * __NQS_q));
                __NQS_u = ((__NQS_q *  2.0) / (__NQS_p + sqrt(__NQS_temp)));
                temp1 = (__NQS_x0 + __NQS_u);
              end
            end
            __QG_NQS = (__xg_ac - (((__x_sp + (temp1 *  4.0)) + __x_dp) *  0.166666666666667));
          end
          else begin
            if ((__SWNQS_i == 2)) begin
              __QS_NQS = (((((__Qp0 *  11.0) + (__Qp1 *  24.0)) + (__Qp2 *  9.0)) + __QpN) /  90.0);
              __QD_NQS = (((((__QpN *  11.0) + (__Qp2 *  24.0)) + (__Qp1 *  9.0)) + __Qp0) /  90.0);
              temp = ((__Qp1 / __pd) + __xg_ac);
              if ((abs(temp) <= __marginp)) begin
                temp1 = (temp / __a_factrp);
              end
              else begin
                if ((temp < (- __marginp))) begin
                  __NQS_yg = (- temp);
                  __NQS_z = ((__NQS_yg *  1.25) / __a_factrp);
                  __NQS_eta = (((__NQS_z +  10.0) - sqrt((((__NQS_z -  6.0) * (__NQS_z -  6.0)) +  64.0))) *  0.5);
                  __NQS_a = (((__NQS_yg - __NQS_eta) * (__NQS_yg - __NQS_eta)) + (__Gp2 * (__NQS_eta +  1.0)));
                  __NQS_c = (((__NQS_yg - __NQS_eta) *  2.0) - __Gp2);
                  __NQS_tau = (ln((__NQS_a / __Gp2)) - __NQS_eta);
                  __nu = (__NQS_a + __NQS_c);
                  __mutau = ((__nu * __nu) + (__NQS_tau * (((__NQS_c * __NQS_c) *  0.5) - __NQS_a)));
                  __NQS_y0 = (__NQS_eta + (((__NQS_a * __nu) * __NQS_tau) / (__mutau + (((((__nu / __mutau) * __NQS_tau) * __NQS_tau) * __NQS_c) * (((__NQS_c * __NQS_c) *  0.333333333333333) - __NQS_a)))));
                  if ((abs(__NQS_y0) <  230.258509299405)) begin
                    __NQS_D0 = exp(__NQS_y0);
                  end
                  else begin
                    if ((__NQS_y0 <  0.0)) begin
                      __NQS_D0 = ( 100.0e-102 / (((-230.258509299405 - __NQS_y0) * ((((-230.258509299405 - __NQS_y0) * (((-230.258509299405 - __NQS_y0) *  0.333333333333333) +  1.0)) *  0.5) +  1.0)) +  1.0));
                    end
                    else begin
                      __NQS_D0 = ((((__NQS_y0 -  230.258509299405) * ((((__NQS_y0 -  230.258509299405) * (((__NQS_y0 -  230.258509299405) *  0.333333333333333) +  1.0)) *  0.5) +  1.0)) +  1.0) *  10.0e+99);
                    end
                  end
                  __NQS_xi = ( 1.0 - ((__Gp2 * __NQS_D0) *  0.5));
                  __NQS_p = (((__NQS_yg - __NQS_y0) *  2.0) + (__Gp2 * (__NQS_D0 -  1.0)));
                  __NQS_q = (((__NQS_yg - __NQS_y0) * (__NQS_yg - __NQS_y0)) + (__Gp2 * ((__NQS_y0 +  1.0) - __NQS_D0)));
                  __NQS_temp = ((__NQS_p * __NQS_p) - ((__NQS_xi *  4.0) * __NQS_q));
                  __NQS_w = ((__NQS_q *  2.0) / (__NQS_p + sqrt(__NQS_temp)));
                  temp1 = (- (__NQS_y0 + __NQS_w));
                end
                else begin
                  __NQS_xg1 = ( 1.0 / ((__Gp *  0.732464877560822) +  1.25));
                  __NQS_A_fac = ((((__a_factrp *  1.25) * __NQS_xg1) -  1.0) * __NQS_xg1);
                  __NQS_xbar = ((temp / __a_factrp) * ((__NQS_A_fac * temp) +  1.0));
                  if ((abs((- __NQS_xbar)) <  230.258509299405)) begin
                    __NQS_temp = exp((- __NQS_xbar));
                  end
                  else begin
                    if (((- __NQS_xbar) <  0.0)) begin
                      __NQS_temp = ( 100.0e-102 / (((-230.258509299405 - (- __NQS_xbar)) * ((((-230.258509299405 - (- __NQS_xbar)) * (((-230.258509299405 - (- __NQS_xbar)) *  0.333333333333333) +  1.0)) *  0.5) +  1.0)) +  1.0));
                    end
                    else begin
                      __NQS_temp = (((((- __NQS_xbar) -  230.258509299405) * (((((- __NQS_xbar) -  230.258509299405) * ((((- __NQS_xbar) -  230.258509299405) *  0.333333333333333) +  1.0)) *  0.5) +  1.0)) +  1.0) *  10.0e+99);
                    end
                  end
                  __NQS_w = ( 1.0 - __NQS_temp);
                  __NQS_x0 = ((temp + (__Gp2 *  0.5)) - (__Gp * sqrt(((temp + (__Gp2 *  0.25)) - __NQS_w))));
                  if ((abs((- __NQS_x0)) <  230.258509299405)) begin
                    __NQS_D0 = exp((- __NQS_x0));
                  end
                  else begin
                    if (((- __NQS_x0) <  0.0)) begin
                      __NQS_D0 = ( 100.0e-102 / (((-230.258509299405 - (- __NQS_x0)) * ((((-230.258509299405 - (- __NQS_x0)) * (((-230.258509299405 - (- __NQS_x0)) *  0.333333333333333) +  1.0)) *  0.5) +  1.0)) +  1.0));
                    end
                    else begin
                      __NQS_D0 = (((((- __NQS_x0) -  230.258509299405) * (((((- __NQS_x0) -  230.258509299405) * ((((- __NQS_x0) -  230.258509299405) *  0.333333333333333) +  1.0)) *  0.5) +  1.0)) +  1.0) *  10.0e+99);
                    end
                  end
                  __NQS_xi = ( 1.0 - ((__Gp2 *  0.5) * __NQS_D0));
                  __NQS_p = (((temp - __NQS_x0) *  2.0) + (__Gp2 * ( 1.0 - __NQS_D0)));
                  __NQS_q = (((temp - __NQS_x0) * (temp - __NQS_x0)) - (__Gp2 * ((__NQS_x0 -  1.0) + __NQS_D0)));
                  __NQS_temp = ((__NQS_p * __NQS_p) - ((__NQS_xi *  4.0) * __NQS_q));
                  __NQS_u = ((__NQS_q *  2.0) / (__NQS_p + sqrt(__NQS_temp)));
                  temp1 = (__NQS_x0 + __NQS_u);
                end
              end
              temp = ((__Qp2 / __pd) + __xg_ac);
              if ((abs(temp) <= __marginp)) begin
                temp2 = (temp / __a_factrp);
              end
              else begin
                if ((temp < (- __marginp))) begin
                  __NQS_yg = (- temp);
                  __NQS_z = ((__NQS_yg *  1.25) / __a_factrp);
                  __NQS_eta = (((__NQS_z +  10.0) - sqrt((((__NQS_z -  6.0) * (__NQS_z -  6.0)) +  64.0))) *  0.5);
                  __NQS_a = (((__NQS_yg - __NQS_eta) * (__NQS_yg - __NQS_eta)) + (__Gp2 * (__NQS_eta +  1.0)));
                  __NQS_c = (((__NQS_yg - __NQS_eta) *  2.0) - __Gp2);
                  __NQS_tau = (ln((__NQS_a / __Gp2)) - __NQS_eta);
                  __nu = (__NQS_a + __NQS_c);
                  __mutau = ((__nu * __nu) + (__NQS_tau * (((__NQS_c * __NQS_c) *  0.5) - __NQS_a)));
                  __NQS_y0 = (__NQS_eta + (((__NQS_a * __nu) * __NQS_tau) / (__mutau + (((((__nu / __mutau) * __NQS_tau) * __NQS_tau) * __NQS_c) * (((__NQS_c * __NQS_c) *  0.333333333333333) - __NQS_a)))));
                  if ((abs(__NQS_y0) <  230.258509299405)) begin
                    __NQS_D0 = exp(__NQS_y0);
                  end
                  else begin
                    if ((__NQS_y0 <  0.0)) begin
                      __NQS_D0 = ( 100.0e-102 / (((-230.258509299405 - __NQS_y0) * ((((-230.258509299405 - __NQS_y0) * (((-230.258509299405 - __NQS_y0) *  0.333333333333333) +  1.0)) *  0.5) +  1.0)) +  1.0));
                    end
                    else begin
                      __NQS_D0 = ((((__NQS_y0 -  230.258509299405) * ((((__NQS_y0 -  230.258509299405) * (((__NQS_y0 -  230.258509299405) *  0.333333333333333) +  1.0)) *  0.5) +  1.0)) +  1.0) *  10.0e+99);
                    end
                  end
                  __NQS_xi = ( 1.0 - ((__Gp2 * __NQS_D0) *  0.5));
                  __NQS_p = (((__NQS_yg - __NQS_y0) *  2.0) + (__Gp2 * (__NQS_D0 -  1.0)));
                  __NQS_q = (((__NQS_yg - __NQS_y0) * (__NQS_yg - __NQS_y0)) + (__Gp2 * ((__NQS_y0 +  1.0) - __NQS_D0)));
                  __NQS_temp = ((__NQS_p * __NQS_p) - ((__NQS_xi *  4.0) * __NQS_q));
                  __NQS_w = ((__NQS_q *  2.0) / (__NQS_p + sqrt(__NQS_temp)));
                  temp2 = (- (__NQS_y0 + __NQS_w));
                end
                else begin
                  __NQS_xg1 = ( 1.0 / ((__Gp *  0.732464877560822) +  1.25));
                  __NQS_A_fac = ((((__a_factrp *  1.25) * __NQS_xg1) -  1.0) * __NQS_xg1);
                  __NQS_xbar = ((temp / __a_factrp) * ((__NQS_A_fac * temp) +  1.0));
                  if ((abs((- __NQS_xbar)) <  230.258509299405)) begin
                    __NQS_temp = exp((- __NQS_xbar));
                  end
                  else begin
                    if (((- __NQS_xbar) <  0.0)) begin
                      __NQS_temp = ( 100.0e-102 / (((-230.258509299405 - (- __NQS_xbar)) * ((((-230.258509299405 - (- __NQS_xbar)) * (((-230.258509299405 - (- __NQS_xbar)) *  0.333333333333333) +  1.0)) *  0.5) +  1.0)) +  1.0));
                    end
                    else begin
                      __NQS_temp = (((((- __NQS_xbar) -  230.258509299405) * (((((- __NQS_xbar) -  230.258509299405) * ((((- __NQS_xbar) -  230.258509299405) *  0.333333333333333) +  1.0)) *  0.5) +  1.0)) +  1.0) *  10.0e+99);
                    end
                  end
                  __NQS_w = ( 1.0 - __NQS_temp);
                  __NQS_x0 = ((temp + (__Gp2 *  0.5)) - (__Gp * sqrt(((temp + (__Gp2 *  0.25)) - __NQS_w))));
                  if ((abs((- __NQS_x0)) <  230.258509299405)) begin
                    __NQS_D0 = exp((- __NQS_x0));
                  end
                  else begin
                    if (((- __NQS_x0) <  0.0)) begin
                      __NQS_D0 = ( 100.0e-102 / (((-230.258509299405 - (- __NQS_x0)) * ((((-230.258509299405 - (- __NQS_x0)) * (((-230.258509299405 - (- __NQS_x0)) *  0.333333333333333) +  1.0)) *  0.5) +  1.0)) +  1.0));
                    end
                    else begin
                      __NQS_D0 = (((((- __NQS_x0) -  230.258509299405) * (((((- __NQS_x0) -  230.258509299405) * ((((- __NQS_x0) -  230.258509299405) *  0.333333333333333) +  1.0)) *  0.5) +  1.0)) +  1.0) *  10.0e+99);
                    end
                  end
                  __NQS_xi = ( 1.0 - ((__Gp2 *  0.5) * __NQS_D0));
                  __NQS_p = (((temp - __NQS_x0) *  2.0) + (__Gp2 * ( 1.0 - __NQS_D0)));
                  __NQS_q = (((temp - __NQS_x0) * (temp - __NQS_x0)) - (__Gp2 * ((__NQS_x0 -  1.0) + __NQS_D0)));
                  __NQS_temp = ((__NQS_p * __NQS_p) - ((__NQS_xi *  4.0) * __NQS_q));
                  __NQS_u = ((__NQS_q *  2.0) / (__NQS_p + sqrt(__NQS_temp)));
                  temp2 = (__NQS_x0 + __NQS_u);
                end
              end
              __QG_NQS = (__xg_ac - (((__x_sp + ((temp1 + temp2) *  3.0)) + __x_dp) *  0.125));
            end
            else begin
              if ((__SWNQS_i == 3)) begin
                __QS_NQS = ((((((__Qp0 *  251.0) + (__Qp1 *  594.0)) + (__Qp2 *  312.0)) + (__Qp3 *  174.0)) + (__QpN *  13.0)) /  2.688e+3);
                __QD_NQS = ((((((__QpN *  251.0) + (__Qp3 *  594.0)) + (__Qp2 *  312.0)) + (__Qp1 *  174.0)) + (__Qp0 *  13.0)) /  2.688e+3);
                temp = ((__Qp1 / __pd) + __xg_ac);
                if ((abs(temp) <= __marginp)) begin
                  temp1 = (temp / __a_factrp);
                end
                else begin
                  if ((temp < (- __marginp))) begin
                    __NQS_yg = (- temp);
                    __NQS_z = ((__NQS_yg *  1.25) / __a_factrp);
                    __NQS_eta = (((__NQS_z +  10.0) - sqrt((((__NQS_z -  6.0) * (__NQS_z -  6.0)) +  64.0))) *  0.5);
                    __NQS_a = (((__NQS_yg - __NQS_eta) * (__NQS_yg - __NQS_eta)) + (__Gp2 * (__NQS_eta +  1.0)));
                    __NQS_c = (((__NQS_yg - __NQS_eta) *  2.0) - __Gp2);
                    __NQS_tau = (ln((__NQS_a / __Gp2)) - __NQS_eta);
                    __nu = (__NQS_a + __NQS_c);
                    __mutau = ((__nu * __nu) + (__NQS_tau * (((__NQS_c * __NQS_c) *  0.5) - __NQS_a)));
                    __NQS_y0 = (__NQS_eta + (((__NQS_a * __nu) * __NQS_tau) / (__mutau + (((((__nu / __mutau) * __NQS_tau) * __NQS_tau) * __NQS_c) * (((__NQS_c * __NQS_c) *  0.333333333333333) - __NQS_a)))));
                    if ((abs(__NQS_y0) <  230.258509299405)) begin
                      __NQS_D0 = exp(__NQS_y0);
                    end
                    else begin
                      if ((__NQS_y0 <  0.0)) begin
                        __NQS_D0 = ( 100.0e-102 / (((-230.258509299405 - __NQS_y0) * ((((-230.258509299405 - __NQS_y0) * (((-230.258509299405 - __NQS_y0) *  0.333333333333333) +  1.0)) *  0.5) +  1.0)) +  1.0));
                      end
                      else begin
                        __NQS_D0 = ((((__NQS_y0 -  230.258509299405) * ((((__NQS_y0 -  230.258509299405) * (((__NQS_y0 -  230.258509299405) *  0.333333333333333) +  1.0)) *  0.5) +  1.0)) +  1.0) *  10.0e+99);
                      end
                    end
                    __NQS_xi = ( 1.0 - ((__Gp2 * __NQS_D0) *  0.5));
                    __NQS_p = (((__NQS_yg - __NQS_y0) *  2.0) + (__Gp2 * (__NQS_D0 -  1.0)));
                    __NQS_q = (((__NQS_yg - __NQS_y0) * (__NQS_yg - __NQS_y0)) + (__Gp2 * ((__NQS_y0 +  1.0) - __NQS_D0)));
                    __NQS_temp = ((__NQS_p * __NQS_p) - ((__NQS_xi *  4.0) * __NQS_q));
                    __NQS_w = ((__NQS_q *  2.0) / (__NQS_p + sqrt(__NQS_temp)));
                    temp1 = (- (__NQS_y0 + __NQS_w));
                  end
                  else begin
                    __NQS_xg1 = ( 1.0 / ((__Gp *  0.732464877560822) +  1.25));
                    __NQS_A_fac = ((((__a_factrp *  1.25) * __NQS_xg1) -  1.0) * __NQS_xg1);
                    __NQS_xbar = ((temp / __a_factrp) * ((__NQS_A_fac * temp) +  1.0));
                    if ((abs((- __NQS_xbar)) <  230.258509299405)) begin
                      __NQS_temp = exp((- __NQS_xbar));
                    end
                    else begin
                      if (((- __NQS_xbar) <  0.0)) begin
                        __NQS_temp = ( 100.0e-102 / (((-230.258509299405 - (- __NQS_xbar)) * ((((-230.258509299405 - (- __NQS_xbar)) * (((-230.258509299405 - (- __NQS_xbar)) *  0.333333333333333) +  1.0)) *  0.5) +  1.0)) +  1.0));
                      end
                      else begin
                        __NQS_temp = (((((- __NQS_xbar) -  230.258509299405) * (((((- __NQS_xbar) -  230.258509299405) * ((((- __NQS_xbar) -  230.258509299405) *  0.333333333333333) +  1.0)) *  0.5) +  1.0)) +  1.0) *  10.0e+99);
                      end
                    end
                    __NQS_w = ( 1.0 - __NQS_temp);
                    __NQS_x0 = ((temp + (__Gp2 *  0.5)) - (__Gp * sqrt(((temp + (__Gp2 *  0.25)) - __NQS_w))));
                    if ((abs((- __NQS_x0)) <  230.258509299405)) begin
                      __NQS_D0 = exp((- __NQS_x0));
                    end
                    else begin
                      if (((- __NQS_x0) <  0.0)) begin
                        __NQS_D0 = ( 100.0e-102 / (((-230.258509299405 - (- __NQS_x0)) * ((((-230.258509299405 - (- __NQS_x0)) * (((-230.258509299405 - (- __NQS_x0)) *  0.333333333333333) +  1.0)) *  0.5) +  1.0)) +  1.0));
                      end
                      else begin
                        __NQS_D0 = (((((- __NQS_x0) -  230.258509299405) * (((((- __NQS_x0) -  230.258509299405) * ((((- __NQS_x0) -  230.258509299405) *  0.333333333333333) +  1.0)) *  0.5) +  1.0)) +  1.0) *  10.0e+99);
                      end
                    end
                    __NQS_xi = ( 1.0 - ((__Gp2 *  0.5) * __NQS_D0));
                    __NQS_p = (((temp - __NQS_x0) *  2.0) + (__Gp2 * ( 1.0 - __NQS_D0)));
                    __NQS_q = (((temp - __NQS_x0) * (temp - __NQS_x0)) - (__Gp2 * ((__NQS_x0 -  1.0) + __NQS_D0)));
                    __NQS_temp = ((__NQS_p * __NQS_p) - ((__NQS_xi *  4.0) * __NQS_q));
                    __NQS_u = ((__NQS_q *  2.0) / (__NQS_p + sqrt(__NQS_temp)));
                    temp1 = (__NQS_x0 + __NQS_u);
                  end
                end
                temp = ((__Qp2 / __pd) + __xg_ac);
                if ((abs(temp) <= __marginp)) begin
                  temp2 = (temp / __a_factrp);
                end
                else begin
                  if ((temp < (- __marginp))) begin
                    __NQS_yg = (- temp);
                    __NQS_z = ((__NQS_yg *  1.25) / __a_factrp);
                    __NQS_eta = (((__NQS_z +  10.0) - sqrt((((__NQS_z -  6.0) * (__NQS_z -  6.0)) +  64.0))) *  0.5);
                    __NQS_a = (((__NQS_yg - __NQS_eta) * (__NQS_yg - __NQS_eta)) + (__Gp2 * (__NQS_eta +  1.0)));
                    __NQS_c = (((__NQS_yg - __NQS_eta) *  2.0) - __Gp2);
                    __NQS_tau = (ln((__NQS_a / __Gp2)) - __NQS_eta);
                    __nu = (__NQS_a + __NQS_c);
                    __mutau = ((__nu * __nu) + (__NQS_tau * (((__NQS_c * __NQS_c) *  0.5) - __NQS_a)));
                    __NQS_y0 = (__NQS_eta + (((__NQS_a * __nu) * __NQS_tau) / (__mutau + (((((__nu / __mutau) * __NQS_tau) * __NQS_tau) * __NQS_c) * (((__NQS_c * __NQS_c) *  0.333333333333333) - __NQS_a)))));
                    if ((abs(__NQS_y0) <  230.258509299405)) begin
                      __NQS_D0 = exp(__NQS_y0);
                    end
                    else begin
                      if ((__NQS_y0 <  0.0)) begin
                        __NQS_D0 = ( 100.0e-102 / (((-230.258509299405 - __NQS_y0) * ((((-230.258509299405 - __NQS_y0) * (((-230.258509299405 - __NQS_y0) *  0.333333333333333) +  1.0)) *  0.5) +  1.0)) +  1.0));
                      end
                      else begin
                        __NQS_D0 = ((((__NQS_y0 -  230.258509299405) * ((((__NQS_y0 -  230.258509299405) * (((__NQS_y0 -  230.258509299405) *  0.333333333333333) +  1.0)) *  0.5) +  1.0)) +  1.0) *  10.0e+99);
                      end
                    end
                    __NQS_xi = ( 1.0 - ((__Gp2 * __NQS_D0) *  0.5));
                    __NQS_p = (((__NQS_yg - __NQS_y0) *  2.0) + (__Gp2 * (__NQS_D0 -  1.0)));
                    __NQS_q = (((__NQS_yg - __NQS_y0) * (__NQS_yg - __NQS_y0)) + (__Gp2 * ((__NQS_y0 +  1.0) - __NQS_D0)));
                    __NQS_temp = ((__NQS_p * __NQS_p) - ((__NQS_xi *  4.0) * __NQS_q));
                    __NQS_w = ((__NQS_q *  2.0) / (__NQS_p + sqrt(__NQS_temp)));
                    temp2 = (- (__NQS_y0 + __NQS_w));
                  end
                  else begin
                    __NQS_xg1 = ( 1.0 / ((__Gp *  0.732464877560822) +  1.25));
                    __NQS_A_fac = ((((__a_factrp *  1.25) * __NQS_xg1) -  1.0) * __NQS_xg1);
                    __NQS_xbar = ((temp / __a_factrp) * ((__NQS_A_fac * temp) +  1.0));
                    if ((abs((- __NQS_xbar)) <  230.258509299405)) begin
                      __NQS_temp = exp((- __NQS_xbar));
                    end
                    else begin
                      if (((- __NQS_xbar) <  0.0)) begin
                        __NQS_temp = ( 100.0e-102 / (((-230.258509299405 - (- __NQS_xbar)) * ((((-230.258509299405 - (- __NQS_xbar)) * (((-230.258509299405 - (- __NQS_xbar)) *  0.333333333333333) +  1.0)) *  0.5) +  1.0)) +  1.0));
                      end
                      else begin
                        __NQS_temp = (((((- __NQS_xbar) -  230.258509299405) * (((((- __NQS_xbar) -  230.258509299405) * ((((- __NQS_xbar) -  230.258509299405) *  0.333333333333333) +  1.0)) *  0.5) +  1.0)) +  1.0) *  10.0e+99);
                      end
                    end
                    __NQS_w = ( 1.0 - __NQS_temp);
                    __NQS_x0 = ((temp + (__Gp2 *  0.5)) - (__Gp * sqrt(((temp + (__Gp2 *  0.25)) - __NQS_w))));
                    if ((abs((- __NQS_x0)) <  230.258509299405)) begin
                      __NQS_D0 = exp((- __NQS_x0));
                    end
                    else begin
                      if (((- __NQS_x0) <  0.0)) begin
                        __NQS_D0 = ( 100.0e-102 / (((-230.258509299405 - (- __NQS_x0)) * ((((-230.258509299405 - (- __NQS_x0)) * (((-230.258509299405 - (- __NQS_x0)) *  0.333333333333333) +  1.0)) *  0.5) +  1.0)) +  1.0));
                      end
                      else begin
                        __NQS_D0 = (((((- __NQS_x0) -  230.258509299405) * (((((- __NQS_x0) -  230.258509299405) * ((((- __NQS_x0) -  230.258509299405) *  0.333333333333333) +  1.0)) *  0.5) +  1.0)) +  1.0) *  10.0e+99);
                      end
                    end
                    __NQS_xi = ( 1.0 - ((__Gp2 *  0.5) * __NQS_D0));
                    __NQS_p = (((temp - __NQS_x0) *  2.0) + (__Gp2 * ( 1.0 - __NQS_D0)));
                    __NQS_q = (((temp - __NQS_x0) * (temp - __NQS_x0)) - (__Gp2 * ((__NQS_x0 -  1.0) + __NQS_D0)));
                    __NQS_temp = ((__NQS_p * __NQS_p) - ((__NQS_xi *  4.0) * __NQS_q));
                    __NQS_u = ((__NQS_q *  2.0) / (__NQS_p + sqrt(__NQS_temp)));
                    temp2 = (__NQS_x0 + __NQS_u);
                  end
                end
                temp = ((__Qp3 / __pd) + __xg_ac);
                if ((abs(temp) <= __marginp)) begin
                  __temp3 = (temp / __a_factrp);
                end
                else begin
                  if ((temp < (- __marginp))) begin
                    __NQS_yg = (- temp);
                    __NQS_z = ((__NQS_yg *  1.25) / __a_factrp);
                    __NQS_eta = (((__NQS_z +  10.0) - sqrt((((__NQS_z -  6.0) * (__NQS_z -  6.0)) +  64.0))) *  0.5);
                    __NQS_a = (((__NQS_yg - __NQS_eta) * (__NQS_yg - __NQS_eta)) + (__Gp2 * (__NQS_eta +  1.0)));
                    __NQS_c = (((__NQS_yg - __NQS_eta) *  2.0) - __Gp2);
                    __NQS_tau = (ln((__NQS_a / __Gp2)) - __NQS_eta);
                    __nu = (__NQS_a + __NQS_c);
                    __mutau = ((__nu * __nu) + (__NQS_tau * (((__NQS_c * __NQS_c) *  0.5) - __NQS_a)));
                    __NQS_y0 = (__NQS_eta + (((__NQS_a * __nu) * __NQS_tau) / (__mutau + (((((__nu / __mutau) * __NQS_tau) * __NQS_tau) * __NQS_c) * (((__NQS_c * __NQS_c) *  0.333333333333333) - __NQS_a)))));
                    if ((abs(__NQS_y0) <  230.258509299405)) begin
                      __NQS_D0 = exp(__NQS_y0);
                    end
                    else begin
                      if ((__NQS_y0 <  0.0)) begin
                        __NQS_D0 = ( 100.0e-102 / (((-230.258509299405 - __NQS_y0) * ((((-230.258509299405 - __NQS_y0) * (((-230.258509299405 - __NQS_y0) *  0.333333333333333) +  1.0)) *  0.5) +  1.0)) +  1.0));
                      end
                      else begin
                        __NQS_D0 = ((((__NQS_y0 -  230.258509299405) * ((((__NQS_y0 -  230.258509299405) * (((__NQS_y0 -  230.258509299405) *  0.333333333333333) +  1.0)) *  0.5) +  1.0)) +  1.0) *  10.0e+99);
                      end
                    end
                    __NQS_xi = ( 1.0 - ((__Gp2 * __NQS_D0) *  0.5));
                    __NQS_p = (((__NQS_yg - __NQS_y0) *  2.0) + (__Gp2 * (__NQS_D0 -  1.0)));
                    __NQS_q = (((__NQS_yg - __NQS_y0) * (__NQS_yg - __NQS_y0)) + (__Gp2 * ((__NQS_y0 +  1.0) - __NQS_D0)));
                    __NQS_temp = ((__NQS_p * __NQS_p) - ((__NQS_xi *  4.0) * __NQS_q));
                    __NQS_w = ((__NQS_q *  2.0) / (__NQS_p + sqrt(__NQS_temp)));
                    __temp3 = (- (__NQS_y0 + __NQS_w));
                  end
                  else begin
                    __NQS_xg1 = ( 1.0 / ((__Gp *  0.732464877560822) +  1.25));
                    __NQS_A_fac = ((((__a_factrp *  1.25) * __NQS_xg1) -  1.0) * __NQS_xg1);
                    __NQS_xbar = ((temp / __a_factrp) * ((__NQS_A_fac * temp) +  1.0));
                    if ((abs((- __NQS_xbar)) <  230.258509299405)) begin
                      __NQS_temp = exp((- __NQS_xbar));
                    end
                    else begin
                      if (((- __NQS_xbar) <  0.0)) begin
                        __NQS_temp = ( 100.0e-102 / (((-230.258509299405 - (- __NQS_xbar)) * ((((-230.258509299405 - (- __NQS_xbar)) * (((-230.258509299405 - (- __NQS_xbar)) *  0.333333333333333) +  1.0)) *  0.5) +  1.0)) +  1.0));
                      end
                      else begin
                        __NQS_temp = (((((- __NQS_xbar) -  230.258509299405) * (((((- __NQS_xbar) -  230.258509299405) * ((((- __NQS_xbar) -  230.258509299405) *  0.333333333333333) +  1.0)) *  0.5) +  1.0)) +  1.0) *  10.0e+99);
                      end
                    end
                    __NQS_w = ( 1.0 - __NQS_temp);
                    __NQS_x0 = ((temp + (__Gp2 *  0.5)) - (__Gp * sqrt(((temp + (__Gp2 *  0.25)) - __NQS_w))));
                    if ((abs((- __NQS_x0)) <  230.258509299405)) begin
                      __NQS_D0 = exp((- __NQS_x0));
                    end
                    else begin
                      if (((- __NQS_x0) <  0.0)) begin
                        __NQS_D0 = ( 100.0e-102 / (((-230.258509299405 - (- __NQS_x0)) * ((((-230.258509299405 - (- __NQS_x0)) * (((-230.258509299405 - (- __NQS_x0)) *  0.333333333333333) +  1.0)) *  0.5) +  1.0)) +  1.0));
                      end
                      else begin
                        __NQS_D0 = (((((- __NQS_x0) -  230.258509299405) * (((((- __NQS_x0) -  230.258509299405) * ((((- __NQS_x0) -  230.258509299405) *  0.333333333333333) +  1.0)) *  0.5) +  1.0)) +  1.0) *  10.0e+99);
                      end
                    end
                    __NQS_xi = ( 1.0 - ((__Gp2 *  0.5) * __NQS_D0));
                    __NQS_p = (((temp - __NQS_x0) *  2.0) + (__Gp2 * ( 1.0 - __NQS_D0)));
                    __NQS_q = (((temp - __NQS_x0) * (temp - __NQS_x0)) - (__Gp2 * ((__NQS_x0 -  1.0) + __NQS_D0)));
                    __NQS_temp = ((__NQS_p * __NQS_p) - ((__NQS_xi *  4.0) * __NQS_q));
                    __NQS_u = ((__NQS_q *  2.0) / (__NQS_p + sqrt(__NQS_temp)));
                    __temp3 = (__NQS_x0 + __NQS_u);
                  end
                end
                __QG_NQS = (__xg_ac - (((((__x_sp + (temp1 *  4.0)) + (temp2 *  2.0)) + (__temp3 *  4.0)) + __x_dp) /  12.0));
              end
              else begin
                if ((__SWNQS_i == 5)) begin
                  __QS_NQS = ((((__Qp0 *  1.187e+3) + (__QpN *  43.0)) /  18.72e+3) + ((((((__Qp1 *  503.0) + (__Qp4 *  172.0)) + (__Qp5 *  87.0)) + (__Qp3 *  265.0)) + (__Qp2 *  328.0)) /  3.12e+3));
                  __QD_NQS = ((((__QpN *  1.187e+3) + (__Qp0 *  43.0)) /  18.72e+3) + ((((((__Qp5 *  503.0) + (__Qp2 *  172.0)) + (__Qp1 *  87.0)) + (__Qp3 *  265.0)) + (__Qp4 *  328.0)) /  3.12e+3));
                  temp = ((__Qp1 / __pd) + __xg_ac);
                  if ((abs(temp) <= __marginp)) begin
                    temp1 = (temp / __a_factrp);
                  end
                  else begin
                    if ((temp < (- __marginp))) begin
                      __NQS_yg = (- temp);
                      __NQS_z = ((__NQS_yg *  1.25) / __a_factrp);
                      __NQS_eta = (((__NQS_z +  10.0) - sqrt((((__NQS_z -  6.0) * (__NQS_z -  6.0)) +  64.0))) *  0.5);
                      __NQS_a = (((__NQS_yg - __NQS_eta) * (__NQS_yg - __NQS_eta)) + (__Gp2 * (__NQS_eta +  1.0)));
                      __NQS_c = (((__NQS_yg - __NQS_eta) *  2.0) - __Gp2);
                      __NQS_tau = (ln((__NQS_a / __Gp2)) - __NQS_eta);
                      __nu = (__NQS_a + __NQS_c);
                      __mutau = ((__nu * __nu) + (__NQS_tau * (((__NQS_c * __NQS_c) *  0.5) - __NQS_a)));
                      __NQS_y0 = (__NQS_eta + (((__NQS_a * __nu) * __NQS_tau) / (__mutau + (((((__nu / __mutau) * __NQS_tau) * __NQS_tau) * __NQS_c) * (((__NQS_c * __NQS_c) *  0.333333333333333) - __NQS_a)))));
                      if ((abs(__NQS_y0) <  230.258509299405)) begin
                        __NQS_D0 = exp(__NQS_y0);
                      end
                      else begin
                        if ((__NQS_y0 <  0.0)) begin
                          __NQS_D0 = ( 100.0e-102 / (((-230.258509299405 - __NQS_y0) * ((((-230.258509299405 - __NQS_y0) * (((-230.258509299405 - __NQS_y0) *  0.333333333333333) +  1.0)) *  0.5) +  1.0)) +  1.0));
                        end
                        else begin
                          __NQS_D0 = ((((__NQS_y0 -  230.258509299405) * ((((__NQS_y0 -  230.258509299405) * (((__NQS_y0 -  230.258509299405) *  0.333333333333333) +  1.0)) *  0.5) +  1.0)) +  1.0) *  10.0e+99);
                        end
                      end
                      __NQS_xi = ( 1.0 - ((__Gp2 * __NQS_D0) *  0.5));
                      __NQS_p = (((__NQS_yg - __NQS_y0) *  2.0) + (__Gp2 * (__NQS_D0 -  1.0)));
                      __NQS_q = (((__NQS_yg - __NQS_y0) * (__NQS_yg - __NQS_y0)) + (__Gp2 * ((__NQS_y0 +  1.0) - __NQS_D0)));
                      __NQS_temp = ((__NQS_p * __NQS_p) - ((__NQS_xi *  4.0) * __NQS_q));
                      __NQS_w = ((__NQS_q *  2.0) / (__NQS_p + sqrt(__NQS_temp)));
                      temp1 = (- (__NQS_y0 + __NQS_w));
                    end
                    else begin
                      __NQS_xg1 = ( 1.0 / ((__Gp *  0.732464877560822) +  1.25));
                      __NQS_A_fac = ((((__a_factrp *  1.25) * __NQS_xg1) -  1.0) * __NQS_xg1);
                      __NQS_xbar = ((temp / __a_factrp) * ((__NQS_A_fac * temp) +  1.0));
                      if ((abs((- __NQS_xbar)) <  230.258509299405)) begin
                        __NQS_temp = exp((- __NQS_xbar));
                      end
                      else begin
                        if (((- __NQS_xbar) <  0.0)) begin
                          __NQS_temp = ( 100.0e-102 / (((-230.258509299405 - (- __NQS_xbar)) * ((((-230.258509299405 - (- __NQS_xbar)) * (((-230.258509299405 - (- __NQS_xbar)) *  0.333333333333333) +  1.0)) *  0.5) +  1.0)) +  1.0));
                        end
                        else begin
                          __NQS_temp = (((((- __NQS_xbar) -  230.258509299405) * (((((- __NQS_xbar) -  230.258509299405) * ((((- __NQS_xbar) -  230.258509299405) *  0.333333333333333) +  1.0)) *  0.5) +  1.0)) +  1.0) *  10.0e+99);
                        end
                      end
                      __NQS_w = ( 1.0 - __NQS_temp);
                      __NQS_x0 = ((temp + (__Gp2 *  0.5)) - (__Gp * sqrt(((temp + (__Gp2 *  0.25)) - __NQS_w))));
                      if ((abs((- __NQS_x0)) <  230.258509299405)) begin
                        __NQS_D0 = exp((- __NQS_x0));
                      end
                      else begin
                        if (((- __NQS_x0) <  0.0)) begin
                          __NQS_D0 = ( 100.0e-102 / (((-230.258509299405 - (- __NQS_x0)) * ((((-230.258509299405 - (- __NQS_x0)) * (((-230.258509299405 - (- __NQS_x0)) *  0.333333333333333) +  1.0)) *  0.5) +  1.0)) +  1.0));
                        end
                        else begin
                          __NQS_D0 = (((((- __NQS_x0) -  230.258509299405) * (((((- __NQS_x0) -  230.258509299405) * ((((- __NQS_x0) -  230.258509299405) *  0.333333333333333) +  1.0)) *  0.5) +  1.0)) +  1.0) *  10.0e+99);
                        end
                      end
                      __NQS_xi = ( 1.0 - ((__Gp2 *  0.5) * __NQS_D0));
                      __NQS_p = (((temp - __NQS_x0) *  2.0) + (__Gp2 * ( 1.0 - __NQS_D0)));
                      __NQS_q = (((temp - __NQS_x0) * (temp - __NQS_x0)) - (__Gp2 * ((__NQS_x0 -  1.0) + __NQS_D0)));
                      __NQS_temp = ((__NQS_p * __NQS_p) - ((__NQS_xi *  4.0) * __NQS_q));
                      __NQS_u = ((__NQS_q *  2.0) / (__NQS_p + sqrt(__NQS_temp)));
                      temp1 = (__NQS_x0 + __NQS_u);
                    end
                  end
                  temp = ((__Qp2 / __pd) + __xg_ac);
                  if ((abs(temp) <= __marginp)) begin
                    temp2 = (temp / __a_factrp);
                  end
                  else begin
                    if ((temp < (- __marginp))) begin
                      __NQS_yg = (- temp);
                      __NQS_z = ((__NQS_yg *  1.25) / __a_factrp);
                      __NQS_eta = (((__NQS_z +  10.0) - sqrt((((__NQS_z -  6.0) * (__NQS_z -  6.0)) +  64.0))) *  0.5);
                      __NQS_a = (((__NQS_yg - __NQS_eta) * (__NQS_yg - __NQS_eta)) + (__Gp2 * (__NQS_eta +  1.0)));
                      __NQS_c = (((__NQS_yg - __NQS_eta) *  2.0) - __Gp2);
                      __NQS_tau = (ln((__NQS_a / __Gp2)) - __NQS_eta);
                      __nu = (__NQS_a + __NQS_c);
                      __mutau = ((__nu * __nu) + (__NQS_tau * (((__NQS_c * __NQS_c) *  0.5) - __NQS_a)));
                      __NQS_y0 = (__NQS_eta + (((__NQS_a * __nu) * __NQS_tau) / (__mutau + (((((__nu / __mutau) * __NQS_tau) * __NQS_tau) * __NQS_c) * (((__NQS_c * __NQS_c) *  0.333333333333333) - __NQS_a)))));
                      if ((abs(__NQS_y0) <  230.258509299405)) begin
                        __NQS_D0 = exp(__NQS_y0);
                      end
                      else begin
                        if ((__NQS_y0 <  0.0)) begin
                          __NQS_D0 = ( 100.0e-102 / (((-230.258509299405 - __NQS_y0) * ((((-230.258509299405 - __NQS_y0) * (((-230.258509299405 - __NQS_y0) *  0.333333333333333) +  1.0)) *  0.5) +  1.0)) +  1.0));
                        end
                        else begin
                          __NQS_D0 = ((((__NQS_y0 -  230.258509299405) * ((((__NQS_y0 -  230.258509299405) * (((__NQS_y0 -  230.258509299405) *  0.333333333333333) +  1.0)) *  0.5) +  1.0)) +  1.0) *  10.0e+99);
                        end
                      end
                      __NQS_xi = ( 1.0 - ((__Gp2 * __NQS_D0) *  0.5));
                      __NQS_p = (((__NQS_yg - __NQS_y0) *  2.0) + (__Gp2 * (__NQS_D0 -  1.0)));
                      __NQS_q = (((__NQS_yg - __NQS_y0) * (__NQS_yg - __NQS_y0)) + (__Gp2 * ((__NQS_y0 +  1.0) - __NQS_D0)));
                      __NQS_temp = ((__NQS_p * __NQS_p) - ((__NQS_xi *  4.0) * __NQS_q));
                      __NQS_w = ((__NQS_q *  2.0) / (__NQS_p + sqrt(__NQS_temp)));
                      temp2 = (- (__NQS_y0 + __NQS_w));
                    end
                    else begin
                      __NQS_xg1 = ( 1.0 / ((__Gp *  0.732464877560822) +  1.25));
                      __NQS_A_fac = ((((__a_factrp *  1.25) * __NQS_xg1) -  1.0) * __NQS_xg1);
                      __NQS_xbar = ((temp / __a_factrp) * ((__NQS_A_fac * temp) +  1.0));
                      if ((abs((- __NQS_xbar)) <  230.258509299405)) begin
                        __NQS_temp = exp((- __NQS_xbar));
                      end
                      else begin
                        if (((- __NQS_xbar) <  0.0)) begin
                          __NQS_temp = ( 100.0e-102 / (((-230.258509299405 - (- __NQS_xbar)) * ((((-230.258509299405 - (- __NQS_xbar)) * (((-230.258509299405 - (- __NQS_xbar)) *  0.333333333333333) +  1.0)) *  0.5) +  1.0)) +  1.0));
                        end
                        else begin
                          __NQS_temp = (((((- __NQS_xbar) -  230.258509299405) * (((((- __NQS_xbar) -  230.258509299405) * ((((- __NQS_xbar) -  230.258509299405) *  0.333333333333333) +  1.0)) *  0.5) +  1.0)) +  1.0) *  10.0e+99);
                        end
                      end
                      __NQS_w = ( 1.0 - __NQS_temp);
                      __NQS_x0 = ((temp + (__Gp2 *  0.5)) - (__Gp * sqrt(((temp + (__Gp2 *  0.25)) - __NQS_w))));
                      if ((abs((- __NQS_x0)) <  230.258509299405)) begin
                        __NQS_D0 = exp((- __NQS_x0));
                      end
                      else begin
                        if (((- __NQS_x0) <  0.0)) begin
                          __NQS_D0 = ( 100.0e-102 / (((-230.258509299405 - (- __NQS_x0)) * ((((-230.258509299405 - (- __NQS_x0)) * (((-230.258509299405 - (- __NQS_x0)) *  0.333333333333333) +  1.0)) *  0.5) +  1.0)) +  1.0));
                        end
                        else begin
                          __NQS_D0 = (((((- __NQS_x0) -  230.258509299405) * (((((- __NQS_x0) -  230.258509299405) * ((((- __NQS_x0) -  230.258509299405) *  0.333333333333333) +  1.0)) *  0.5) +  1.0)) +  1.0) *  10.0e+99);
                        end
                      end
                      __NQS_xi = ( 1.0 - ((__Gp2 *  0.5) * __NQS_D0));
                      __NQS_p = (((temp - __NQS_x0) *  2.0) + (__Gp2 * ( 1.0 - __NQS_D0)));
                      __NQS_q = (((temp - __NQS_x0) * (temp - __NQS_x0)) - (__Gp2 * ((__NQS_x0 -  1.0) + __NQS_D0)));
                      __NQS_temp = ((__NQS_p * __NQS_p) - ((__NQS_xi *  4.0) * __NQS_q));
                      __NQS_u = ((__NQS_q *  2.0) / (__NQS_p + sqrt(__NQS_temp)));
                      temp2 = (__NQS_x0 + __NQS_u);
                    end
                  end
                  temp = ((__Qp3 / __pd) + __xg_ac);
                  if ((abs(temp) <= __marginp)) begin
                    __temp3 = (temp / __a_factrp);
                  end
                  else begin
                    if ((temp < (- __marginp))) begin
                      __NQS_yg = (- temp);
                      __NQS_z = ((__NQS_yg *  1.25) / __a_factrp);
                      __NQS_eta = (((__NQS_z +  10.0) - sqrt((((__NQS_z -  6.0) * (__NQS_z -  6.0)) +  64.0))) *  0.5);
                      __NQS_a = (((__NQS_yg - __NQS_eta) * (__NQS_yg - __NQS_eta)) + (__Gp2 * (__NQS_eta +  1.0)));
                      __NQS_c = (((__NQS_yg - __NQS_eta) *  2.0) - __Gp2);
                      __NQS_tau = (ln((__NQS_a / __Gp2)) - __NQS_eta);
                      __nu = (__NQS_a + __NQS_c);
                      __mutau = ((__nu * __nu) + (__NQS_tau * (((__NQS_c * __NQS_c) *  0.5) - __NQS_a)));
                      __NQS_y0 = (__NQS_eta + (((__NQS_a * __nu) * __NQS_tau) / (__mutau + (((((__nu / __mutau) * __NQS_tau) * __NQS_tau) * __NQS_c) * (((__NQS_c * __NQS_c) *  0.333333333333333) - __NQS_a)))));
                      if ((abs(__NQS_y0) <  230.258509299405)) begin
                        __NQS_D0 = exp(__NQS_y0);
                      end
                      else begin
                        if ((__NQS_y0 <  0.0)) begin
                          __NQS_D0 = ( 100.0e-102 / (((-230.258509299405 - __NQS_y0) * ((((-230.258509299405 - __NQS_y0) * (((-230.258509299405 - __NQS_y0) *  0.333333333333333) +  1.0)) *  0.5) +  1.0)) +  1.0));
                        end
                        else begin
                          __NQS_D0 = ((((__NQS_y0 -  230.258509299405) * ((((__NQS_y0 -  230.258509299405) * (((__NQS_y0 -  230.258509299405) *  0.333333333333333) +  1.0)) *  0.5) +  1.0)) +  1.0) *  10.0e+99);
                        end
                      end
                      __NQS_xi = ( 1.0 - ((__Gp2 * __NQS_D0) *  0.5));
                      __NQS_p = (((__NQS_yg - __NQS_y0) *  2.0) + (__Gp2 * (__NQS_D0 -  1.0)));
                      __NQS_q = (((__NQS_yg - __NQS_y0) * (__NQS_yg - __NQS_y0)) + (__Gp2 * ((__NQS_y0 +  1.0) - __NQS_D0)));
                      __NQS_temp = ((__NQS_p * __NQS_p) - ((__NQS_xi *  4.0) * __NQS_q));
                      __NQS_w = ((__NQS_q *  2.0) / (__NQS_p + sqrt(__NQS_temp)));
                      __temp3 = (- (__NQS_y0 + __NQS_w));
                    end
                    else begin
                      __NQS_xg1 = ( 1.0 / ((__Gp *  0.732464877560822) +  1.25));
                      __NQS_A_fac = ((((__a_factrp *  1.25) * __NQS_xg1) -  1.0) * __NQS_xg1);
                      __NQS_xbar = ((temp / __a_factrp) * ((__NQS_A_fac * temp) +  1.0));
                      if ((abs((- __NQS_xbar)) <  230.258509299405)) begin
                        __NQS_temp = exp((- __NQS_xbar));
                      end
                      else begin
                        if (((- __NQS_xbar) <  0.0)) begin
                          __NQS_temp = ( 100.0e-102 / (((-230.258509299405 - (- __NQS_xbar)) * ((((-230.258509299405 - (- __NQS_xbar)) * (((-230.258509299405 - (- __NQS_xbar)) *  0.333333333333333) +  1.0)) *  0.5) +  1.0)) +  1.0));
                        end
                        else begin
                          __NQS_temp = (((((- __NQS_xbar) -  230.258509299405) * (((((- __NQS_xbar) -  230.258509299405) * ((((- __NQS_xbar) -  230.258509299405) *  0.333333333333333) +  1.0)) *  0.5) +  1.0)) +  1.0) *  10.0e+99);
                        end
                      end
                      __NQS_w = ( 1.0 - __NQS_temp);
                      __NQS_x0 = ((temp + (__Gp2 *  0.5)) - (__Gp * sqrt(((temp + (__Gp2 *  0.25)) - __NQS_w))));
                      if ((abs((- __NQS_x0)) <  230.258509299405)) begin
                        __NQS_D0 = exp((- __NQS_x0));
                      end
                      else begin
                        if (((- __NQS_x0) <  0.0)) begin
                          __NQS_D0 = ( 100.0e-102 / (((-230.258509299405 - (- __NQS_x0)) * ((((-230.258509299405 - (- __NQS_x0)) * (((-230.258509299405 - (- __NQS_x0)) *  0.333333333333333) +  1.0)) *  0.5) +  1.0)) +  1.0));
                        end
                        else begin
                          __NQS_D0 = (((((- __NQS_x0) -  230.258509299405) * (((((- __NQS_x0) -  230.258509299405) * ((((- __NQS_x0) -  230.258509299405) *  0.333333333333333) +  1.0)) *  0.5) +  1.0)) +  1.0) *  10.0e+99);
                        end
                      end
                      __NQS_xi = ( 1.0 - ((__Gp2 *  0.5) * __NQS_D0));
                      __NQS_p = (((temp - __NQS_x0) *  2.0) + (__Gp2 * ( 1.0 - __NQS_D0)));
                      __NQS_q = (((temp - __NQS_x0) * (temp - __NQS_x0)) - (__Gp2 * ((__NQS_x0 -  1.0) + __NQS_D0)));
                      __NQS_temp = ((__NQS_p * __NQS_p) - ((__NQS_xi *  4.0) * __NQS_q));
                      __NQS_u = ((__NQS_q *  2.0) / (__NQS_p + sqrt(__NQS_temp)));
                      __temp3 = (__NQS_x0 + __NQS_u);
                    end
                  end
                  temp = ((__Qp4 / __pd) + __xg_ac);
                  if ((abs(temp) <= __marginp)) begin
                    __temp4 = (temp / __a_factrp);
                  end
                  else begin
                    if ((temp < (- __marginp))) begin
                      __NQS_yg = (- temp);
                      __NQS_z = ((__NQS_yg *  1.25) / __a_factrp);
                      __NQS_eta = (((__NQS_z +  10.0) - sqrt((((__NQS_z -  6.0) * (__NQS_z -  6.0)) +  64.0))) *  0.5);
                      __NQS_a = (((__NQS_yg - __NQS_eta) * (__NQS_yg - __NQS_eta)) + (__Gp2 * (__NQS_eta +  1.0)));
                      __NQS_c = (((__NQS_yg - __NQS_eta) *  2.0) - __Gp2);
                      __NQS_tau = (ln((__NQS_a / __Gp2)) - __NQS_eta);
                      __nu = (__NQS_a + __NQS_c);
                      __mutau = ((__nu * __nu) + (__NQS_tau * (((__NQS_c * __NQS_c) *  0.5) - __NQS_a)));
                      __NQS_y0 = (__NQS_eta + (((__NQS_a * __nu) * __NQS_tau) / (__mutau + (((((__nu / __mutau) * __NQS_tau) * __NQS_tau) * __NQS_c) * (((__NQS_c * __NQS_c) *  0.333333333333333) - __NQS_a)))));
                      if ((abs(__NQS_y0) <  230.258509299405)) begin
                        __NQS_D0 = exp(__NQS_y0);
                      end
                      else begin
                        if ((__NQS_y0 <  0.0)) begin
                          __NQS_D0 = ( 100.0e-102 / (((-230.258509299405 - __NQS_y0) * ((((-230.258509299405 - __NQS_y0) * (((-230.258509299405 - __NQS_y0) *  0.333333333333333) +  1.0)) *  0.5) +  1.0)) +  1.0));
                        end
                        else begin
                          __NQS_D0 = ((((__NQS_y0 -  230.258509299405) * ((((__NQS_y0 -  230.258509299405) * (((__NQS_y0 -  230.258509299405) *  0.333333333333333) +  1.0)) *  0.5) +  1.0)) +  1.0) *  10.0e+99);
                        end
                      end
                      __NQS_xi = ( 1.0 - ((__Gp2 * __NQS_D0) *  0.5));
                      __NQS_p = (((__NQS_yg - __NQS_y0) *  2.0) + (__Gp2 * (__NQS_D0 -  1.0)));
                      __NQS_q = (((__NQS_yg - __NQS_y0) * (__NQS_yg - __NQS_y0)) + (__Gp2 * ((__NQS_y0 +  1.0) - __NQS_D0)));
                      __NQS_temp = ((__NQS_p * __NQS_p) - ((__NQS_xi *  4.0) * __NQS_q));
                      __NQS_w = ((__NQS_q *  2.0) / (__NQS_p + sqrt(__NQS_temp)));
                      __temp4 = (- (__NQS_y0 + __NQS_w));
                    end
                    else begin
                      __NQS_xg1 = ( 1.0 / ((__Gp *  0.732464877560822) +  1.25));
                      __NQS_A_fac = ((((__a_factrp *  1.25) * __NQS_xg1) -  1.0) * __NQS_xg1);
                      __NQS_xbar = ((temp / __a_factrp) * ((__NQS_A_fac * temp) +  1.0));
                      if ((abs((- __NQS_xbar)) <  230.258509299405)) begin
                        __NQS_temp = exp((- __NQS_xbar));
                      end
                      else begin
                        if (((- __NQS_xbar) <  0.0)) begin
                          __NQS_temp = ( 100.0e-102 / (((-230.258509299405 - (- __NQS_xbar)) * ((((-230.258509299405 - (- __NQS_xbar)) * (((-230.258509299405 - (- __NQS_xbar)) *  0.333333333333333) +  1.0)) *  0.5) +  1.0)) +  1.0));
                        end
                        else begin
                          __NQS_temp = (((((- __NQS_xbar) -  230.258509299405) * (((((- __NQS_xbar) -  230.258509299405) * ((((- __NQS_xbar) -  230.258509299405) *  0.333333333333333) +  1.0)) *  0.5) +  1.0)) +  1.0) *  10.0e+99);
                        end
                      end
                      __NQS_w = ( 1.0 - __NQS_temp);
                      __NQS_x0 = ((temp + (__Gp2 *  0.5)) - (__Gp * sqrt(((temp + (__Gp2 *  0.25)) - __NQS_w))));
                      if ((abs((- __NQS_x0)) <  230.258509299405)) begin
                        __NQS_D0 = exp((- __NQS_x0));
                      end
                      else begin
                        if (((- __NQS_x0) <  0.0)) begin
                          __NQS_D0 = ( 100.0e-102 / (((-230.258509299405 - (- __NQS_x0)) * ((((-230.258509299405 - (- __NQS_x0)) * (((-230.258509299405 - (- __NQS_x0)) *  0.333333333333333) +  1.0)) *  0.5) +  1.0)) +  1.0));
                        end
                        else begin
                          __NQS_D0 = (((((- __NQS_x0) -  230.258509299405) * (((((- __NQS_x0) -  230.258509299405) * ((((- __NQS_x0) -  230.258509299405) *  0.333333333333333) +  1.0)) *  0.5) +  1.0)) +  1.0) *  10.0e+99);
                        end
                      end
                      __NQS_xi = ( 1.0 - ((__Gp2 *  0.5) * __NQS_D0));
                      __NQS_p = (((temp - __NQS_x0) *  2.0) + (__Gp2 * ( 1.0 - __NQS_D0)));
                      __NQS_q = (((temp - __NQS_x0) * (temp - __NQS_x0)) - (__Gp2 * ((__NQS_x0 -  1.0) + __NQS_D0)));
                      __NQS_temp = ((__NQS_p * __NQS_p) - ((__NQS_xi *  4.0) * __NQS_q));
                      __NQS_u = ((__NQS_q *  2.0) / (__NQS_p + sqrt(__NQS_temp)));
                      __temp4 = (__NQS_x0 + __NQS_u);
                    end
                  end
                  temp = ((__Qp5 / __pd) + __xg_ac);
                  if ((abs(temp) <= __marginp)) begin
                    __temp5 = (temp / __a_factrp);
                  end
                  else begin
                    if ((temp < (- __marginp))) begin
                      __NQS_yg = (- temp);
                      __NQS_z = ((__NQS_yg *  1.25) / __a_factrp);
                      __NQS_eta = (((__NQS_z +  10.0) - sqrt((((__NQS_z -  6.0) * (__NQS_z -  6.0)) +  64.0))) *  0.5);
                      __NQS_a = (((__NQS_yg - __NQS_eta) * (__NQS_yg - __NQS_eta)) + (__Gp2 * (__NQS_eta +  1.0)));
                      __NQS_c = (((__NQS_yg - __NQS_eta) *  2.0) - __Gp2);
                      __NQS_tau = (ln((__NQS_a / __Gp2)) - __NQS_eta);
                      __nu = (__NQS_a + __NQS_c);
                      __mutau = ((__nu * __nu) + (__NQS_tau * (((__NQS_c * __NQS_c) *  0.5) - __NQS_a)));
                      __NQS_y0 = (__NQS_eta + (((__NQS_a * __nu) * __NQS_tau) / (__mutau + (((((__nu / __mutau) * __NQS_tau) * __NQS_tau) * __NQS_c) * (((__NQS_c * __NQS_c) *  0.333333333333333) - __NQS_a)))));
                      if ((abs(__NQS_y0) <  230.258509299405)) begin
                        __NQS_D0 = exp(__NQS_y0);
                      end
                      else begin
                        if ((__NQS_y0 <  0.0)) begin
                          __NQS_D0 = ( 100.0e-102 / (((-230.258509299405 - __NQS_y0) * ((((-230.258509299405 - __NQS_y0) * (((-230.258509299405 - __NQS_y0) *  0.333333333333333) +  1.0)) *  0.5) +  1.0)) +  1.0));
                        end
                        else begin
                          __NQS_D0 = ((((__NQS_y0 -  230.258509299405) * ((((__NQS_y0 -  230.258509299405) * (((__NQS_y0 -  230.258509299405) *  0.333333333333333) +  1.0)) *  0.5) +  1.0)) +  1.0) *  10.0e+99);
                        end
                      end
                      __NQS_xi = ( 1.0 - ((__Gp2 * __NQS_D0) *  0.5));
                      __NQS_p = (((__NQS_yg - __NQS_y0) *  2.0) + (__Gp2 * (__NQS_D0 -  1.0)));
                      __NQS_q = (((__NQS_yg - __NQS_y0) * (__NQS_yg - __NQS_y0)) + (__Gp2 * ((__NQS_y0 +  1.0) - __NQS_D0)));
                      __NQS_temp = ((__NQS_p * __NQS_p) - ((__NQS_xi *  4.0) * __NQS_q));
                      __NQS_w = ((__NQS_q *  2.0) / (__NQS_p + sqrt(__NQS_temp)));
                      __temp5 = (- (__NQS_y0 + __NQS_w));
                    end
                    else begin
                      __NQS_xg1 = ( 1.0 / ((__Gp *  0.732464877560822) +  1.25));
                      __NQS_A_fac = ((((__a_factrp *  1.25) * __NQS_xg1) -  1.0) * __NQS_xg1);
                      __NQS_xbar = ((temp / __a_factrp) * ((__NQS_A_fac * temp) +  1.0));
                      if ((abs((- __NQS_xbar)) <  230.258509299405)) begin
                        __NQS_temp = exp((- __NQS_xbar));
                      end
                      else begin
                        if (((- __NQS_xbar) <  0.0)) begin
                          __NQS_temp = ( 100.0e-102 / (((-230.258509299405 - (- __NQS_xbar)) * ((((-230.258509299405 - (- __NQS_xbar)) * (((-230.258509299405 - (- __NQS_xbar)) *  0.333333333333333) +  1.0)) *  0.5) +  1.0)) +  1.0));
                        end
                        else begin
                          __NQS_temp = (((((- __NQS_xbar) -  230.258509299405) * (((((- __NQS_xbar) -  230.258509299405) * ((((- __NQS_xbar) -  230.258509299405) *  0.333333333333333) +  1.0)) *  0.5) +  1.0)) +  1.0) *  10.0e+99);
                        end
                      end
                      __NQS_w = ( 1.0 - __NQS_temp);
                      __NQS_x0 = ((temp + (__Gp2 *  0.5)) - (__Gp * sqrt(((temp + (__Gp2 *  0.25)) - __NQS_w))));
                      if ((abs((- __NQS_x0)) <  230.258509299405)) begin
                        __NQS_D0 = exp((- __NQS_x0));
                      end
                      else begin
                        if (((- __NQS_x0) <  0.0)) begin
                          __NQS_D0 = ( 100.0e-102 / (((-230.258509299405 - (- __NQS_x0)) * ((((-230.258509299405 - (- __NQS_x0)) * (((-230.258509299405 - (- __NQS_x0)) *  0.333333333333333) +  1.0)) *  0.5) +  1.0)) +  1.0));
                        end
                        else begin
                          __NQS_D0 = (((((- __NQS_x0) -  230.258509299405) * (((((- __NQS_x0) -  230.258509299405) * ((((- __NQS_x0) -  230.258509299405) *  0.333333333333333) +  1.0)) *  0.5) +  1.0)) +  1.0) *  10.0e+99);
                        end
                      end
                      __NQS_xi = ( 1.0 - ((__Gp2 *  0.5) * __NQS_D0));
                      __NQS_p = (((temp - __NQS_x0) *  2.0) + (__Gp2 * ( 1.0 - __NQS_D0)));
                      __NQS_q = (((temp - __NQS_x0) * (temp - __NQS_x0)) - (__Gp2 * ((__NQS_x0 -  1.0) + __NQS_D0)));
                      __NQS_temp = ((__NQS_p * __NQS_p) - ((__NQS_xi *  4.0) * __NQS_q));
                      __NQS_u = ((__NQS_q *  2.0) / (__NQS_p + sqrt(__NQS_temp)));
                      __temp5 = (__NQS_x0 + __NQS_u);
                    end
                  end
                  __QG_NQS = (__xg_ac - ((((__x_sp + (((temp1 + __temp3) + __temp5) *  4.0)) + ((temp2 + __temp4) *  2.0)) + __x_dp) /  18.0));
                end
                else begin
                  if ((__SWNQS_i == 9)) begin
                    __QS_NQS = ((((((((__Qp8 *  75.653e+3) + (__Qp4 *  225.999e+3)) /  3.7829e+6) + (((((__Qp9 *  151.321e+3) + (__Qp7 *  454.023e+3)) + (__Qp3 *  1.073767e+6)) + (__Qp1 *  1.564569e+6)) /  15.1316e+6)) + (__Qp6 *  0.0399814956779191)) + (__Qp5 *  0.0500690607734807)) + (__Qp2 *  0.076410161516297)) + (((__Qp0 *  3.504517e+6) + (__QpN *  75.653e+3)) /  90.7896e+6));
                    __QD_NQS = ((((((((__Qp2 *  75.653e+3) + (__Qp6 *  225.999e+3)) /  3.7829e+6) + (((((__Qp1 *  151.321e+3) + (__Qp3 *  454.023e+3)) + (__Qp7 *  1.073767e+6)) + (__Qp9 *  1.564569e+6)) /  15.1316e+6)) + (__Qp4 *  0.0399814956779191)) + (__Qp5 *  0.0500690607734807)) + (__Qp8 *  0.076410161516297)) + (((__QpN *  3.504517e+6) + (__Qp0 *  75.653e+3)) /  90.7896e+6));
                    temp = ((__Qp1 / __pd) + __xg_ac);
                    if ((abs(temp) <= __marginp)) begin
                      temp1 = (temp / __a_factrp);
                    end
                    else begin
                      if ((temp < (- __marginp))) begin
                        __NQS_yg = (- temp);
                        __NQS_z = ((__NQS_yg *  1.25) / __a_factrp);
                        __NQS_eta = (((__NQS_z +  10.0) - sqrt((((__NQS_z -  6.0) * (__NQS_z -  6.0)) +  64.0))) *  0.5);
                        __NQS_a = (((__NQS_yg - __NQS_eta) * (__NQS_yg - __NQS_eta)) + (__Gp2 * (__NQS_eta +  1.0)));
                        __NQS_c = (((__NQS_yg - __NQS_eta) *  2.0) - __Gp2);
                        __NQS_tau = (ln((__NQS_a / __Gp2)) - __NQS_eta);
                        __nu = (__NQS_a + __NQS_c);
                        __mutau = ((__nu * __nu) + (__NQS_tau * (((__NQS_c * __NQS_c) *  0.5) - __NQS_a)));
                        __NQS_y0 = (__NQS_eta + (((__NQS_a * __nu) * __NQS_tau) / (__mutau + (((((__nu / __mutau) * __NQS_tau) * __NQS_tau) * __NQS_c) * (((__NQS_c * __NQS_c) *  0.333333333333333) - __NQS_a)))));
                        if ((abs(__NQS_y0) <  230.258509299405)) begin
                          __NQS_D0 = exp(__NQS_y0);
                        end
                        else begin
                          if ((__NQS_y0 <  0.0)) begin
                            __NQS_D0 = ( 100.0e-102 / (((-230.258509299405 - __NQS_y0) * ((((-230.258509299405 - __NQS_y0) * (((-230.258509299405 - __NQS_y0) *  0.333333333333333) +  1.0)) *  0.5) +  1.0)) +  1.0));
                          end
                          else begin
                            __NQS_D0 = ((((__NQS_y0 -  230.258509299405) * ((((__NQS_y0 -  230.258509299405) * (((__NQS_y0 -  230.258509299405) *  0.333333333333333) +  1.0)) *  0.5) +  1.0)) +  1.0) *  10.0e+99);
                          end
                        end
                        __NQS_xi = ( 1.0 - ((__Gp2 * __NQS_D0) *  0.5));
                        __NQS_p = (((__NQS_yg - __NQS_y0) *  2.0) + (__Gp2 * (__NQS_D0 -  1.0)));
                        __NQS_q = (((__NQS_yg - __NQS_y0) * (__NQS_yg - __NQS_y0)) + (__Gp2 * ((__NQS_y0 +  1.0) - __NQS_D0)));
                        __NQS_temp = ((__NQS_p * __NQS_p) - ((__NQS_xi *  4.0) * __NQS_q));
                        __NQS_w = ((__NQS_q *  2.0) / (__NQS_p + sqrt(__NQS_temp)));
                        temp1 = (- (__NQS_y0 + __NQS_w));
                      end
                      else begin
                        __NQS_xg1 = ( 1.0 / ((__Gp *  0.732464877560822) +  1.25));
                        __NQS_A_fac = ((((__a_factrp *  1.25) * __NQS_xg1) -  1.0) * __NQS_xg1);
                        __NQS_xbar = ((temp / __a_factrp) * ((__NQS_A_fac * temp) +  1.0));
                        if ((abs((- __NQS_xbar)) <  230.258509299405)) begin
                          __NQS_temp = exp((- __NQS_xbar));
                        end
                        else begin
                          if (((- __NQS_xbar) <  0.0)) begin
                            __NQS_temp = ( 100.0e-102 / (((-230.258509299405 - (- __NQS_xbar)) * ((((-230.258509299405 - (- __NQS_xbar)) * (((-230.258509299405 - (- __NQS_xbar)) *  0.333333333333333) +  1.0)) *  0.5) +  1.0)) +  1.0));
                          end
                          else begin
                            __NQS_temp = (((((- __NQS_xbar) -  230.258509299405) * (((((- __NQS_xbar) -  230.258509299405) * ((((- __NQS_xbar) -  230.258509299405) *  0.333333333333333) +  1.0)) *  0.5) +  1.0)) +  1.0) *  10.0e+99);
                          end
                        end
                        __NQS_w = ( 1.0 - __NQS_temp);
                        __NQS_x0 = ((temp + (__Gp2 *  0.5)) - (__Gp * sqrt(((temp + (__Gp2 *  0.25)) - __NQS_w))));
                        if ((abs((- __NQS_x0)) <  230.258509299405)) begin
                          __NQS_D0 = exp((- __NQS_x0));
                        end
                        else begin
                          if (((- __NQS_x0) <  0.0)) begin
                            __NQS_D0 = ( 100.0e-102 / (((-230.258509299405 - (- __NQS_x0)) * ((((-230.258509299405 - (- __NQS_x0)) * (((-230.258509299405 - (- __NQS_x0)) *  0.333333333333333) +  1.0)) *  0.5) +  1.0)) +  1.0));
                          end
                          else begin
                            __NQS_D0 = (((((- __NQS_x0) -  230.258509299405) * (((((- __NQS_x0) -  230.258509299405) * ((((- __NQS_x0) -  230.258509299405) *  0.333333333333333) +  1.0)) *  0.5) +  1.0)) +  1.0) *  10.0e+99);
                          end
                        end
                        __NQS_xi = ( 1.0 - ((__Gp2 *  0.5) * __NQS_D0));
                        __NQS_p = (((temp - __NQS_x0) *  2.0) + (__Gp2 * ( 1.0 - __NQS_D0)));
                        __NQS_q = (((temp - __NQS_x0) * (temp - __NQS_x0)) - (__Gp2 * ((__NQS_x0 -  1.0) + __NQS_D0)));
                        __NQS_temp = ((__NQS_p * __NQS_p) - ((__NQS_xi *  4.0) * __NQS_q));
                        __NQS_u = ((__NQS_q *  2.0) / (__NQS_p + sqrt(__NQS_temp)));
                        temp1 = (__NQS_x0 + __NQS_u);
                      end
                    end
                    temp = ((__Qp2 / __pd) + __xg_ac);
                    if ((abs(temp) <= __marginp)) begin
                      temp2 = (temp / __a_factrp);
                    end
                    else begin
                      if ((temp < (- __marginp))) begin
                        __NQS_yg = (- temp);
                        __NQS_z = ((__NQS_yg *  1.25) / __a_factrp);
                        __NQS_eta = (((__NQS_z +  10.0) - sqrt((((__NQS_z -  6.0) * (__NQS_z -  6.0)) +  64.0))) *  0.5);
                        __NQS_a = (((__NQS_yg - __NQS_eta) * (__NQS_yg - __NQS_eta)) + (__Gp2 * (__NQS_eta +  1.0)));
                        __NQS_c = (((__NQS_yg - __NQS_eta) *  2.0) - __Gp2);
                        __NQS_tau = (ln((__NQS_a / __Gp2)) - __NQS_eta);
                        __nu = (__NQS_a + __NQS_c);
                        __mutau = ((__nu * __nu) + (__NQS_tau * (((__NQS_c * __NQS_c) *  0.5) - __NQS_a)));
                        __NQS_y0 = (__NQS_eta + (((__NQS_a * __nu) * __NQS_tau) / (__mutau + (((((__nu / __mutau) * __NQS_tau) * __NQS_tau) * __NQS_c) * (((__NQS_c * __NQS_c) *  0.333333333333333) - __NQS_a)))));
                        if ((abs(__NQS_y0) <  230.258509299405)) begin
                          __NQS_D0 = exp(__NQS_y0);
                        end
                        else begin
                          if ((__NQS_y0 <  0.0)) begin
                            __NQS_D0 = ( 100.0e-102 / (((-230.258509299405 - __NQS_y0) * ((((-230.258509299405 - __NQS_y0) * (((-230.258509299405 - __NQS_y0) *  0.333333333333333) +  1.0)) *  0.5) +  1.0)) +  1.0));
                          end
                          else begin
                            __NQS_D0 = ((((__NQS_y0 -  230.258509299405) * ((((__NQS_y0 -  230.258509299405) * (((__NQS_y0 -  230.258509299405) *  0.333333333333333) +  1.0)) *  0.5) +  1.0)) +  1.0) *  10.0e+99);
                          end
                        end
                        __NQS_xi = ( 1.0 - ((__Gp2 * __NQS_D0) *  0.5));
                        __NQS_p = (((__NQS_yg - __NQS_y0) *  2.0) + (__Gp2 * (__NQS_D0 -  1.0)));
                        __NQS_q = (((__NQS_yg - __NQS_y0) * (__NQS_yg - __NQS_y0)) + (__Gp2 * ((__NQS_y0 +  1.0) - __NQS_D0)));
                        __NQS_temp = ((__NQS_p * __NQS_p) - ((__NQS_xi *  4.0) * __NQS_q));
                        __NQS_w = ((__NQS_q *  2.0) / (__NQS_p + sqrt(__NQS_temp)));
                        temp2 = (- (__NQS_y0 + __NQS_w));
                      end
                      else begin
                        __NQS_xg1 = ( 1.0 / ((__Gp *  0.732464877560822) +  1.25));
                        __NQS_A_fac = ((((__a_factrp *  1.25) * __NQS_xg1) -  1.0) * __NQS_xg1);
                        __NQS_xbar = ((temp / __a_factrp) * ((__NQS_A_fac * temp) +  1.0));
                        if ((abs((- __NQS_xbar)) <  230.258509299405)) begin
                          __NQS_temp = exp((- __NQS_xbar));
                        end
                        else begin
                          if (((- __NQS_xbar) <  0.0)) begin
                            __NQS_temp = ( 100.0e-102 / (((-230.258509299405 - (- __NQS_xbar)) * ((((-230.258509299405 - (- __NQS_xbar)) * (((-230.258509299405 - (- __NQS_xbar)) *  0.333333333333333) +  1.0)) *  0.5) +  1.0)) +  1.0));
                          end
                          else begin
                            __NQS_temp = (((((- __NQS_xbar) -  230.258509299405) * (((((- __NQS_xbar) -  230.258509299405) * ((((- __NQS_xbar) -  230.258509299405) *  0.333333333333333) +  1.0)) *  0.5) +  1.0)) +  1.0) *  10.0e+99);
                          end
                        end
                        __NQS_w = ( 1.0 - __NQS_temp);
                        __NQS_x0 = ((temp + (__Gp2 *  0.5)) - (__Gp * sqrt(((temp + (__Gp2 *  0.25)) - __NQS_w))));
                        if ((abs((- __NQS_x0)) <  230.258509299405)) begin
                          __NQS_D0 = exp((- __NQS_x0));
                        end
                        else begin
                          if (((- __NQS_x0) <  0.0)) begin
                            __NQS_D0 = ( 100.0e-102 / (((-230.258509299405 - (- __NQS_x0)) * ((((-230.258509299405 - (- __NQS_x0)) * (((-230.258509299405 - (- __NQS_x0)) *  0.333333333333333) +  1.0)) *  0.5) +  1.0)) +  1.0));
                          end
                          else begin
                            __NQS_D0 = (((((- __NQS_x0) -  230.258509299405) * (((((- __NQS_x0) -  230.258509299405) * ((((- __NQS_x0) -  230.258509299405) *  0.333333333333333) +  1.0)) *  0.5) +  1.0)) +  1.0) *  10.0e+99);
                          end
                        end
                        __NQS_xi = ( 1.0 - ((__Gp2 *  0.5) * __NQS_D0));
                        __NQS_p = (((temp - __NQS_x0) *  2.0) + (__Gp2 * ( 1.0 - __NQS_D0)));
                        __NQS_q = (((temp - __NQS_x0) * (temp - __NQS_x0)) - (__Gp2 * ((__NQS_x0 -  1.0) + __NQS_D0)));
                        __NQS_temp = ((__NQS_p * __NQS_p) - ((__NQS_xi *  4.0) * __NQS_q));
                        __NQS_u = ((__NQS_q *  2.0) / (__NQS_p + sqrt(__NQS_temp)));
                        temp2 = (__NQS_x0 + __NQS_u);
                      end
                    end
                    temp = ((__Qp3 / __pd) + __xg_ac);
                    if ((abs(temp) <= __marginp)) begin
                      __temp3 = (temp / __a_factrp);
                    end
                    else begin
                      if ((temp < (- __marginp))) begin
                        __NQS_yg = (- temp);
                        __NQS_z = ((__NQS_yg *  1.25) / __a_factrp);
                        __NQS_eta = (((__NQS_z +  10.0) - sqrt((((__NQS_z -  6.0) * (__NQS_z -  6.0)) +  64.0))) *  0.5);
                        __NQS_a = (((__NQS_yg - __NQS_eta) * (__NQS_yg - __NQS_eta)) + (__Gp2 * (__NQS_eta +  1.0)));
                        __NQS_c = (((__NQS_yg - __NQS_eta) *  2.0) - __Gp2);
                        __NQS_tau = (ln((__NQS_a / __Gp2)) - __NQS_eta);
                        __nu = (__NQS_a + __NQS_c);
                        __mutau = ((__nu * __nu) + (__NQS_tau * (((__NQS_c * __NQS_c) *  0.5) - __NQS_a)));
                        __NQS_y0 = (__NQS_eta + (((__NQS_a * __nu) * __NQS_tau) / (__mutau + (((((__nu / __mutau) * __NQS_tau) * __NQS_tau) * __NQS_c) * (((__NQS_c * __NQS_c) *  0.333333333333333) - __NQS_a)))));
                        if ((abs(__NQS_y0) <  230.258509299405)) begin
                          __NQS_D0 = exp(__NQS_y0);
                        end
                        else begin
                          if ((__NQS_y0 <  0.0)) begin
                            __NQS_D0 = ( 100.0e-102 / (((-230.258509299405 - __NQS_y0) * ((((-230.258509299405 - __NQS_y0) * (((-230.258509299405 - __NQS_y0) *  0.333333333333333) +  1.0)) *  0.5) +  1.0)) +  1.0));
                          end
                          else begin
                            __NQS_D0 = ((((__NQS_y0 -  230.258509299405) * ((((__NQS_y0 -  230.258509299405) * (((__NQS_y0 -  230.258509299405) *  0.333333333333333) +  1.0)) *  0.5) +  1.0)) +  1.0) *  10.0e+99);
                          end
                        end
                        __NQS_xi = ( 1.0 - ((__Gp2 * __NQS_D0) *  0.5));
                        __NQS_p = (((__NQS_yg - __NQS_y0) *  2.0) + (__Gp2 * (__NQS_D0 -  1.0)));
                        __NQS_q = (((__NQS_yg - __NQS_y0) * (__NQS_yg - __NQS_y0)) + (__Gp2 * ((__NQS_y0 +  1.0) - __NQS_D0)));
                        __NQS_temp = ((__NQS_p * __NQS_p) - ((__NQS_xi *  4.0) * __NQS_q));
                        __NQS_w = ((__NQS_q *  2.0) / (__NQS_p + sqrt(__NQS_temp)));
                        __temp3 = (- (__NQS_y0 + __NQS_w));
                      end
                      else begin
                        __NQS_xg1 = ( 1.0 / ((__Gp *  0.732464877560822) +  1.25));
                        __NQS_A_fac = ((((__a_factrp *  1.25) * __NQS_xg1) -  1.0) * __NQS_xg1);
                        __NQS_xbar = ((temp / __a_factrp) * ((__NQS_A_fac * temp) +  1.0));
                        if ((abs((- __NQS_xbar)) <  230.258509299405)) begin
                          __NQS_temp = exp((- __NQS_xbar));
                        end
                        else begin
                          if (((- __NQS_xbar) <  0.0)) begin
                            __NQS_temp = ( 100.0e-102 / (((-230.258509299405 - (- __NQS_xbar)) * ((((-230.258509299405 - (- __NQS_xbar)) * (((-230.258509299405 - (- __NQS_xbar)) *  0.333333333333333) +  1.0)) *  0.5) +  1.0)) +  1.0));
                          end
                          else begin
                            __NQS_temp = (((((- __NQS_xbar) -  230.258509299405) * (((((- __NQS_xbar) -  230.258509299405) * ((((- __NQS_xbar) -  230.258509299405) *  0.333333333333333) +  1.0)) *  0.5) +  1.0)) +  1.0) *  10.0e+99);
                          end
                        end
                        __NQS_w = ( 1.0 - __NQS_temp);
                        __NQS_x0 = ((temp + (__Gp2 *  0.5)) - (__Gp * sqrt(((temp + (__Gp2 *  0.25)) - __NQS_w))));
                        if ((abs((- __NQS_x0)) <  230.258509299405)) begin
                          __NQS_D0 = exp((- __NQS_x0));
                        end
                        else begin
                          if (((- __NQS_x0) <  0.0)) begin
                            __NQS_D0 = ( 100.0e-102 / (((-230.258509299405 - (- __NQS_x0)) * ((((-230.258509299405 - (- __NQS_x0)) * (((-230.258509299405 - (- __NQS_x0)) *  0.333333333333333) +  1.0)) *  0.5) +  1.0)) +  1.0));
                          end
                          else begin
                            __NQS_D0 = (((((- __NQS_x0) -  230.258509299405) * (((((- __NQS_x0) -  230.258509299405) * ((((- __NQS_x0) -  230.258509299405) *  0.333333333333333) +  1.0)) *  0.5) +  1.0)) +  1.0) *  10.0e+99);
                          end
                        end
                        __NQS_xi = ( 1.0 - ((__Gp2 *  0.5) * __NQS_D0));
                        __NQS_p = (((temp - __NQS_x0) *  2.0) + (__Gp2 * ( 1.0 - __NQS_D0)));
                        __NQS_q = (((temp - __NQS_x0) * (temp - __NQS_x0)) - (__Gp2 * ((__NQS_x0 -  1.0) + __NQS_D0)));
                        __NQS_temp = ((__NQS_p * __NQS_p) - ((__NQS_xi *  4.0) * __NQS_q));
                        __NQS_u = ((__NQS_q *  2.0) / (__NQS_p + sqrt(__NQS_temp)));
                        __temp3 = (__NQS_x0 + __NQS_u);
                      end
                    end
                    temp = ((__Qp4 / __pd) + __xg_ac);
                    if ((abs(temp) <= __marginp)) begin
                      __temp4 = (temp / __a_factrp);
                    end
                    else begin
                      if ((temp < (- __marginp))) begin
                        __NQS_yg = (- temp);
                        __NQS_z = ((__NQS_yg *  1.25) / __a_factrp);
                        __NQS_eta = (((__NQS_z +  10.0) - sqrt((((__NQS_z -  6.0) * (__NQS_z -  6.0)) +  64.0))) *  0.5);
                        __NQS_a = (((__NQS_yg - __NQS_eta) * (__NQS_yg - __NQS_eta)) + (__Gp2 * (__NQS_eta +  1.0)));
                        __NQS_c = (((__NQS_yg - __NQS_eta) *  2.0) - __Gp2);
                        __NQS_tau = (ln((__NQS_a / __Gp2)) - __NQS_eta);
                        __nu = (__NQS_a + __NQS_c);
                        __mutau = ((__nu * __nu) + (__NQS_tau * (((__NQS_c * __NQS_c) *  0.5) - __NQS_a)));
                        __NQS_y0 = (__NQS_eta + (((__NQS_a * __nu) * __NQS_tau) / (__mutau + (((((__nu / __mutau) * __NQS_tau) * __NQS_tau) * __NQS_c) * (((__NQS_c * __NQS_c) *  0.333333333333333) - __NQS_a)))));
                        if ((abs(__NQS_y0) <  230.258509299405)) begin
                          __NQS_D0 = exp(__NQS_y0);
                        end
                        else begin
                          if ((__NQS_y0 <  0.0)) begin
                            __NQS_D0 = ( 100.0e-102 / (((-230.258509299405 - __NQS_y0) * ((((-230.258509299405 - __NQS_y0) * (((-230.258509299405 - __NQS_y0) *  0.333333333333333) +  1.0)) *  0.5) +  1.0)) +  1.0));
                          end
                          else begin
                            __NQS_D0 = ((((__NQS_y0 -  230.258509299405) * ((((__NQS_y0 -  230.258509299405) * (((__NQS_y0 -  230.258509299405) *  0.333333333333333) +  1.0)) *  0.5) +  1.0)) +  1.0) *  10.0e+99);
                          end
                        end
                        __NQS_xi = ( 1.0 - ((__Gp2 * __NQS_D0) *  0.5));
                        __NQS_p = (((__NQS_yg - __NQS_y0) *  2.0) + (__Gp2 * (__NQS_D0 -  1.0)));
                        __NQS_q = (((__NQS_yg - __NQS_y0) * (__NQS_yg - __NQS_y0)) + (__Gp2 * ((__NQS_y0 +  1.0) - __NQS_D0)));
                        __NQS_temp = ((__NQS_p * __NQS_p) - ((__NQS_xi *  4.0) * __NQS_q));
                        __NQS_w = ((__NQS_q *  2.0) / (__NQS_p + sqrt(__NQS_temp)));
                        __temp4 = (- (__NQS_y0 + __NQS_w));
                      end
                      else begin
                        __NQS_xg1 = ( 1.0 / ((__Gp *  0.732464877560822) +  1.25));
                        __NQS_A_fac = ((((__a_factrp *  1.25) * __NQS_xg1) -  1.0) * __NQS_xg1);
                        __NQS_xbar = ((temp / __a_factrp) * ((__NQS_A_fac * temp) +  1.0));
                        if ((abs((- __NQS_xbar)) <  230.258509299405)) begin
                          __NQS_temp = exp((- __NQS_xbar));
                        end
                        else begin
                          if (((- __NQS_xbar) <  0.0)) begin
                            __NQS_temp = ( 100.0e-102 / (((-230.258509299405 - (- __NQS_xbar)) * ((((-230.258509299405 - (- __NQS_xbar)) * (((-230.258509299405 - (- __NQS_xbar)) *  0.333333333333333) +  1.0)) *  0.5) +  1.0)) +  1.0));
                          end
                          else begin
                            __NQS_temp = (((((- __NQS_xbar) -  230.258509299405) * (((((- __NQS_xbar) -  230.258509299405) * ((((- __NQS_xbar) -  230.258509299405) *  0.333333333333333) +  1.0)) *  0.5) +  1.0)) +  1.0) *  10.0e+99);
                          end
                        end
                        __NQS_w = ( 1.0 - __NQS_temp);
                        __NQS_x0 = ((temp + (__Gp2 *  0.5)) - (__Gp * sqrt(((temp + (__Gp2 *  0.25)) - __NQS_w))));
                        if ((abs((- __NQS_x0)) <  230.258509299405)) begin
                          __NQS_D0 = exp((- __NQS_x0));
                        end
                        else begin
                          if (((- __NQS_x0) <  0.0)) begin
                            __NQS_D0 = ( 100.0e-102 / (((-230.258509299405 - (- __NQS_x0)) * ((((-230.258509299405 - (- __NQS_x0)) * (((-230.258509299405 - (- __NQS_x0)) *  0.333333333333333) +  1.0)) *  0.5) +  1.0)) +  1.0));
                          end
                          else begin
                            __NQS_D0 = (((((- __NQS_x0) -  230.258509299405) * (((((- __NQS_x0) -  230.258509299405) * ((((- __NQS_x0) -  230.258509299405) *  0.333333333333333) +  1.0)) *  0.5) +  1.0)) +  1.0) *  10.0e+99);
                          end
                        end
                        __NQS_xi = ( 1.0 - ((__Gp2 *  0.5) * __NQS_D0));
                        __NQS_p = (((temp - __NQS_x0) *  2.0) + (__Gp2 * ( 1.0 - __NQS_D0)));
                        __NQS_q = (((temp - __NQS_x0) * (temp - __NQS_x0)) - (__Gp2 * ((__NQS_x0 -  1.0) + __NQS_D0)));
                        __NQS_temp = ((__NQS_p * __NQS_p) - ((__NQS_xi *  4.0) * __NQS_q));
                        __NQS_u = ((__NQS_q *  2.0) / (__NQS_p + sqrt(__NQS_temp)));
                        __temp4 = (__NQS_x0 + __NQS_u);
                      end
                    end
                    temp = ((__Qp5 / __pd) + __xg_ac);
                    if ((abs(temp) <= __marginp)) begin
                      __temp5 = (temp / __a_factrp);
                    end
                    else begin
                      if ((temp < (- __marginp))) begin
                        __NQS_yg = (- temp);
                        __NQS_z = ((__NQS_yg *  1.25) / __a_factrp);
                        __NQS_eta = (((__NQS_z +  10.0) - sqrt((((__NQS_z -  6.0) * (__NQS_z -  6.0)) +  64.0))) *  0.5);
                        __NQS_a = (((__NQS_yg - __NQS_eta) * (__NQS_yg - __NQS_eta)) + (__Gp2 * (__NQS_eta +  1.0)));
                        __NQS_c = (((__NQS_yg - __NQS_eta) *  2.0) - __Gp2);
                        __NQS_tau = (ln((__NQS_a / __Gp2)) - __NQS_eta);
                        __nu = (__NQS_a + __NQS_c);
                        __mutau = ((__nu * __nu) + (__NQS_tau * (((__NQS_c * __NQS_c) *  0.5) - __NQS_a)));
                        __NQS_y0 = (__NQS_eta + (((__NQS_a * __nu) * __NQS_tau) / (__mutau + (((((__nu / __mutau) * __NQS_tau) * __NQS_tau) * __NQS_c) * (((__NQS_c * __NQS_c) *  0.333333333333333) - __NQS_a)))));
                        if ((abs(__NQS_y0) <  230.258509299405)) begin
                          __NQS_D0 = exp(__NQS_y0);
                        end
                        else begin
                          if ((__NQS_y0 <  0.0)) begin
                            __NQS_D0 = ( 100.0e-102 / (((-230.258509299405 - __NQS_y0) * ((((-230.258509299405 - __NQS_y0) * (((-230.258509299405 - __NQS_y0) *  0.333333333333333) +  1.0)) *  0.5) +  1.0)) +  1.0));
                          end
                          else begin
                            __NQS_D0 = ((((__NQS_y0 -  230.258509299405) * ((((__NQS_y0 -  230.258509299405) * (((__NQS_y0 -  230.258509299405) *  0.333333333333333) +  1.0)) *  0.5) +  1.0)) +  1.0) *  10.0e+99);
                          end
                        end
                        __NQS_xi = ( 1.0 - ((__Gp2 * __NQS_D0) *  0.5));
                        __NQS_p = (((__NQS_yg - __NQS_y0) *  2.0) + (__Gp2 * (__NQS_D0 -  1.0)));
                        __NQS_q = (((__NQS_yg - __NQS_y0) * (__NQS_yg - __NQS_y0)) + (__Gp2 * ((__NQS_y0 +  1.0) - __NQS_D0)));
                        __NQS_temp = ((__NQS_p * __NQS_p) - ((__NQS_xi *  4.0) * __NQS_q));
                        __NQS_w = ((__NQS_q *  2.0) / (__NQS_p + sqrt(__NQS_temp)));
                        __temp5 = (- (__NQS_y0 + __NQS_w));
                      end
                      else begin
                        __NQS_xg1 = ( 1.0 / ((__Gp *  0.732464877560822) +  1.25));
                        __NQS_A_fac = ((((__a_factrp *  1.25) * __NQS_xg1) -  1.0) * __NQS_xg1);
                        __NQS_xbar = ((temp / __a_factrp) * ((__NQS_A_fac * temp) +  1.0));
                        if ((abs((- __NQS_xbar)) <  230.258509299405)) begin
                          __NQS_temp = exp((- __NQS_xbar));
                        end
                        else begin
                          if (((- __NQS_xbar) <  0.0)) begin
                            __NQS_temp = ( 100.0e-102 / (((-230.258509299405 - (- __NQS_xbar)) * ((((-230.258509299405 - (- __NQS_xbar)) * (((-230.258509299405 - (- __NQS_xbar)) *  0.333333333333333) +  1.0)) *  0.5) +  1.0)) +  1.0));
                          end
                          else begin
                            __NQS_temp = (((((- __NQS_xbar) -  230.258509299405) * (((((- __NQS_xbar) -  230.258509299405) * ((((- __NQS_xbar) -  230.258509299405) *  0.333333333333333) +  1.0)) *  0.5) +  1.0)) +  1.0) *  10.0e+99);
                          end
                        end
                        __NQS_w = ( 1.0 - __NQS_temp);
                        __NQS_x0 = ((temp + (__Gp2 *  0.5)) - (__Gp * sqrt(((temp + (__Gp2 *  0.25)) - __NQS_w))));
                        if ((abs((- __NQS_x0)) <  230.258509299405)) begin
                          __NQS_D0 = exp((- __NQS_x0));
                        end
                        else begin
                          if (((- __NQS_x0) <  0.0)) begin
                            __NQS_D0 = ( 100.0e-102 / (((-230.258509299405 - (- __NQS_x0)) * ((((-230.258509299405 - (- __NQS_x0)) * (((-230.258509299405 - (- __NQS_x0)) *  0.333333333333333) +  1.0)) *  0.5) +  1.0)) +  1.0));
                          end
                          else begin
                            __NQS_D0 = (((((- __NQS_x0) -  230.258509299405) * (((((- __NQS_x0) -  230.258509299405) * ((((- __NQS_x0) -  230.258509299405) *  0.333333333333333) +  1.0)) *  0.5) +  1.0)) +  1.0) *  10.0e+99);
                          end
                        end
                        __NQS_xi = ( 1.0 - ((__Gp2 *  0.5) * __NQS_D0));
                        __NQS_p = (((temp - __NQS_x0) *  2.0) + (__Gp2 * ( 1.0 - __NQS_D0)));
                        __NQS_q = (((temp - __NQS_x0) * (temp - __NQS_x0)) - (__Gp2 * ((__NQS_x0 -  1.0) + __NQS_D0)));
                        __NQS_temp = ((__NQS_p * __NQS_p) - ((__NQS_xi *  4.0) * __NQS_q));
                        __NQS_u = ((__NQS_q *  2.0) / (__NQS_p + sqrt(__NQS_temp)));
                        __temp5 = (__NQS_x0 + __NQS_u);
                      end
                    end
                    temp = ((__Qp6 / __pd) + __xg_ac);
                    if ((abs(temp) <= __marginp)) begin
                      __temp6 = (temp / __a_factrp);
                    end
                    else begin
                      if ((temp < (- __marginp))) begin
                        __NQS_yg = (- temp);
                        __NQS_z = ((__NQS_yg *  1.25) / __a_factrp);
                        __NQS_eta = (((__NQS_z +  10.0) - sqrt((((__NQS_z -  6.0) * (__NQS_z -  6.0)) +  64.0))) *  0.5);
                        __NQS_a = (((__NQS_yg - __NQS_eta) * (__NQS_yg - __NQS_eta)) + (__Gp2 * (__NQS_eta +  1.0)));
                        __NQS_c = (((__NQS_yg - __NQS_eta) *  2.0) - __Gp2);
                        __NQS_tau = (ln((__NQS_a / __Gp2)) - __NQS_eta);
                        __nu = (__NQS_a + __NQS_c);
                        __mutau = ((__nu * __nu) + (__NQS_tau * (((__NQS_c * __NQS_c) *  0.5) - __NQS_a)));
                        __NQS_y0 = (__NQS_eta + (((__NQS_a * __nu) * __NQS_tau) / (__mutau + (((((__nu / __mutau) * __NQS_tau) * __NQS_tau) * __NQS_c) * (((__NQS_c * __NQS_c) *  0.333333333333333) - __NQS_a)))));
                        if ((abs(__NQS_y0) <  230.258509299405)) begin
                          __NQS_D0 = exp(__NQS_y0);
                        end
                        else begin
                          if ((__NQS_y0 <  0.0)) begin
                            __NQS_D0 = ( 100.0e-102 / (((-230.258509299405 - __NQS_y0) * ((((-230.258509299405 - __NQS_y0) * (((-230.258509299405 - __NQS_y0) *  0.333333333333333) +  1.0)) *  0.5) +  1.0)) +  1.0));
                          end
                          else begin
                            __NQS_D0 = ((((__NQS_y0 -  230.258509299405) * ((((__NQS_y0 -  230.258509299405) * (((__NQS_y0 -  230.258509299405) *  0.333333333333333) +  1.0)) *  0.5) +  1.0)) +  1.0) *  10.0e+99);
                          end
                        end
                        __NQS_xi = ( 1.0 - ((__Gp2 * __NQS_D0) *  0.5));
                        __NQS_p = (((__NQS_yg - __NQS_y0) *  2.0) + (__Gp2 * (__NQS_D0 -  1.0)));
                        __NQS_q = (((__NQS_yg - __NQS_y0) * (__NQS_yg - __NQS_y0)) + (__Gp2 * ((__NQS_y0 +  1.0) - __NQS_D0)));
                        __NQS_temp = ((__NQS_p * __NQS_p) - ((__NQS_xi *  4.0) * __NQS_q));
                        __NQS_w = ((__NQS_q *  2.0) / (__NQS_p + sqrt(__NQS_temp)));
                        __temp6 = (- (__NQS_y0 + __NQS_w));
                      end
                      else begin
                        __NQS_xg1 = ( 1.0 / ((__Gp *  0.732464877560822) +  1.25));
                        __NQS_A_fac = ((((__a_factrp *  1.25) * __NQS_xg1) -  1.0) * __NQS_xg1);
                        __NQS_xbar = ((temp / __a_factrp) * ((__NQS_A_fac * temp) +  1.0));
                        if ((abs((- __NQS_xbar)) <  230.258509299405)) begin
                          __NQS_temp = exp((- __NQS_xbar));
                        end
                        else begin
                          if (((- __NQS_xbar) <  0.0)) begin
                            __NQS_temp = ( 100.0e-102 / (((-230.258509299405 - (- __NQS_xbar)) * ((((-230.258509299405 - (- __NQS_xbar)) * (((-230.258509299405 - (- __NQS_xbar)) *  0.333333333333333) +  1.0)) *  0.5) +  1.0)) +  1.0));
                          end
                          else begin
                            __NQS_temp = (((((- __NQS_xbar) -  230.258509299405) * (((((- __NQS_xbar) -  230.258509299405) * ((((- __NQS_xbar) -  230.258509299405) *  0.333333333333333) +  1.0)) *  0.5) +  1.0)) +  1.0) *  10.0e+99);
                          end
                        end
                        __NQS_w = ( 1.0 - __NQS_temp);
                        __NQS_x0 = ((temp + (__Gp2 *  0.5)) - (__Gp * sqrt(((temp + (__Gp2 *  0.25)) - __NQS_w))));
                        if ((abs((- __NQS_x0)) <  230.258509299405)) begin
                          __NQS_D0 = exp((- __NQS_x0));
                        end
                        else begin
                          if (((- __NQS_x0) <  0.0)) begin
                            __NQS_D0 = ( 100.0e-102 / (((-230.258509299405 - (- __NQS_x0)) * ((((-230.258509299405 - (- __NQS_x0)) * (((-230.258509299405 - (- __NQS_x0)) *  0.333333333333333) +  1.0)) *  0.5) +  1.0)) +  1.0));
                          end
                          else begin
                            __NQS_D0 = (((((- __NQS_x0) -  230.258509299405) * (((((- __NQS_x0) -  230.258509299405) * ((((- __NQS_x0) -  230.258509299405) *  0.333333333333333) +  1.0)) *  0.5) +  1.0)) +  1.0) *  10.0e+99);
                          end
                        end
                        __NQS_xi = ( 1.0 - ((__Gp2 *  0.5) * __NQS_D0));
                        __NQS_p = (((temp - __NQS_x0) *  2.0) + (__Gp2 * ( 1.0 - __NQS_D0)));
                        __NQS_q = (((temp - __NQS_x0) * (temp - __NQS_x0)) - (__Gp2 * ((__NQS_x0 -  1.0) + __NQS_D0)));
                        __NQS_temp = ((__NQS_p * __NQS_p) - ((__NQS_xi *  4.0) * __NQS_q));
                        __NQS_u = ((__NQS_q *  2.0) / (__NQS_p + sqrt(__NQS_temp)));
                        __temp6 = (__NQS_x0 + __NQS_u);
                      end
                    end
                    temp = ((__Qp7 / __pd) + __xg_ac);
                    if ((abs(temp) <= __marginp)) begin
                      __temp7 = (temp / __a_factrp);
                    end
                    else begin
                      if ((temp < (- __marginp))) begin
                        __NQS_yg = (- temp);
                        __NQS_z = ((__NQS_yg *  1.25) / __a_factrp);
                        __NQS_eta = (((__NQS_z +  10.0) - sqrt((((__NQS_z -  6.0) * (__NQS_z -  6.0)) +  64.0))) *  0.5);
                        __NQS_a = (((__NQS_yg - __NQS_eta) * (__NQS_yg - __NQS_eta)) + (__Gp2 * (__NQS_eta +  1.0)));
                        __NQS_c = (((__NQS_yg - __NQS_eta) *  2.0) - __Gp2);
                        __NQS_tau = (ln((__NQS_a / __Gp2)) - __NQS_eta);
                        __nu = (__NQS_a + __NQS_c);
                        __mutau = ((__nu * __nu) + (__NQS_tau * (((__NQS_c * __NQS_c) *  0.5) - __NQS_a)));
                        __NQS_y0 = (__NQS_eta + (((__NQS_a * __nu) * __NQS_tau) / (__mutau + (((((__nu / __mutau) * __NQS_tau) * __NQS_tau) * __NQS_c) * (((__NQS_c * __NQS_c) *  0.333333333333333) - __NQS_a)))));
                        if ((abs(__NQS_y0) <  230.258509299405)) begin
                          __NQS_D0 = exp(__NQS_y0);
                        end
                        else begin
                          if ((__NQS_y0 <  0.0)) begin
                            __NQS_D0 = ( 100.0e-102 / (((-230.258509299405 - __NQS_y0) * ((((-230.258509299405 - __NQS_y0) * (((-230.258509299405 - __NQS_y0) *  0.333333333333333) +  1.0)) *  0.5) +  1.0)) +  1.0));
                          end
                          else begin
                            __NQS_D0 = ((((__NQS_y0 -  230.258509299405) * ((((__NQS_y0 -  230.258509299405) * (((__NQS_y0 -  230.258509299405) *  0.333333333333333) +  1.0)) *  0.5) +  1.0)) +  1.0) *  10.0e+99);
                          end
                        end
                        __NQS_xi = ( 1.0 - ((__Gp2 * __NQS_D0) *  0.5));
                        __NQS_p = (((__NQS_yg - __NQS_y0) *  2.0) + (__Gp2 * (__NQS_D0 -  1.0)));
                        __NQS_q = (((__NQS_yg - __NQS_y0) * (__NQS_yg - __NQS_y0)) + (__Gp2 * ((__NQS_y0 +  1.0) - __NQS_D0)));
                        __NQS_temp = ((__NQS_p * __NQS_p) - ((__NQS_xi *  4.0) * __NQS_q));
                        __NQS_w = ((__NQS_q *  2.0) / (__NQS_p + sqrt(__NQS_temp)));
                        __temp7 = (- (__NQS_y0 + __NQS_w));
                      end
                      else begin
                        __NQS_xg1 = ( 1.0 / ((__Gp *  0.732464877560822) +  1.25));
                        __NQS_A_fac = ((((__a_factrp *  1.25) * __NQS_xg1) -  1.0) * __NQS_xg1);
                        __NQS_xbar = ((temp / __a_factrp) * ((__NQS_A_fac * temp) +  1.0));
                        if ((abs((- __NQS_xbar)) <  230.258509299405)) begin
                          __NQS_temp = exp((- __NQS_xbar));
                        end
                        else begin
                          if (((- __NQS_xbar) <  0.0)) begin
                            __NQS_temp = ( 100.0e-102 / (((-230.258509299405 - (- __NQS_xbar)) * ((((-230.258509299405 - (- __NQS_xbar)) * (((-230.258509299405 - (- __NQS_xbar)) *  0.333333333333333) +  1.0)) *  0.5) +  1.0)) +  1.0));
                          end
                          else begin
                            __NQS_temp = (((((- __NQS_xbar) -  230.258509299405) * (((((- __NQS_xbar) -  230.258509299405) * ((((- __NQS_xbar) -  230.258509299405) *  0.333333333333333) +  1.0)) *  0.5) +  1.0)) +  1.0) *  10.0e+99);
                          end
                        end
                        __NQS_w = ( 1.0 - __NQS_temp);
                        __NQS_x0 = ((temp + (__Gp2 *  0.5)) - (__Gp * sqrt(((temp + (__Gp2 *  0.25)) - __NQS_w))));
                        if ((abs((- __NQS_x0)) <  230.258509299405)) begin
                          __NQS_D0 = exp((- __NQS_x0));
                        end
                        else begin
                          if (((- __NQS_x0) <  0.0)) begin
                            __NQS_D0 = ( 100.0e-102 / (((-230.258509299405 - (- __NQS_x0)) * ((((-230.258509299405 - (- __NQS_x0)) * (((-230.258509299405 - (- __NQS_x0)) *  0.333333333333333) +  1.0)) *  0.5) +  1.0)) +  1.0));
                          end
                          else begin
                            __NQS_D0 = (((((- __NQS_x0) -  230.258509299405) * (((((- __NQS_x0) -  230.258509299405) * ((((- __NQS_x0) -  230.258509299405) *  0.333333333333333) +  1.0)) *  0.5) +  1.0)) +  1.0) *  10.0e+99);
                          end
                        end
                        __NQS_xi = ( 1.0 - ((__Gp2 *  0.5) * __NQS_D0));
                        __NQS_p = (((temp - __NQS_x0) *  2.0) + (__Gp2 * ( 1.0 - __NQS_D0)));
                        __NQS_q = (((temp - __NQS_x0) * (temp - __NQS_x0)) - (__Gp2 * ((__NQS_x0 -  1.0) + __NQS_D0)));
                        __NQS_temp = ((__NQS_p * __NQS_p) - ((__NQS_xi *  4.0) * __NQS_q));
                        __NQS_u = ((__NQS_q *  2.0) / (__NQS_p + sqrt(__NQS_temp)));
                        __temp7 = (__NQS_x0 + __NQS_u);
                      end
                    end
                    temp = ((__Qp8 / __pd) + __xg_ac);
                    if ((abs(temp) <= __marginp)) begin
                      __temp8 = (temp / __a_factrp);
                    end
                    else begin
                      if ((temp < (- __marginp))) begin
                        __NQS_yg = (- temp);
                        __NQS_z = ((__NQS_yg *  1.25) / __a_factrp);
                        __NQS_eta = (((__NQS_z +  10.0) - sqrt((((__NQS_z -  6.0) * (__NQS_z -  6.0)) +  64.0))) *  0.5);
                        __NQS_a = (((__NQS_yg - __NQS_eta) * (__NQS_yg - __NQS_eta)) + (__Gp2 * (__NQS_eta +  1.0)));
                        __NQS_c = (((__NQS_yg - __NQS_eta) *  2.0) - __Gp2);
                        __NQS_tau = (ln((__NQS_a / __Gp2)) - __NQS_eta);
                        __nu = (__NQS_a + __NQS_c);
                        __mutau = ((__nu * __nu) + (__NQS_tau * (((__NQS_c * __NQS_c) *  0.5) - __NQS_a)));
                        __NQS_y0 = (__NQS_eta + (((__NQS_a * __nu) * __NQS_tau) / (__mutau + (((((__nu / __mutau) * __NQS_tau) * __NQS_tau) * __NQS_c) * (((__NQS_c * __NQS_c) *  0.333333333333333) - __NQS_a)))));
                        if ((abs(__NQS_y0) <  230.258509299405)) begin
                          __NQS_D0 = exp(__NQS_y0);
                        end
                        else begin
                          if ((__NQS_y0 <  0.0)) begin
                            __NQS_D0 = ( 100.0e-102 / (((-230.258509299405 - __NQS_y0) * ((((-230.258509299405 - __NQS_y0) * (((-230.258509299405 - __NQS_y0) *  0.333333333333333) +  1.0)) *  0.5) +  1.0)) +  1.0));
                          end
                          else begin
                            __NQS_D0 = ((((__NQS_y0 -  230.258509299405) * ((((__NQS_y0 -  230.258509299405) * (((__NQS_y0 -  230.258509299405) *  0.333333333333333) +  1.0)) *  0.5) +  1.0)) +  1.0) *  10.0e+99);
                          end
                        end
                        __NQS_xi = ( 1.0 - ((__Gp2 * __NQS_D0) *  0.5));
                        __NQS_p = (((__NQS_yg - __NQS_y0) *  2.0) + (__Gp2 * (__NQS_D0 -  1.0)));
                        __NQS_q = (((__NQS_yg - __NQS_y0) * (__NQS_yg - __NQS_y0)) + (__Gp2 * ((__NQS_y0 +  1.0) - __NQS_D0)));
                        __NQS_temp = ((__NQS_p * __NQS_p) - ((__NQS_xi *  4.0) * __NQS_q));
                        __NQS_w = ((__NQS_q *  2.0) / (__NQS_p + sqrt(__NQS_temp)));
                        __temp8 = (- (__NQS_y0 + __NQS_w));
                      end
                      else begin
                        __NQS_xg1 = ( 1.0 / ((__Gp *  0.732464877560822) +  1.25));
                        __NQS_A_fac = ((((__a_factrp *  1.25) * __NQS_xg1) -  1.0) * __NQS_xg1);
                        __NQS_xbar = ((temp / __a_factrp) * ((__NQS_A_fac * temp) +  1.0));
                        if ((abs((- __NQS_xbar)) <  230.258509299405)) begin
                          __NQS_temp = exp((- __NQS_xbar));
                        end
                        else begin
                          if (((- __NQS_xbar) <  0.0)) begin
                            __NQS_temp = ( 100.0e-102 / (((-230.258509299405 - (- __NQS_xbar)) * ((((-230.258509299405 - (- __NQS_xbar)) * (((-230.258509299405 - (- __NQS_xbar)) *  0.333333333333333) +  1.0)) *  0.5) +  1.0)) +  1.0));
                          end
                          else begin
                            __NQS_temp = (((((- __NQS_xbar) -  230.258509299405) * (((((- __NQS_xbar) -  230.258509299405) * ((((- __NQS_xbar) -  230.258509299405) *  0.333333333333333) +  1.0)) *  0.5) +  1.0)) +  1.0) *  10.0e+99);
                          end
                        end
                        __NQS_w = ( 1.0 - __NQS_temp);
                        __NQS_x0 = ((temp + (__Gp2 *  0.5)) - (__Gp * sqrt(((temp + (__Gp2 *  0.25)) - __NQS_w))));
                        if ((abs((- __NQS_x0)) <  230.258509299405)) begin
                          __NQS_D0 = exp((- __NQS_x0));
                        end
                        else begin
                          if (((- __NQS_x0) <  0.0)) begin
                            __NQS_D0 = ( 100.0e-102 / (((-230.258509299405 - (- __NQS_x0)) * ((((-230.258509299405 - (- __NQS_x0)) * (((-230.258509299405 - (- __NQS_x0)) *  0.333333333333333) +  1.0)) *  0.5) +  1.0)) +  1.0));
                          end
                          else begin
                            __NQS_D0 = (((((- __NQS_x0) -  230.258509299405) * (((((- __NQS_x0) -  230.258509299405) * ((((- __NQS_x0) -  230.258509299405) *  0.333333333333333) +  1.0)) *  0.5) +  1.0)) +  1.0) *  10.0e+99);
                          end
                        end
                        __NQS_xi = ( 1.0 - ((__Gp2 *  0.5) * __NQS_D0));
                        __NQS_p = (((temp - __NQS_x0) *  2.0) + (__Gp2 * ( 1.0 - __NQS_D0)));
                        __NQS_q = (((temp - __NQS_x0) * (temp - __NQS_x0)) - (__Gp2 * ((__NQS_x0 -  1.0) + __NQS_D0)));
                        __NQS_temp = ((__NQS_p * __NQS_p) - ((__NQS_xi *  4.0) * __NQS_q));
                        __NQS_u = ((__NQS_q *  2.0) / (__NQS_p + sqrt(__NQS_temp)));
                        __temp8 = (__NQS_x0 + __NQS_u);
                      end
                    end
                    temp = ((__Qp9 / __pd) + __xg_ac);
                    if ((abs(temp) <= __marginp)) begin
                      __temp9 = (temp / __a_factrp);
                    end
                    else begin
                      if ((temp < (- __marginp))) begin
                        __NQS_yg = (- temp);
                        __NQS_z = ((__NQS_yg *  1.25) / __a_factrp);
                        __NQS_eta = (((__NQS_z +  10.0) - sqrt((((__NQS_z -  6.0) * (__NQS_z -  6.0)) +  64.0))) *  0.5);
                        __NQS_a = (((__NQS_yg - __NQS_eta) * (__NQS_yg - __NQS_eta)) + (__Gp2 * (__NQS_eta +  1.0)));
                        __NQS_c = (((__NQS_yg - __NQS_eta) *  2.0) - __Gp2);
                        __NQS_tau = (ln((__NQS_a / __Gp2)) - __NQS_eta);
                        __nu = (__NQS_a + __NQS_c);
                        __mutau = ((__nu * __nu) + (__NQS_tau * (((__NQS_c * __NQS_c) *  0.5) - __NQS_a)));
                        __NQS_y0 = (__NQS_eta + (((__NQS_a * __nu) * __NQS_tau) / (__mutau + (((((__nu / __mutau) * __NQS_tau) * __NQS_tau) * __NQS_c) * (((__NQS_c * __NQS_c) *  0.333333333333333) - __NQS_a)))));
                        if ((abs(__NQS_y0) <  230.258509299405)) begin
                          __NQS_D0 = exp(__NQS_y0);
                        end
                        else begin
                          if ((__NQS_y0 <  0.0)) begin
                            __NQS_D0 = ( 100.0e-102 / (((-230.258509299405 - __NQS_y0) * ((((-230.258509299405 - __NQS_y0) * (((-230.258509299405 - __NQS_y0) *  0.333333333333333) +  1.0)) *  0.5) +  1.0)) +  1.0));
                          end
                          else begin
                            __NQS_D0 = ((((__NQS_y0 -  230.258509299405) * ((((__NQS_y0 -  230.258509299405) * (((__NQS_y0 -  230.258509299405) *  0.333333333333333) +  1.0)) *  0.5) +  1.0)) +  1.0) *  10.0e+99);
                          end
                        end
                        __NQS_xi = ( 1.0 - ((__Gp2 * __NQS_D0) *  0.5));
                        __NQS_p = (((__NQS_yg - __NQS_y0) *  2.0) + (__Gp2 * (__NQS_D0 -  1.0)));
                        __NQS_q = (((__NQS_yg - __NQS_y0) * (__NQS_yg - __NQS_y0)) + (__Gp2 * ((__NQS_y0 +  1.0) - __NQS_D0)));
                        __NQS_temp = ((__NQS_p * __NQS_p) - ((__NQS_xi *  4.0) * __NQS_q));
                        __NQS_w = ((__NQS_q *  2.0) / (__NQS_p + sqrt(__NQS_temp)));
                        __temp9 = (- (__NQS_y0 + __NQS_w));
                      end
                      else begin
                        __NQS_xg1 = ( 1.0 / ((__Gp *  0.732464877560822) +  1.25));
                        __NQS_A_fac = ((((__a_factrp *  1.25) * __NQS_xg1) -  1.0) * __NQS_xg1);
                        __NQS_xbar = ((temp / __a_factrp) * ((__NQS_A_fac * temp) +  1.0));
                        if ((abs((- __NQS_xbar)) <  230.258509299405)) begin
                          __NQS_temp = exp((- __NQS_xbar));
                        end
                        else begin
                          if (((- __NQS_xbar) <  0.0)) begin
                            __NQS_temp = ( 100.0e-102 / (((-230.258509299405 - (- __NQS_xbar)) * ((((-230.258509299405 - (- __NQS_xbar)) * (((-230.258509299405 - (- __NQS_xbar)) *  0.333333333333333) +  1.0)) *  0.5) +  1.0)) +  1.0));
                          end
                          else begin
                            __NQS_temp = (((((- __NQS_xbar) -  230.258509299405) * (((((- __NQS_xbar) -  230.258509299405) * ((((- __NQS_xbar) -  230.258509299405) *  0.333333333333333) +  1.0)) *  0.5) +  1.0)) +  1.0) *  10.0e+99);
                          end
                        end
                        __NQS_w = ( 1.0 - __NQS_temp);
                        __NQS_x0 = ((temp + (__Gp2 *  0.5)) - (__Gp * sqrt(((temp + (__Gp2 *  0.25)) - __NQS_w))));
                        if ((abs((- __NQS_x0)) <  230.258509299405)) begin
                          __NQS_D0 = exp((- __NQS_x0));
                        end
                        else begin
                          if (((- __NQS_x0) <  0.0)) begin
                            __NQS_D0 = ( 100.0e-102 / (((-230.258509299405 - (- __NQS_x0)) * ((((-230.258509299405 - (- __NQS_x0)) * (((-230.258509299405 - (- __NQS_x0)) *  0.333333333333333) +  1.0)) *  0.5) +  1.0)) +  1.0));
                          end
                          else begin
                            __NQS_D0 = (((((- __NQS_x0) -  230.258509299405) * (((((- __NQS_x0) -  230.258509299405) * ((((- __NQS_x0) -  230.258509299405) *  0.333333333333333) +  1.0)) *  0.5) +  1.0)) +  1.0) *  10.0e+99);
                          end
                        end
                        __NQS_xi = ( 1.0 - ((__Gp2 *  0.5) * __NQS_D0));
                        __NQS_p = (((temp - __NQS_x0) *  2.0) + (__Gp2 * ( 1.0 - __NQS_D0)));
                        __NQS_q = (((temp - __NQS_x0) * (temp - __NQS_x0)) - (__Gp2 * ((__NQS_x0 -  1.0) + __NQS_D0)));
                        __NQS_temp = ((__NQS_p * __NQS_p) - ((__NQS_xi *  4.0) * __NQS_q));
                        __NQS_u = ((__NQS_q *  2.0) / (__NQS_p + sqrt(__NQS_temp)));
                        __temp9 = (__NQS_x0 + __NQS_u);
                      end
                    end
                    __QG_NQS = (__xg_ac - ((((__x_sp + (((((temp1 + __temp3) + __temp5) + __temp7) + __temp9) *  4.0)) + ((((temp2 + __temp4) + __temp6) + __temp8) *  2.0)) + __x_dp) /  30.0));
                  end
                end
              end
            end
          end
          __QG_NQS = (__pd * __QG_NQS);
          if ((sigVds > 0)) begin
            __Qs = ((COX_qm * phit1) * __QS_NQS);
            __Qd = ((COX_qm * phit1) * __QD_NQS);
          end
          else begin
            __Qs = ((COX_qm * phit1) * __QD_NQS);
            __Qd = ((COX_qm * phit1) * __QS_NQS);
          end
          __Qg = ((COX_qm * phit1) * __QG_NQS);
          __Qb = (((- __Qg) - __Qs) - __Qd);
        end
        V(RES1) <+ ((__vnorm_inv * I(RES1)) * __r_nqs);
        V(SPLINE1) <+ (__vnorm_inv * idt(((- __Tnorm) * __fk1), __Qp1_0));
        V(RES2) <+ ((__vnorm_inv * I(RES2)) * __r_nqs);
        V(SPLINE2) <+ (__vnorm_inv * idt(((- __Tnorm) * __fk2), __Qp2_0));
        V(RES3) <+ ((__vnorm_inv * I(RES3)) * __r_nqs);
        V(SPLINE3) <+ (__vnorm_inv * idt(((- __Tnorm) * __fk3), __Qp3_0));
        V(RES4) <+ ((__vnorm_inv * I(RES4)) * __r_nqs);
        V(SPLINE4) <+ (__vnorm_inv * idt(((- __Tnorm) * __fk4), __Qp4_0));
        V(RES5) <+ ((__vnorm_inv * I(RES5)) * __r_nqs);
        V(SPLINE5) <+ (__vnorm_inv * idt(((- __Tnorm) * __fk5), __Qp5_0));
        V(RES6) <+ ((__vnorm_inv * I(RES6)) * __r_nqs);
        V(SPLINE6) <+ (__vnorm_inv * idt(((- __Tnorm) * __fk6), __Qp6_0));
        V(RES7) <+ ((__vnorm_inv * I(RES7)) * __r_nqs);
        V(SPLINE7) <+ (__vnorm_inv * idt(((- __Tnorm) * __fk7), __Qp7_0));
        V(RES8) <+ ((__vnorm_inv * I(RES8)) * __r_nqs);
        V(SPLINE8) <+ (__vnorm_inv * idt(((- __Tnorm) * __fk8), __Qp8_0));
        V(RES9) <+ ((__vnorm_inv * I(RES9)) * __r_nqs);
        V(SPLINE9) <+ (__vnorm_inv * idt(((- __Tnorm) * __fk9), __Qp9_0));
      end
      begin : loadDynamic
        real temp;
        __Qs = (- ((__Qg + __Qb) + __Qd));
        __Qfgs = (__Qfgs + __Qgs_ov);
        __Qfgd = (__Qfgd + __Qgd_ov);
        qjun_s = (((__ABSOURCE_i * qjunbot_s) + (__LSSOURCE_i * qjunsti_s)) + (__LGSOURCE_i * qjungat_s));
        qjun_d = (((__ABDRAIN_i * qjunbot_d) + (__LSDRAIN_i * qjunsti_d)) + (__LGDRAIN_i * qjungat_d));
        if ((sigVds <  0.0)) begin
          temp = __Qd;
          __Qd = __Qs;
          __Qs = temp;
        end
        I(GP, SI) <+ ddt(((__CHNL_TYPE * __MULT_i) * __Qg));
        I(BP, SI) <+ ddt(((__CHNL_TYPE * __MULT_i) * __Qb));
        I(DI, SI) <+ ddt(((__CHNL_TYPE * __MULT_i) * __Qd));
        I(GP, SI) <+ ddt(((__CHNL_TYPE * __MULT_i) * __Qfgs));
        I(GP, DI) <+ ddt(((__CHNL_TYPE * __MULT_i) * __Qfgd));
        I(GP, BP) <+ ddt(((__CHNL_TYPE * __MULT_i) * __Qgb_ov));
        I(BS, SI) <+ ddt(((__CHNL_TYPE * __MULT_i) * qjun_s));
        I(BD, DI) <+ ddt(((__CHNL_TYPE * __MULT_i) * qjun_d));
      end
      begin : noise
        __Sfl =  0.0;
        __Sidexc =  0.0;
        __mid =  0.0;
        __mig =  100.0e-42;
        __migid =  0.0;
        __c_igid =  0.0;
        __CGeff = (COX_qm * eta_p_ac);
        __sqid =  0.0;
        __sqig =  0.0;
        Sfledge =  0.0;
        midedge =  0.0;
        sqidedge =  0.0;
        if ((((xg_dc >  0.0) && (__MULT_i >  0.0)) && (__BET_i >  0.0))) begin
          __N1 = ((__Cox_over_q * alpha_dc) * __phit);
          __Nm1 = (__Cox_over_q * qim1_dc);
          __Delta_N1 = ((__Cox_over_q * alpha_dc) * dps_dc);
          __Sfl = (((__NFA_i - (__NFB_i * __N1)) + (__NFC_i * (__N1 * __N1))) * ln(((__Nm1 + (__Delta_N1 *  0.5)) / (__Nm1 - (__Delta_N1 *  0.5)))));
          __Sfl = (__Sfl + ((__NFB_i + (__NFC_i * (__Nm1 - (__N1 *  2.0)))) * __Delta_N1));
          __Sfl = ((((__Sfl_prefac * Ids) * Gvsatinv_dc) * __Sfl) / __N1);
          __Sfl = (((__Sfl >  0.0))? (__Sfl):( 0.0));
          H0 = (qim1_dc / alpha_dc);
          __t1 = (qim_dc / qim1_dc);
          __sqt2 = ((dps_dc / H0) *  0.0833333333333333);
          __t2 = (__sqt2 * __sqt2);
          __r = ((H0 / H_dc) -  1.0);
          __lc = (((( 1.0 - ((__r * __t2) *  12.0)) >  10.0e-21))? (( 1.0 - ((__r * __t2) *  12.0))):( 10.0e-21));
          __lcinv2 = ( 1.0 / (__lc * __lc));
          __g_ideal = (__BET_i * ((FdL_dc * qim1_dc) * Gvsatinv_dc));
          __mid = ((__t1 + (__t2 *  12.0)) - ((((__t1 +  1.0) * __t2) * __r) *  24.0));
          __mid = (((__mid >  100.0e-42))? (__mid):( 100.0e-42));
          __mid = ((__g_ideal * __lcinv2) * __mid);
          if ((__FNTEXC_i >  0.0)) begin
            __temp2_exc = (qim_dc * xitsb_dc);
            __wsat_exc = ((__temp2_exc / (__temp2_exc +  100.0)) *  100.0);
            if ((__THESATG_i < 0)) begin
              __temp_exc = ( 1.0 / ( 1.0 - (__THESATG_i * __wsat_exc)));
            end
            else begin
              __temp_exc = ((__THESATG_i * __wsat_exc) +  1.0);
            end
            __thesat1_exc = (__THESAT_T * (__temp_exc / Gmob_dc));
            __zsat_exc = (((__thesat1_exc * __thesat1_exc) * dps_dc) * dps_dc);
            if ((__CHNL_TYPE == -1)) begin
              __zsat_exc = (__zsat_exc / ((__thesat1_exc * dps_dc) +  1.0));
            end
            __Gvsat_exc = ((Gmob_dc * (sqrt(((__zsat_exc *  2.0) +  1.0)) +  1.0)) *  0.5);
            __gfac = (Gmob_dc / (__Gvsat_exc * __lc));
            __Sidexc = ((((__fac_exc * Ids) * Vdse_dc) * __gfac) * __gfac);
            __mid = (__mid + (__Sidexc / __nt0));
          end
          __sqid = sqrt((__nt * __mid));
          if ((1 && (__nt >  0.0))) begin
            __mig = (((__t1 /  12.0) - (__t2 * ((__t1 +  0.2) - (__t2 *  12.0)))) - (((__t2 * ((__t1 +  1.0) - (__t2 *  12.0))) * __r) *  1.6));
            __mig = (((__mig >  100.0e-42))? (__mig):( 100.0e-42));
            __mig = ((__lcinv2 / __g_ideal) * __mig);
            __migid0 = ((__lcinv2 * __sqt2) * (( 1.0 - (__t2 *  12.0)) - (((__t1 + (__t2 *  19.2)) - ((__t1 * __t2) *  12.0)) * __r)));
            __CGeff = ((((Gvsat_ac * Gvsat_ac) * COX_qm) * eta_p_ac) / (Gmob_dL_ac * Gmob_dL_ac));
            if ((__FNTEXC_i >  0.0)) begin
              __mig = (__mig + ((__Sidexc * ((__t2 *  12.0) +  1.0)) / (((__g_ideal *  12.0) * __g_ideal) * __nt0)));
              __migid0 = (__migid0 - (((__Sidexc * __sqt2) * (__r +  1.0)) / (__g_ideal * __nt0)));
            end
            __sqig = sqrt((__nt / __mig));
            if ((__sqid <= 0)) begin
              __c_igid =  0.0;
            end
            else begin
              __c_igid = ((__migid0 * __sqig) / __sqid);
            end
            __c_igid = (((__c_igid >  0.0))? ((((__c_igid <  1.0))? (__c_igid):( 1.0))):( 0.0));
            __migid = ((__c_igid * __sqid) / __sqig);
          end
        end
        __shot_igcsx = (abs(Igcs) *  320.43836e-21);
        __shot_igcdx = (abs(Igcd) *  320.43836e-21);
        __shot_igsov = (abs(Igsov) *  320.43836e-21);
        __shot_igdov = (abs(Igdov) *  320.43836e-21);
        __shot_iavl = (((mavl + 1) * abs(Iimpact)) *  320.43836e-21);
        __jnoisex_s = (abs(ijun_s) *  320.43836e-21);
        __jnoisex_d = (abs(ijun_d) *  320.43836e-21);
        if ((sigVds >  0.0)) begin
          __shot_igs = (__shot_igcsx + __shot_igsov);
          __shot_igd = (__shot_igcdx + __shot_igdov);
          jnoise_s = __jnoisex_s;
          jnoise_d = (__jnoisex_d + __shot_iavl);
        end
        else begin
          __shot_igs = (__shot_igcdx + __shot_igsov);
          __shot_igd = (__shot_igcsx + __shot_igdov);
          jnoise_s = (__jnoisex_s + __shot_iavl);
          jnoise_d = __jnoisex_d;
        end
        if (0) begin
          if ((temp1 >  100.0e-12)) begin
          end
        end
        I(NOII) <+ white_noise((__nt / __mig), "igig");
        I(NOIR) <+ (V(NOIR) / __mig);
        I(NOIC) <+ ddt((__CGeff * V(NOIC)));
        I(GP, SI) <+ (- ddt((((sqrt(__MULT_i) *  0.5) * __CGeff) * V(NOIC))));
        I(GP, DI) <+ (- ddt((((sqrt(__MULT_i) *  0.5) * __CGeff) * V(NOIC))));
        I(DI, SI) <+ (((sigVds * sqrt(__MULT_i)) * __migid) * I(NOII));
        I(DI, SI) <+ white_noise((((__MULT_i * __sqid) * __sqid) * ( 1.0 - (__c_igid * __c_igid))), "idid");
        I(DI, SI) <+ flicker_noise(((sigVds * __MULT_i) * __Sfl), __EF_i, "flicker");
        I(GP, SI) <+ white_noise((__MULT_i * __shot_igs), "igs");
        I(GP, DI) <+ white_noise((__MULT_i * __shot_igd), "igd");
        I(BS, SI) <+ white_noise((__MULT_i * jnoise_s), "ibs");
        I(BD, DI) <+ white_noise((__MULT_i * jnoise_d), "ibd");
        I(DI, SI) <+ flicker_noise(((sigVds * __MULT_i) * Sfledge), __EFEDGE_i, "flicker");
        I(DI, SI) <+ white_noise(((__MULT_i * sqidedge) * sqidedge), "ididedge");
      end
      begin : OPinfo
        __id_op = (((Ids + Idsedge) + Iimpact) - Igcd);
        __is = (((- Ids) - Idsedge) - Igcs);
        __ig = ((((Igcs + Igcd) + Igsov) + Igdov) + __Igb);
        __ib = ((((- Iimpact) - __Igb) - __Igidl) - __Igisl);
        __sig1k = (__CGeff *  6.28318530717959e+3);
        __sig1k = ((__sig1k * __sig1k) * __mig);
        __sdint = sigVds;
        __ctype = __CHNL_TYPE;
        if ((sigVds <  0.0)) begin
          __ise = (__MULT_i * (((__is - Igdov) + __Igidl) - ijun_d));
          __ige = (__MULT_i * __ig);
          __ide = (__MULT_i * (((__id_op - Igsov) + __Igisl) - ijun_s));
          __ibe = (__MULT_i * ((__ib + ijun_s) + ijun_d));
          __ids = (__MULT_i * Ids);
          __idb = (__MULT_i * ((Iimpact + __Igisl) - ijun_s));
          __isb = (__MULT_i * (__Igidl - ijun_d));
          __igs = (__MULT_i * (Igcs + Igdov));
          __igd = (__MULT_i * (Igcd + Igsov));
          __igb = (__MULT_i * __Igb);
          __idedge = (__MULT_i * Idsedge);
          __igcs = (__MULT_i * Igcs);
          __igcd = (__MULT_i * Igcd);
          __iavl = (__MULT_i * Iimpact);
          __igisl = (__MULT_i * __Igidl);
          __igidl = (__MULT_i * __Igisl);
          if ((__SWJUNEXP_i == 1)) begin
            __ijsbot =  0.0;
            __ijsgat =  0.0;
            __ijssti =  0.0;
            __ijdbot =  0.0;
            __ijdgat =  0.0;
            __ijdsti =  0.0;
            __idsatsbot =  0.0;
            __idsatssti =  0.0;
            __idsatsgat =  0.0;
            __idsatsbotd =  0.0;
            __idsatsstid =  0.0;
            __idsatsgatd =  0.0;
          end
          else begin
            __ijsbot = ((__MULT_i * __ABDRAIN_i) * ijunbot_d);
            __ijsgat = ((__MULT_i * __LGDRAIN_i) * ijungat_d);
            __ijssti = ((__MULT_i * __LSDRAIN_i) * ijunsti_d);
            __ijdbot = ((__MULT_i * __ABSOURCE_i) * ijunbot_s);
            __ijdgat = ((__MULT_i * __LGSOURCE_i) * ijungat_s);
            __ijdsti = ((__MULT_i * __LSSOURCE_i) * ijunsti_s);
            __idsatsbot = ((__MULT_i * __ABSOURCE_i) * __idsatbot);
            __idsatssti = ((__MULT_i * __LSSOURCE_i) * __idsatsti);
            __idsatsgat = ((__MULT_i * __LGSOURCE_i) * __idsatgat);
            __idsatsbotd = ((__MULT_i * __ABDRAIN_i) * __idsatbot_d);
            __idsatsstid = ((__MULT_i * __LSDRAIN_i) * __idsatsti_d);
            __idsatsgatd = ((__MULT_i * __LGDRAIN_i) * __idsatgat_d);
          end
          __ijs = (__MULT_i * ijun_d);
          __ijd = (__MULT_i * ijun_s);
          __vds = __Vds;
          __vgs = __Vgs;
          __vsb = __Vsb;
          __vto = ((__VFB_T + (__P_D * __facvsb0)) + (__Gf_dc * sqrt((phit1 * __facvsb0))));
          __vts = __vts_i;
          __vth = __vth_i;
          __vgt = (__vgs - __vth);
          __vdss = __Vdsat_dc;
          __vsat = (__Vds - __vdss);
          __ids_i = ((((((Ids + Idsedge) + Iimpact) + __Igisl) - Igcs) - Igsov) - ijun_s);
          __gm = ((__CHNL_TYPE * __MULT_i) * ddx(__ids_i, V(GP)));
          __gmb = ((__CHNL_TYPE * __MULT_i) * ddx(__ids_i, V(BP)));
          __gds = ((__CHNL_TYPE * __MULT_i) * ddx(__ids_i, V(SI)));
          __gjs = (__MULT_i * ddx(ijun_d, V(BD)));
          __gjd = (__MULT_i * ddx(ijun_s, V(BS)));
          __css = ((__CHNL_TYPE * __MULT_i) * ddx(__Qd, V(DI)));
          __csg = (((- __CHNL_TYPE) * __MULT_i) * ddx(__Qd, V(GP)));
          __csb = (((- __CHNL_TYPE) * __MULT_i) * ddx(__Qd, V(BP)));
          __csd = ((__css - __csg) - __csb);
          __cgs = (((- __CHNL_TYPE) * __MULT_i) * ddx(__Qg, V(DI)));
          __cgg = ((__CHNL_TYPE * __MULT_i) * ddx(__Qg, V(GP)));
          __cgb = (((- __CHNL_TYPE) * __MULT_i) * ddx(__Qg, V(BP)));
          __cgd = ((__cgg - __cgs) - __cgb);
          __cds = (((- __CHNL_TYPE) * __MULT_i) * ddx(__Qs, V(DI)));
          __cdg = (((- __CHNL_TYPE) * __MULT_i) * ddx(__Qs, V(GP)));
          __cdb = (((- __CHNL_TYPE) * __MULT_i) * ddx(__Qs, V(BP)));
          __cdd = ((__cdg + __cds) + __cdb);
          __cbs = (((- __CHNL_TYPE) * __MULT_i) * ddx(__Qb, V(DI)));
          __cbg = (((- __CHNL_TYPE) * __MULT_i) * ddx(__Qb, V(GP)));
          __cbb = ((__CHNL_TYPE * __MULT_i) * ddx(__Qb, V(BP)));
          __cbd = ((__cbb - __cbs) - __cbg);
          __cgsol = ((__CHNL_TYPE * __MULT_i) * ddx(__Qfgd, V(GP)));
          __cgdol = ((__CHNL_TYPE * __MULT_i) * ddx(__Qfgs, V(GP)));
          __cjsbot = ((((- __MULT_i) * __CHNL_TYPE) * __ABDRAIN_i) * ddx(qjunbot_d, V(DI)));
          __cjsgat = ((((- __MULT_i) * __CHNL_TYPE) * __LGDRAIN_i) * ddx(qjungat_d, V(DI)));
          __cjssti = ((((- __MULT_i) * __CHNL_TYPE) * __LSDRAIN_i) * ddx(qjunsti_d, V(DI)));
          __cjs = ((__cjsbot + __cjsgat) + __cjssti);
          __cjdbot = ((((- __MULT_i) * __CHNL_TYPE) * __ABSOURCE_i) * ddx(qjunbot_s, V(SI)));
          __cjdgat = ((((- __MULT_i) * __CHNL_TYPE) * __LGSOURCE_i) * ddx(qjungat_s, V(SI)));
          __cjdsti = ((((- __MULT_i) * __CHNL_TYPE) * __LSSOURCE_i) * ddx(qjunsti_s, V(SI)));
          __cjd = ((__cjdbot + __cjdgat) + __cjdsti);
        end
        else begin
          __ise = (__MULT_i * (((__is - Igsov) + __Igisl) - ijun_s));
          __ige = (__MULT_i * __ig);
          __ide = (__MULT_i * (((__id_op - Igdov) + __Igidl) - ijun_d));
          __ibe = (__MULT_i * ((__ib + ijun_s) + ijun_d));
          __ids = (__MULT_i * Ids);
          __idb = (__MULT_i * ((Iimpact + __Igidl) - ijun_d));
          __isb = (__MULT_i * (__Igisl - ijun_s));
          __igs = (__MULT_i * (Igcs + Igsov));
          __igd = (__MULT_i * (Igcd + Igdov));
          __igb = (__MULT_i * __Igb);
          __idedge = (__MULT_i * Idsedge);
          __igcs = (__MULT_i * Igcs);
          __igcd = (__MULT_i * Igcd);
          __iavl = (__MULT_i * Iimpact);
          __igisl = (__MULT_i * __Igisl);
          __igidl = (__MULT_i * __Igidl);
          if ((__SWJUNEXP_i == 1)) begin
            __ijsbot =  0.0;
            __ijsgat =  0.0;
            __ijssti =  0.0;
            __ijdbot =  0.0;
            __ijdgat =  0.0;
            __ijdsti =  0.0;
            __idsatsbot =  0.0;
            __idsatssti =  0.0;
            __idsatsgat =  0.0;
            __idsatsbotd =  0.0;
            __idsatsstid =  0.0;
            __idsatsgatd =  0.0;
          end
          else begin
            __ijsbot = ((__MULT_i * __ABSOURCE_i) * ijunbot_s);
            __ijsgat = ((__MULT_i * __LGSOURCE_i) * ijungat_s);
            __ijssti = ((__MULT_i * __LSSOURCE_i) * ijunsti_s);
            __ijdbot = ((__MULT_i * __ABDRAIN_i) * ijunbot_d);
            __ijdgat = ((__MULT_i * __LGDRAIN_i) * ijungat_d);
            __ijdsti = ((__MULT_i * __LSDRAIN_i) * ijunsti_d);
            __idsatsbot = ((__MULT_i * __ABSOURCE_i) * __idsatbot);
            __idsatssti = ((__MULT_i * __LSSOURCE_i) * __idsatsti);
            __idsatsgat = ((__MULT_i * __LGSOURCE_i) * __idsatgat);
            __idsatsbotd = ((__MULT_i * __ABDRAIN_i) * __idsatbot_d);
            __idsatsstid = ((__MULT_i * __LSDRAIN_i) * __idsatsti_d);
            __idsatsgatd = ((__MULT_i * __LGDRAIN_i) * __idsatgat_d);
          end
          __ijs = (__MULT_i * ijun_s);
          __ijd = (__MULT_i * ijun_d);
          __vds = __Vds;
          __vgs = __Vgs;
          __vsb = __Vsb;
          __vto = ((__VFB_T + (__P_D * __facvsb0)) + (__Gf_dc * sqrt((phit1 * __facvsb0))));
          __vts = __vts_i;
          __vth = __vth_i;
          __vgt = (__vgs - __vth);
          __vdss = __Vdsat_dc;
          __vsat = (__Vds - __vdss);
          __ids_i = ((((((Ids + Idsedge) + Iimpact) + __Igidl) - Igcd) - Igdov) - ijun_d);
          __gm = ((__CHNL_TYPE * __MULT_i) * ddx(__ids_i, V(GP)));
          __gmb = ((__CHNL_TYPE * __MULT_i) * ddx(__ids_i, V(BP)));
          __gds = ((__CHNL_TYPE * __MULT_i) * ddx(__ids_i, V(DI)));
          __gjs = ((- __MULT_i) * ddx(ijun_s, V(SI)));
          __gjd = ((- __MULT_i) * ddx(ijun_d, V(DI)));
          __cdd = ((__CHNL_TYPE * __MULT_i) * ddx(__Qd, V(DI)));
          __cdg = (((- __CHNL_TYPE) * __MULT_i) * ddx(__Qd, V(GP)));
          __cdb = (((- __CHNL_TYPE) * __MULT_i) * ddx(__Qd, V(BP)));
          __cds = ((__cdd - __cdg) - __cdb);
          __cgd = (((- __CHNL_TYPE) * __MULT_i) * ddx(__Qg, V(DI)));
          __cgg = ((__CHNL_TYPE * __MULT_i) * ddx(__Qg, V(GP)));
          __cgb = (((- __CHNL_TYPE) * __MULT_i) * ddx(__Qg, V(BP)));
          __cgs = ((__cgg - __cgd) - __cgb);
          __csd = (((- __CHNL_TYPE) * __MULT_i) * ddx(__Qs, V(DI)));
          __csg = (((- __CHNL_TYPE) * __MULT_i) * ddx(__Qs, V(GP)));
          __csb = (((- __CHNL_TYPE) * __MULT_i) * ddx(__Qs, V(BP)));
          __css = ((__csg + __csd) + __csb);
          __cbd = (((- __CHNL_TYPE) * __MULT_i) * ddx(__Qb, V(DI)));
          __cbg = (((- __CHNL_TYPE) * __MULT_i) * ddx(__Qb, V(GP)));
          __cbb = ((__CHNL_TYPE * __MULT_i) * ddx(__Qb, V(BP)));
          __cbs = ((__cbb - __cbd) - __cbg);
          __cgsol = ((__CHNL_TYPE * __MULT_i) * ddx(__Qfgs, V(GP)));
          __cgdol = ((__CHNL_TYPE * __MULT_i) * ddx(__Qfgd, V(GP)));
          __cjsbot = ((((- __MULT_i) * __CHNL_TYPE) * __ABSOURCE_i) * ddx(qjunbot_s, V(SI)));
          __cjsgat = ((((- __MULT_i) * __CHNL_TYPE) * __LGSOURCE_i) * ddx(qjungat_s, V(SI)));
          __cjssti = ((((- __MULT_i) * __CHNL_TYPE) * __LSSOURCE_i) * ddx(qjunsti_s, V(SI)));
          __cjs = ((__cjsbot + __cjsgat) + __cjssti);
          __cjdbot = ((((- __MULT_i) * __CHNL_TYPE) * __ABDRAIN_i) * ddx(qjunbot_d, V(DI)));
          __cjdgat = ((((- __MULT_i) * __CHNL_TYPE) * __LGDRAIN_i) * ddx(qjungat_d, V(DI)));
          __cjdsti = ((((- __MULT_i) * __CHNL_TYPE) * __LSDRAIN_i) * ddx(qjunsti_d, V(DI)));
          __cjd = ((__cjdbot + __cjdgat) + __cjdsti);
        end
        __weff = __WE;
        __leff = __LE;
        if ((abs(__gds) <  1.0e-18)) begin
          __u =  0.0;
          __rout =  0.0;
          __vearly =  0.0;
        end
        else begin
          __u = (__gm / __gds);
          __rout = ( 1.0 / __gds);
          __vearly = (__ide / __gds);
        end
        if ((abs(__vgt) <  1.0e-12)) begin
          __beff =  0.0;
        end
        else begin
          __beff = ((abs(__ide) *  2.0) / (__vgt * __vgt));
        end
        if ((abs(((__cgg + __cgsol) + __cgdol)) <  1.0e-30)) begin
          __fug =  0.0;
        end
        else begin
          __fug = (__gm / (((__cgg + __cgsol) + __cgdol) *  6.28318530717959));
        end
        __rg = (__RG_i / __MULT_i);
        __sfl = (__MULT_i * __Sfl);
        if ((abs(__gm) <  1.0e-18)) begin
          __sqrtsff =  0.0;
          __sqrtsfw =  0.0;
        end
        else begin
          __sqrtsff = (sqrt((((__MULT_i * __Sfl) /  1.0e+3) / $mfactor)) / __gm);
          __sqrtsfw = ((sqrt((__MULT_i / $mfactor)) * __sqid) / __gm);
        end
        __sid = ((__MULT_i * __sqid) * __sqid);
        __sig = (((__MULT_i * __nt) * __sig1k) / ((__sig1k * __mig) +  1.0));
        __cigid = __c_igid;
        if ((__sid <=  0.0)) begin
          __fknee =  0.0;
        end
        else begin
          __fknee = (__sfl / __sid);
        end
        __siavl = (__MULT_i * __shot_iavl);
        if ((sigVds <  0.0)) begin
          __sigs = (__MULT_i * (__shot_igcsx + __shot_igdov));
          __sigd = (__MULT_i * (__shot_igcdx + __shot_igsov));
          __ssi = (__MULT_i * __jnoisex_d);
          __sdi = (__MULT_i * __jnoisex_s);
        end
        else begin
          __sigs = (__MULT_i * (__shot_igcsx + __shot_igsov));
          __sigd = (__MULT_i * (__shot_igcdx + __shot_igdov));
          __ssi = (__MULT_i * __jnoisex_s);
          __sdi = (__MULT_i * __jnoisex_d);
        end
        __sfledge = (__MULT_i * Sfledge);
        __sidedge = (__MULT_i * sqidedge);
        __lp_vfb = __VFB_T;
        __lp_stvfb = __STVFB_i;
        __lp_st2vfb = __ST2VFB_i;
        __lp_tox = __TOX_i;
        __lp_epsrox = __EPSROX_i;
        __lp_neff = __NEFF_i;
        __lp_facneffac = __FACNEFFAC_i;
        __lp_gfacnud = __GFACNUD_i;
        __lp_vsbnud = __VSBNUD_i;
        __lp_dvsbnud = __DVSBNUD_i;
        __lp_vnsub = __VNSUB_i;
        __lp_nslp = __NSLP_i;
        __lp_dnsub = __DNSUB_i;
        __lp_dphib = __DPHIB_i;
        __lp_delvtac = __DELVTAC_i;
        __lp_np = __NP_i;
        __lp_toxov = __TOXOV_i;
        __lp_toxovd = __TOXOVD_i;
        __lp_nov = __NOV_i;
        __lp_novd = __NOVD_i;
        __lp_ct = __CT_T;
        __lp_ctg = __CTG_T;
        __lp_ctb = __CTB_i;
        __lp_stct = __STCT_i;
        __lp_cf = __CF_i;
        __lp_cfac = __CFAC_i;
        __lp_cfd = __CFD_i;
        __lp_cfb = __CFB_i;
        __lp_psce = __PSCE_i;
        __lp_psceb = __PSCEB_i;
        __lp_psced = __PSCED_i;
        __lp_betn = __BETN_T;
        __lp_stbet = __STBET_i;
        __lp_mue = __MUE_T;
        __lp_stmue = __STMUE_i;
        __lp_themu = __THEMU_T;
        __lp_stthemu = __STTHEMU_i;
        __lp_cs = __CS_T;
        __lp_stcs = __STCS_i;
        __lp_thecs = __THECS_T;
        __lp_stthecs = __STTHECS_i;
        __lp_xcor = __XCOR_T;
        __lp_stxcor = __STXCOR_i;
        __lp_feta = __FETA_i;
        __lp_rs = __RS_T;
        __lp_strs = __STRS_i;
        __lp_rsb = __RSB_i;
        __lp_rsg = __RSG_i;
        __lp_thesat = __THESAT_T;
        __lp_thesatac = __THESATAC_T;
        __lp_stthesat = __STTHESAT_i;
        __lp_thesatb = __THESATB_i;
        __lp_thesatg = __THESATG_i;
        __lp_ax = __AX_i;
        __lp_axac = __AXAC_i;
        __lp_alp = __ALP_i;
        __lp_alpac = __ALPAC_i;
        __lp_alp1 = __ALP1_i;
        __lp_alp2 = __ALP2_i;
        __lp_vp = __VP_i;
        __lp_a1 = __A1_i;
        __lp_a2 = __A2_T;
        __lp_sta2 = __STA2_i;
        __lp_a3 = __A3_i;
        __lp_a4 = __A4_i;
        __lp_gco = __GCO_i;
        __lp_iginv = __IGINV_i;
        __lp_igov = __IGOV_i;
        __lp_igovd = __IGOVD_i;
        __lp_stig = __STIG_i;
        __lp_gc2 = __GC2_i;
        __lp_gc3 = __GC3_i;
        __lp_gc2ov = __GC2OV_i;
        __lp_gc3ov = __GC3OV_i;
        __lp_chib = __CHIB_i;
        __lp_agidl = __AGIDL_i;
        __lp_agidld = __AGIDLD_i;
        __lp_bgidl = __BGIDL_T;
        __lp_bgidld = __BGIDLD_T;
        __lp_stbgidl = __STBGIDL_i;
        __lp_stbgidld = __STBGIDLD_i;
        __lp_cgidl = __CGIDL_i;
        __lp_cgidld = __CGIDLD_i;
        __lp_cox = __COX_i;
        __lp_cgov = __CGOV_i;
        __lp_cgovd = __CGOVD_i;
        __lp_fcgovacc = __FCGOVACC_i;
        __lp_fcgovaccd = __FCGOVACCD_i;
        __lp_cgovaccg = __CGOVACCG_i;
        __lp_cgbov = __CGBOV_i;
        __lp_cinr = __CINR_i;
        __lp_cinrd = __CINRD_i;
        __lp_dvfbinr = __DVFBINR_i;
        __lp_fcinrdep = __FCINRDEP_i;
        __lp_fcinracc = __FCINRACC_i;
        __lp_axinr = __AXINR_i;
        __lp_cfr = __CFR_i;
        __lp_cfrd = __CFRD_i;
        __lp_fnt = __FNT_i;
        __lp_fntexc = __FNTEXC_i;
        __lp_nfa = __NFA_i;
        __lp_nfb = __NFB_i;
        __lp_nfc = __NFC_i;
        __lp_ef = __EF_i;
        __lp_vfbedge = __VFBEDGE_T;
        __lp_stvfbedge = __STVFBEDGE_i;
        __lp_dphibedge = __DPHIBEDGE_i;
        __lp_neffedge = __NEFFEDGE_i;
        __lp_ctedge = __CTEDGE_i;
        __lp_betnedge = __BETNEDGE_T;
        __lp_stbetedge = __STBETEDGE_i;
        __lp_psceedge = __PSCEEDGE_i;
        __lp_pscebedge = __PSCEBEDGE_i;
        __lp_pscededge = __PSCEDEDGE_i;
        __lp_cfedge = __CFEDGE_i;
        __lp_cfdedge = __CFDEDGE_i;
        __lp_cfbedge = __CFBEDGE_i;
        __lp_fntedge = __FNTEDGE_i;
        __lp_nfaedge = __NFAEDGE_i;
        __lp_nfbedge = __NFBEDGE_i;
        __lp_nfcedge = __NFCEDGE_i;
        __lp_efedge = __EFEDGE_i;
        __lp_rg = __RG_i;
        __lp_rse = __RSE_i;
        __lp_rde = __RDE_i;
        __lp_rbulk = __RBULK_i;
        __lp_rwell = __RWELL_i;
        __lp_rjuns = __RJUNS_i;
        __lp_rjund = __RJUND_i;
        __tk = __TKD;
        __cjosbot = ((__MULT_i * __ABSOURCE_i) * __cjobot);
        __cjossti = ((__MULT_i * __LSSOURCE_i) * __cjosti);
        __cjosgat = ((__MULT_i * __LGSOURCE_i) * __cjogat);
        __vbisbot = __vbibot;
        __vbissti = __vbisti;
        __vbisgat = __vbigat;
        __cjosbotd = ((__MULT_i * __ABDRAIN_i) * __cjobot_d);
        __cjosstid = ((__MULT_i * __LSDRAIN_i) * __cjosti_d);
        __cjosgatd = ((__MULT_i * __LGDRAIN_i) * __cjogat_d);
        __vbisbotd = __vbibot_d;
        __vbisstid = __vbisti_d;
        __vbisgatd = __vbigat_d;
        __lp_munqs = __MUNQS_i;
      end
    end
  end

endmodule
