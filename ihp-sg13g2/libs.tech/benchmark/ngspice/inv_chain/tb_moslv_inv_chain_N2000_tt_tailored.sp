* CMOS inverter chain

.model sg13_lv_nmos sg13g2_lv_nmos_psp_model
.model sg13_lv_pmos sg13g2_lv_pmos_psp_model

.options noacct
.options nomod
.options nopage
.options klu
.options reltol=1e-4

VDD vdd 0 1.2
VIN in 0 PWL(0 0 10n 0 11n 1.2 100.0n 1.2)

* Inverter subcircuit
.subckt inv in out vdd gnd
N1 out in vdd vdd sg13_lv_pmos
N2 out in gnd gnd sg13_lv_nmos
.ends

* Inverter instances
X1 in n1 vdd 0 inv
X2 n1 n2 vdd 0 inv
X3 n2 n3 vdd 0 inv
X4 n3 n4 vdd 0 inv
X5 n4 n5 vdd 0 inv
X6 n5 n6 vdd 0 inv
X7 n6 n7 vdd 0 inv
X8 n7 n8 vdd 0 inv
X9 n8 n9 vdd 0 inv
X10 n9 n10 vdd 0 inv
X11 n10 n11 vdd 0 inv
X12 n11 n12 vdd 0 inv
X13 n12 n13 vdd 0 inv
X14 n13 n14 vdd 0 inv
X15 n14 n15 vdd 0 inv
X16 n15 n16 vdd 0 inv
X17 n16 n17 vdd 0 inv
X18 n17 n18 vdd 0 inv
X19 n18 n19 vdd 0 inv
X20 n19 n20 vdd 0 inv
X21 n20 n21 vdd 0 inv
X22 n21 n22 vdd 0 inv
X23 n22 n23 vdd 0 inv
X24 n23 n24 vdd 0 inv
X25 n24 n25 vdd 0 inv
X26 n25 n26 vdd 0 inv
X27 n26 n27 vdd 0 inv
X28 n27 n28 vdd 0 inv
X29 n28 n29 vdd 0 inv
X30 n29 n30 vdd 0 inv
X31 n30 n31 vdd 0 inv
X32 n31 n32 vdd 0 inv
X33 n32 n33 vdd 0 inv
X34 n33 n34 vdd 0 inv
X35 n34 n35 vdd 0 inv
X36 n35 n36 vdd 0 inv
X37 n36 n37 vdd 0 inv
X38 n37 n38 vdd 0 inv
X39 n38 n39 vdd 0 inv
X40 n39 n40 vdd 0 inv
X41 n40 n41 vdd 0 inv
X42 n41 n42 vdd 0 inv
X43 n42 n43 vdd 0 inv
X44 n43 n44 vdd 0 inv
X45 n44 n45 vdd 0 inv
X46 n45 n46 vdd 0 inv
X47 n46 n47 vdd 0 inv
X48 n47 n48 vdd 0 inv
X49 n48 n49 vdd 0 inv
X50 n49 n50 vdd 0 inv
X51 n50 n51 vdd 0 inv
X52 n51 n52 vdd 0 inv
X53 n52 n53 vdd 0 inv
X54 n53 n54 vdd 0 inv
X55 n54 n55 vdd 0 inv
X56 n55 n56 vdd 0 inv
X57 n56 n57 vdd 0 inv
X58 n57 n58 vdd 0 inv
X59 n58 n59 vdd 0 inv
X60 n59 n60 vdd 0 inv
X61 n60 n61 vdd 0 inv
X62 n61 n62 vdd 0 inv
X63 n62 n63 vdd 0 inv
X64 n63 n64 vdd 0 inv
X65 n64 n65 vdd 0 inv
X66 n65 n66 vdd 0 inv
X67 n66 n67 vdd 0 inv
X68 n67 n68 vdd 0 inv
X69 n68 n69 vdd 0 inv
X70 n69 n70 vdd 0 inv
X71 n70 n71 vdd 0 inv
X72 n71 n72 vdd 0 inv
X73 n72 n73 vdd 0 inv
X74 n73 n74 vdd 0 inv
X75 n74 n75 vdd 0 inv
X76 n75 n76 vdd 0 inv
X77 n76 n77 vdd 0 inv
X78 n77 n78 vdd 0 inv
X79 n78 n79 vdd 0 inv
X80 n79 n80 vdd 0 inv
X81 n80 n81 vdd 0 inv
X82 n81 n82 vdd 0 inv
X83 n82 n83 vdd 0 inv
X84 n83 n84 vdd 0 inv
X85 n84 n85 vdd 0 inv
X86 n85 n86 vdd 0 inv
X87 n86 n87 vdd 0 inv
X88 n87 n88 vdd 0 inv
X89 n88 n89 vdd 0 inv
X90 n89 n90 vdd 0 inv
X91 n90 n91 vdd 0 inv
X92 n91 n92 vdd 0 inv
X93 n92 n93 vdd 0 inv
X94 n93 n94 vdd 0 inv
X95 n94 n95 vdd 0 inv
X96 n95 n96 vdd 0 inv
X97 n96 n97 vdd 0 inv
X98 n97 n98 vdd 0 inv
X99 n98 n99 vdd 0 inv
X100 n99 n100 vdd 0 inv
X101 n100 n101 vdd 0 inv
X102 n101 n102 vdd 0 inv
X103 n102 n103 vdd 0 inv
X104 n103 n104 vdd 0 inv
X105 n104 n105 vdd 0 inv
X106 n105 n106 vdd 0 inv
X107 n106 n107 vdd 0 inv
X108 n107 n108 vdd 0 inv
X109 n108 n109 vdd 0 inv
X110 n109 n110 vdd 0 inv
X111 n110 n111 vdd 0 inv
X112 n111 n112 vdd 0 inv
X113 n112 n113 vdd 0 inv
X114 n113 n114 vdd 0 inv
X115 n114 n115 vdd 0 inv
X116 n115 n116 vdd 0 inv
X117 n116 n117 vdd 0 inv
X118 n117 n118 vdd 0 inv
X119 n118 n119 vdd 0 inv
X120 n119 n120 vdd 0 inv
X121 n120 n121 vdd 0 inv
X122 n121 n122 vdd 0 inv
X123 n122 n123 vdd 0 inv
X124 n123 n124 vdd 0 inv
X125 n124 n125 vdd 0 inv
X126 n125 n126 vdd 0 inv
X127 n126 n127 vdd 0 inv
X128 n127 n128 vdd 0 inv
X129 n128 n129 vdd 0 inv
X130 n129 n130 vdd 0 inv
X131 n130 n131 vdd 0 inv
X132 n131 n132 vdd 0 inv
X133 n132 n133 vdd 0 inv
X134 n133 n134 vdd 0 inv
X135 n134 n135 vdd 0 inv
X136 n135 n136 vdd 0 inv
X137 n136 n137 vdd 0 inv
X138 n137 n138 vdd 0 inv
X139 n138 n139 vdd 0 inv
X140 n139 n140 vdd 0 inv
X141 n140 n141 vdd 0 inv
X142 n141 n142 vdd 0 inv
X143 n142 n143 vdd 0 inv
X144 n143 n144 vdd 0 inv
X145 n144 n145 vdd 0 inv
X146 n145 n146 vdd 0 inv
X147 n146 n147 vdd 0 inv
X148 n147 n148 vdd 0 inv
X149 n148 n149 vdd 0 inv
X150 n149 n150 vdd 0 inv
X151 n150 n151 vdd 0 inv
X152 n151 n152 vdd 0 inv
X153 n152 n153 vdd 0 inv
X154 n153 n154 vdd 0 inv
X155 n154 n155 vdd 0 inv
X156 n155 n156 vdd 0 inv
X157 n156 n157 vdd 0 inv
X158 n157 n158 vdd 0 inv
X159 n158 n159 vdd 0 inv
X160 n159 n160 vdd 0 inv
X161 n160 n161 vdd 0 inv
X162 n161 n162 vdd 0 inv
X163 n162 n163 vdd 0 inv
X164 n163 n164 vdd 0 inv
X165 n164 n165 vdd 0 inv
X166 n165 n166 vdd 0 inv
X167 n166 n167 vdd 0 inv
X168 n167 n168 vdd 0 inv
X169 n168 n169 vdd 0 inv
X170 n169 n170 vdd 0 inv
X171 n170 n171 vdd 0 inv
X172 n171 n172 vdd 0 inv
X173 n172 n173 vdd 0 inv
X174 n173 n174 vdd 0 inv
X175 n174 n175 vdd 0 inv
X176 n175 n176 vdd 0 inv
X177 n176 n177 vdd 0 inv
X178 n177 n178 vdd 0 inv
X179 n178 n179 vdd 0 inv
X180 n179 n180 vdd 0 inv
X181 n180 n181 vdd 0 inv
X182 n181 n182 vdd 0 inv
X183 n182 n183 vdd 0 inv
X184 n183 n184 vdd 0 inv
X185 n184 n185 vdd 0 inv
X186 n185 n186 vdd 0 inv
X187 n186 n187 vdd 0 inv
X188 n187 n188 vdd 0 inv
X189 n188 n189 vdd 0 inv
X190 n189 n190 vdd 0 inv
X191 n190 n191 vdd 0 inv
X192 n191 n192 vdd 0 inv
X193 n192 n193 vdd 0 inv
X194 n193 n194 vdd 0 inv
X195 n194 n195 vdd 0 inv
X196 n195 n196 vdd 0 inv
X197 n196 n197 vdd 0 inv
X198 n197 n198 vdd 0 inv
X199 n198 n199 vdd 0 inv
X200 n199 n200 vdd 0 inv
X201 n200 n201 vdd 0 inv
X202 n201 n202 vdd 0 inv
X203 n202 n203 vdd 0 inv
X204 n203 n204 vdd 0 inv
X205 n204 n205 vdd 0 inv
X206 n205 n206 vdd 0 inv
X207 n206 n207 vdd 0 inv
X208 n207 n208 vdd 0 inv
X209 n208 n209 vdd 0 inv
X210 n209 n210 vdd 0 inv
X211 n210 n211 vdd 0 inv
X212 n211 n212 vdd 0 inv
X213 n212 n213 vdd 0 inv
X214 n213 n214 vdd 0 inv
X215 n214 n215 vdd 0 inv
X216 n215 n216 vdd 0 inv
X217 n216 n217 vdd 0 inv
X218 n217 n218 vdd 0 inv
X219 n218 n219 vdd 0 inv
X220 n219 n220 vdd 0 inv
X221 n220 n221 vdd 0 inv
X222 n221 n222 vdd 0 inv
X223 n222 n223 vdd 0 inv
X224 n223 n224 vdd 0 inv
X225 n224 n225 vdd 0 inv
X226 n225 n226 vdd 0 inv
X227 n226 n227 vdd 0 inv
X228 n227 n228 vdd 0 inv
X229 n228 n229 vdd 0 inv
X230 n229 n230 vdd 0 inv
X231 n230 n231 vdd 0 inv
X232 n231 n232 vdd 0 inv
X233 n232 n233 vdd 0 inv
X234 n233 n234 vdd 0 inv
X235 n234 n235 vdd 0 inv
X236 n235 n236 vdd 0 inv
X237 n236 n237 vdd 0 inv
X238 n237 n238 vdd 0 inv
X239 n238 n239 vdd 0 inv
X240 n239 n240 vdd 0 inv
X241 n240 n241 vdd 0 inv
X242 n241 n242 vdd 0 inv
X243 n242 n243 vdd 0 inv
X244 n243 n244 vdd 0 inv
X245 n244 n245 vdd 0 inv
X246 n245 n246 vdd 0 inv
X247 n246 n247 vdd 0 inv
X248 n247 n248 vdd 0 inv
X249 n248 n249 vdd 0 inv
X250 n249 n250 vdd 0 inv
X251 n250 n251 vdd 0 inv
X252 n251 n252 vdd 0 inv
X253 n252 n253 vdd 0 inv
X254 n253 n254 vdd 0 inv
X255 n254 n255 vdd 0 inv
X256 n255 n256 vdd 0 inv
X257 n256 n257 vdd 0 inv
X258 n257 n258 vdd 0 inv
X259 n258 n259 vdd 0 inv
X260 n259 n260 vdd 0 inv
X261 n260 n261 vdd 0 inv
X262 n261 n262 vdd 0 inv
X263 n262 n263 vdd 0 inv
X264 n263 n264 vdd 0 inv
X265 n264 n265 vdd 0 inv
X266 n265 n266 vdd 0 inv
X267 n266 n267 vdd 0 inv
X268 n267 n268 vdd 0 inv
X269 n268 n269 vdd 0 inv
X270 n269 n270 vdd 0 inv
X271 n270 n271 vdd 0 inv
X272 n271 n272 vdd 0 inv
X273 n272 n273 vdd 0 inv
X274 n273 n274 vdd 0 inv
X275 n274 n275 vdd 0 inv
X276 n275 n276 vdd 0 inv
X277 n276 n277 vdd 0 inv
X278 n277 n278 vdd 0 inv
X279 n278 n279 vdd 0 inv
X280 n279 n280 vdd 0 inv
X281 n280 n281 vdd 0 inv
X282 n281 n282 vdd 0 inv
X283 n282 n283 vdd 0 inv
X284 n283 n284 vdd 0 inv
X285 n284 n285 vdd 0 inv
X286 n285 n286 vdd 0 inv
X287 n286 n287 vdd 0 inv
X288 n287 n288 vdd 0 inv
X289 n288 n289 vdd 0 inv
X290 n289 n290 vdd 0 inv
X291 n290 n291 vdd 0 inv
X292 n291 n292 vdd 0 inv
X293 n292 n293 vdd 0 inv
X294 n293 n294 vdd 0 inv
X295 n294 n295 vdd 0 inv
X296 n295 n296 vdd 0 inv
X297 n296 n297 vdd 0 inv
X298 n297 n298 vdd 0 inv
X299 n298 n299 vdd 0 inv
X300 n299 n300 vdd 0 inv
X301 n300 n301 vdd 0 inv
X302 n301 n302 vdd 0 inv
X303 n302 n303 vdd 0 inv
X304 n303 n304 vdd 0 inv
X305 n304 n305 vdd 0 inv
X306 n305 n306 vdd 0 inv
X307 n306 n307 vdd 0 inv
X308 n307 n308 vdd 0 inv
X309 n308 n309 vdd 0 inv
X310 n309 n310 vdd 0 inv
X311 n310 n311 vdd 0 inv
X312 n311 n312 vdd 0 inv
X313 n312 n313 vdd 0 inv
X314 n313 n314 vdd 0 inv
X315 n314 n315 vdd 0 inv
X316 n315 n316 vdd 0 inv
X317 n316 n317 vdd 0 inv
X318 n317 n318 vdd 0 inv
X319 n318 n319 vdd 0 inv
X320 n319 n320 vdd 0 inv
X321 n320 n321 vdd 0 inv
X322 n321 n322 vdd 0 inv
X323 n322 n323 vdd 0 inv
X324 n323 n324 vdd 0 inv
X325 n324 n325 vdd 0 inv
X326 n325 n326 vdd 0 inv
X327 n326 n327 vdd 0 inv
X328 n327 n328 vdd 0 inv
X329 n328 n329 vdd 0 inv
X330 n329 n330 vdd 0 inv
X331 n330 n331 vdd 0 inv
X332 n331 n332 vdd 0 inv
X333 n332 n333 vdd 0 inv
X334 n333 n334 vdd 0 inv
X335 n334 n335 vdd 0 inv
X336 n335 n336 vdd 0 inv
X337 n336 n337 vdd 0 inv
X338 n337 n338 vdd 0 inv
X339 n338 n339 vdd 0 inv
X340 n339 n340 vdd 0 inv
X341 n340 n341 vdd 0 inv
X342 n341 n342 vdd 0 inv
X343 n342 n343 vdd 0 inv
X344 n343 n344 vdd 0 inv
X345 n344 n345 vdd 0 inv
X346 n345 n346 vdd 0 inv
X347 n346 n347 vdd 0 inv
X348 n347 n348 vdd 0 inv
X349 n348 n349 vdd 0 inv
X350 n349 n350 vdd 0 inv
X351 n350 n351 vdd 0 inv
X352 n351 n352 vdd 0 inv
X353 n352 n353 vdd 0 inv
X354 n353 n354 vdd 0 inv
X355 n354 n355 vdd 0 inv
X356 n355 n356 vdd 0 inv
X357 n356 n357 vdd 0 inv
X358 n357 n358 vdd 0 inv
X359 n358 n359 vdd 0 inv
X360 n359 n360 vdd 0 inv
X361 n360 n361 vdd 0 inv
X362 n361 n362 vdd 0 inv
X363 n362 n363 vdd 0 inv
X364 n363 n364 vdd 0 inv
X365 n364 n365 vdd 0 inv
X366 n365 n366 vdd 0 inv
X367 n366 n367 vdd 0 inv
X368 n367 n368 vdd 0 inv
X369 n368 n369 vdd 0 inv
X370 n369 n370 vdd 0 inv
X371 n370 n371 vdd 0 inv
X372 n371 n372 vdd 0 inv
X373 n372 n373 vdd 0 inv
X374 n373 n374 vdd 0 inv
X375 n374 n375 vdd 0 inv
X376 n375 n376 vdd 0 inv
X377 n376 n377 vdd 0 inv
X378 n377 n378 vdd 0 inv
X379 n378 n379 vdd 0 inv
X380 n379 n380 vdd 0 inv
X381 n380 n381 vdd 0 inv
X382 n381 n382 vdd 0 inv
X383 n382 n383 vdd 0 inv
X384 n383 n384 vdd 0 inv
X385 n384 n385 vdd 0 inv
X386 n385 n386 vdd 0 inv
X387 n386 n387 vdd 0 inv
X388 n387 n388 vdd 0 inv
X389 n388 n389 vdd 0 inv
X390 n389 n390 vdd 0 inv
X391 n390 n391 vdd 0 inv
X392 n391 n392 vdd 0 inv
X393 n392 n393 vdd 0 inv
X394 n393 n394 vdd 0 inv
X395 n394 n395 vdd 0 inv
X396 n395 n396 vdd 0 inv
X397 n396 n397 vdd 0 inv
X398 n397 n398 vdd 0 inv
X399 n398 n399 vdd 0 inv
X400 n399 n400 vdd 0 inv
X401 n400 n401 vdd 0 inv
X402 n401 n402 vdd 0 inv
X403 n402 n403 vdd 0 inv
X404 n403 n404 vdd 0 inv
X405 n404 n405 vdd 0 inv
X406 n405 n406 vdd 0 inv
X407 n406 n407 vdd 0 inv
X408 n407 n408 vdd 0 inv
X409 n408 n409 vdd 0 inv
X410 n409 n410 vdd 0 inv
X411 n410 n411 vdd 0 inv
X412 n411 n412 vdd 0 inv
X413 n412 n413 vdd 0 inv
X414 n413 n414 vdd 0 inv
X415 n414 n415 vdd 0 inv
X416 n415 n416 vdd 0 inv
X417 n416 n417 vdd 0 inv
X418 n417 n418 vdd 0 inv
X419 n418 n419 vdd 0 inv
X420 n419 n420 vdd 0 inv
X421 n420 n421 vdd 0 inv
X422 n421 n422 vdd 0 inv
X423 n422 n423 vdd 0 inv
X424 n423 n424 vdd 0 inv
X425 n424 n425 vdd 0 inv
X426 n425 n426 vdd 0 inv
X427 n426 n427 vdd 0 inv
X428 n427 n428 vdd 0 inv
X429 n428 n429 vdd 0 inv
X430 n429 n430 vdd 0 inv
X431 n430 n431 vdd 0 inv
X432 n431 n432 vdd 0 inv
X433 n432 n433 vdd 0 inv
X434 n433 n434 vdd 0 inv
X435 n434 n435 vdd 0 inv
X436 n435 n436 vdd 0 inv
X437 n436 n437 vdd 0 inv
X438 n437 n438 vdd 0 inv
X439 n438 n439 vdd 0 inv
X440 n439 n440 vdd 0 inv
X441 n440 n441 vdd 0 inv
X442 n441 n442 vdd 0 inv
X443 n442 n443 vdd 0 inv
X444 n443 n444 vdd 0 inv
X445 n444 n445 vdd 0 inv
X446 n445 n446 vdd 0 inv
X447 n446 n447 vdd 0 inv
X448 n447 n448 vdd 0 inv
X449 n448 n449 vdd 0 inv
X450 n449 n450 vdd 0 inv
X451 n450 n451 vdd 0 inv
X452 n451 n452 vdd 0 inv
X453 n452 n453 vdd 0 inv
X454 n453 n454 vdd 0 inv
X455 n454 n455 vdd 0 inv
X456 n455 n456 vdd 0 inv
X457 n456 n457 vdd 0 inv
X458 n457 n458 vdd 0 inv
X459 n458 n459 vdd 0 inv
X460 n459 n460 vdd 0 inv
X461 n460 n461 vdd 0 inv
X462 n461 n462 vdd 0 inv
X463 n462 n463 vdd 0 inv
X464 n463 n464 vdd 0 inv
X465 n464 n465 vdd 0 inv
X466 n465 n466 vdd 0 inv
X467 n466 n467 vdd 0 inv
X468 n467 n468 vdd 0 inv
X469 n468 n469 vdd 0 inv
X470 n469 n470 vdd 0 inv
X471 n470 n471 vdd 0 inv
X472 n471 n472 vdd 0 inv
X473 n472 n473 vdd 0 inv
X474 n473 n474 vdd 0 inv
X475 n474 n475 vdd 0 inv
X476 n475 n476 vdd 0 inv
X477 n476 n477 vdd 0 inv
X478 n477 n478 vdd 0 inv
X479 n478 n479 vdd 0 inv
X480 n479 n480 vdd 0 inv
X481 n480 n481 vdd 0 inv
X482 n481 n482 vdd 0 inv
X483 n482 n483 vdd 0 inv
X484 n483 n484 vdd 0 inv
X485 n484 n485 vdd 0 inv
X486 n485 n486 vdd 0 inv
X487 n486 n487 vdd 0 inv
X488 n487 n488 vdd 0 inv
X489 n488 n489 vdd 0 inv
X490 n489 n490 vdd 0 inv
X491 n490 n491 vdd 0 inv
X492 n491 n492 vdd 0 inv
X493 n492 n493 vdd 0 inv
X494 n493 n494 vdd 0 inv
X495 n494 n495 vdd 0 inv
X496 n495 n496 vdd 0 inv
X497 n496 n497 vdd 0 inv
X498 n497 n498 vdd 0 inv
X499 n498 n499 vdd 0 inv
X500 n499 n500 vdd 0 inv
X501 n500 n501 vdd 0 inv
X502 n501 n502 vdd 0 inv
X503 n502 n503 vdd 0 inv
X504 n503 n504 vdd 0 inv
X505 n504 n505 vdd 0 inv
X506 n505 n506 vdd 0 inv
X507 n506 n507 vdd 0 inv
X508 n507 n508 vdd 0 inv
X509 n508 n509 vdd 0 inv
X510 n509 n510 vdd 0 inv
X511 n510 n511 vdd 0 inv
X512 n511 n512 vdd 0 inv
X513 n512 n513 vdd 0 inv
X514 n513 n514 vdd 0 inv
X515 n514 n515 vdd 0 inv
X516 n515 n516 vdd 0 inv
X517 n516 n517 vdd 0 inv
X518 n517 n518 vdd 0 inv
X519 n518 n519 vdd 0 inv
X520 n519 n520 vdd 0 inv
X521 n520 n521 vdd 0 inv
X522 n521 n522 vdd 0 inv
X523 n522 n523 vdd 0 inv
X524 n523 n524 vdd 0 inv
X525 n524 n525 vdd 0 inv
X526 n525 n526 vdd 0 inv
X527 n526 n527 vdd 0 inv
X528 n527 n528 vdd 0 inv
X529 n528 n529 vdd 0 inv
X530 n529 n530 vdd 0 inv
X531 n530 n531 vdd 0 inv
X532 n531 n532 vdd 0 inv
X533 n532 n533 vdd 0 inv
X534 n533 n534 vdd 0 inv
X535 n534 n535 vdd 0 inv
X536 n535 n536 vdd 0 inv
X537 n536 n537 vdd 0 inv
X538 n537 n538 vdd 0 inv
X539 n538 n539 vdd 0 inv
X540 n539 n540 vdd 0 inv
X541 n540 n541 vdd 0 inv
X542 n541 n542 vdd 0 inv
X543 n542 n543 vdd 0 inv
X544 n543 n544 vdd 0 inv
X545 n544 n545 vdd 0 inv
X546 n545 n546 vdd 0 inv
X547 n546 n547 vdd 0 inv
X548 n547 n548 vdd 0 inv
X549 n548 n549 vdd 0 inv
X550 n549 n550 vdd 0 inv
X551 n550 n551 vdd 0 inv
X552 n551 n552 vdd 0 inv
X553 n552 n553 vdd 0 inv
X554 n553 n554 vdd 0 inv
X555 n554 n555 vdd 0 inv
X556 n555 n556 vdd 0 inv
X557 n556 n557 vdd 0 inv
X558 n557 n558 vdd 0 inv
X559 n558 n559 vdd 0 inv
X560 n559 n560 vdd 0 inv
X561 n560 n561 vdd 0 inv
X562 n561 n562 vdd 0 inv
X563 n562 n563 vdd 0 inv
X564 n563 n564 vdd 0 inv
X565 n564 n565 vdd 0 inv
X566 n565 n566 vdd 0 inv
X567 n566 n567 vdd 0 inv
X568 n567 n568 vdd 0 inv
X569 n568 n569 vdd 0 inv
X570 n569 n570 vdd 0 inv
X571 n570 n571 vdd 0 inv
X572 n571 n572 vdd 0 inv
X573 n572 n573 vdd 0 inv
X574 n573 n574 vdd 0 inv
X575 n574 n575 vdd 0 inv
X576 n575 n576 vdd 0 inv
X577 n576 n577 vdd 0 inv
X578 n577 n578 vdd 0 inv
X579 n578 n579 vdd 0 inv
X580 n579 n580 vdd 0 inv
X581 n580 n581 vdd 0 inv
X582 n581 n582 vdd 0 inv
X583 n582 n583 vdd 0 inv
X584 n583 n584 vdd 0 inv
X585 n584 n585 vdd 0 inv
X586 n585 n586 vdd 0 inv
X587 n586 n587 vdd 0 inv
X588 n587 n588 vdd 0 inv
X589 n588 n589 vdd 0 inv
X590 n589 n590 vdd 0 inv
X591 n590 n591 vdd 0 inv
X592 n591 n592 vdd 0 inv
X593 n592 n593 vdd 0 inv
X594 n593 n594 vdd 0 inv
X595 n594 n595 vdd 0 inv
X596 n595 n596 vdd 0 inv
X597 n596 n597 vdd 0 inv
X598 n597 n598 vdd 0 inv
X599 n598 n599 vdd 0 inv
X600 n599 n600 vdd 0 inv
X601 n600 n601 vdd 0 inv
X602 n601 n602 vdd 0 inv
X603 n602 n603 vdd 0 inv
X604 n603 n604 vdd 0 inv
X605 n604 n605 vdd 0 inv
X606 n605 n606 vdd 0 inv
X607 n606 n607 vdd 0 inv
X608 n607 n608 vdd 0 inv
X609 n608 n609 vdd 0 inv
X610 n609 n610 vdd 0 inv
X611 n610 n611 vdd 0 inv
X612 n611 n612 vdd 0 inv
X613 n612 n613 vdd 0 inv
X614 n613 n614 vdd 0 inv
X615 n614 n615 vdd 0 inv
X616 n615 n616 vdd 0 inv
X617 n616 n617 vdd 0 inv
X618 n617 n618 vdd 0 inv
X619 n618 n619 vdd 0 inv
X620 n619 n620 vdd 0 inv
X621 n620 n621 vdd 0 inv
X622 n621 n622 vdd 0 inv
X623 n622 n623 vdd 0 inv
X624 n623 n624 vdd 0 inv
X625 n624 n625 vdd 0 inv
X626 n625 n626 vdd 0 inv
X627 n626 n627 vdd 0 inv
X628 n627 n628 vdd 0 inv
X629 n628 n629 vdd 0 inv
X630 n629 n630 vdd 0 inv
X631 n630 n631 vdd 0 inv
X632 n631 n632 vdd 0 inv
X633 n632 n633 vdd 0 inv
X634 n633 n634 vdd 0 inv
X635 n634 n635 vdd 0 inv
X636 n635 n636 vdd 0 inv
X637 n636 n637 vdd 0 inv
X638 n637 n638 vdd 0 inv
X639 n638 n639 vdd 0 inv
X640 n639 n640 vdd 0 inv
X641 n640 n641 vdd 0 inv
X642 n641 n642 vdd 0 inv
X643 n642 n643 vdd 0 inv
X644 n643 n644 vdd 0 inv
X645 n644 n645 vdd 0 inv
X646 n645 n646 vdd 0 inv
X647 n646 n647 vdd 0 inv
X648 n647 n648 vdd 0 inv
X649 n648 n649 vdd 0 inv
X650 n649 n650 vdd 0 inv
X651 n650 n651 vdd 0 inv
X652 n651 n652 vdd 0 inv
X653 n652 n653 vdd 0 inv
X654 n653 n654 vdd 0 inv
X655 n654 n655 vdd 0 inv
X656 n655 n656 vdd 0 inv
X657 n656 n657 vdd 0 inv
X658 n657 n658 vdd 0 inv
X659 n658 n659 vdd 0 inv
X660 n659 n660 vdd 0 inv
X661 n660 n661 vdd 0 inv
X662 n661 n662 vdd 0 inv
X663 n662 n663 vdd 0 inv
X664 n663 n664 vdd 0 inv
X665 n664 n665 vdd 0 inv
X666 n665 n666 vdd 0 inv
X667 n666 n667 vdd 0 inv
X668 n667 n668 vdd 0 inv
X669 n668 n669 vdd 0 inv
X670 n669 n670 vdd 0 inv
X671 n670 n671 vdd 0 inv
X672 n671 n672 vdd 0 inv
X673 n672 n673 vdd 0 inv
X674 n673 n674 vdd 0 inv
X675 n674 n675 vdd 0 inv
X676 n675 n676 vdd 0 inv
X677 n676 n677 vdd 0 inv
X678 n677 n678 vdd 0 inv
X679 n678 n679 vdd 0 inv
X680 n679 n680 vdd 0 inv
X681 n680 n681 vdd 0 inv
X682 n681 n682 vdd 0 inv
X683 n682 n683 vdd 0 inv
X684 n683 n684 vdd 0 inv
X685 n684 n685 vdd 0 inv
X686 n685 n686 vdd 0 inv
X687 n686 n687 vdd 0 inv
X688 n687 n688 vdd 0 inv
X689 n688 n689 vdd 0 inv
X690 n689 n690 vdd 0 inv
X691 n690 n691 vdd 0 inv
X692 n691 n692 vdd 0 inv
X693 n692 n693 vdd 0 inv
X694 n693 n694 vdd 0 inv
X695 n694 n695 vdd 0 inv
X696 n695 n696 vdd 0 inv
X697 n696 n697 vdd 0 inv
X698 n697 n698 vdd 0 inv
X699 n698 n699 vdd 0 inv
X700 n699 n700 vdd 0 inv
X701 n700 n701 vdd 0 inv
X702 n701 n702 vdd 0 inv
X703 n702 n703 vdd 0 inv
X704 n703 n704 vdd 0 inv
X705 n704 n705 vdd 0 inv
X706 n705 n706 vdd 0 inv
X707 n706 n707 vdd 0 inv
X708 n707 n708 vdd 0 inv
X709 n708 n709 vdd 0 inv
X710 n709 n710 vdd 0 inv
X711 n710 n711 vdd 0 inv
X712 n711 n712 vdd 0 inv
X713 n712 n713 vdd 0 inv
X714 n713 n714 vdd 0 inv
X715 n714 n715 vdd 0 inv
X716 n715 n716 vdd 0 inv
X717 n716 n717 vdd 0 inv
X718 n717 n718 vdd 0 inv
X719 n718 n719 vdd 0 inv
X720 n719 n720 vdd 0 inv
X721 n720 n721 vdd 0 inv
X722 n721 n722 vdd 0 inv
X723 n722 n723 vdd 0 inv
X724 n723 n724 vdd 0 inv
X725 n724 n725 vdd 0 inv
X726 n725 n726 vdd 0 inv
X727 n726 n727 vdd 0 inv
X728 n727 n728 vdd 0 inv
X729 n728 n729 vdd 0 inv
X730 n729 n730 vdd 0 inv
X731 n730 n731 vdd 0 inv
X732 n731 n732 vdd 0 inv
X733 n732 n733 vdd 0 inv
X734 n733 n734 vdd 0 inv
X735 n734 n735 vdd 0 inv
X736 n735 n736 vdd 0 inv
X737 n736 n737 vdd 0 inv
X738 n737 n738 vdd 0 inv
X739 n738 n739 vdd 0 inv
X740 n739 n740 vdd 0 inv
X741 n740 n741 vdd 0 inv
X742 n741 n742 vdd 0 inv
X743 n742 n743 vdd 0 inv
X744 n743 n744 vdd 0 inv
X745 n744 n745 vdd 0 inv
X746 n745 n746 vdd 0 inv
X747 n746 n747 vdd 0 inv
X748 n747 n748 vdd 0 inv
X749 n748 n749 vdd 0 inv
X750 n749 n750 vdd 0 inv
X751 n750 n751 vdd 0 inv
X752 n751 n752 vdd 0 inv
X753 n752 n753 vdd 0 inv
X754 n753 n754 vdd 0 inv
X755 n754 n755 vdd 0 inv
X756 n755 n756 vdd 0 inv
X757 n756 n757 vdd 0 inv
X758 n757 n758 vdd 0 inv
X759 n758 n759 vdd 0 inv
X760 n759 n760 vdd 0 inv
X761 n760 n761 vdd 0 inv
X762 n761 n762 vdd 0 inv
X763 n762 n763 vdd 0 inv
X764 n763 n764 vdd 0 inv
X765 n764 n765 vdd 0 inv
X766 n765 n766 vdd 0 inv
X767 n766 n767 vdd 0 inv
X768 n767 n768 vdd 0 inv
X769 n768 n769 vdd 0 inv
X770 n769 n770 vdd 0 inv
X771 n770 n771 vdd 0 inv
X772 n771 n772 vdd 0 inv
X773 n772 n773 vdd 0 inv
X774 n773 n774 vdd 0 inv
X775 n774 n775 vdd 0 inv
X776 n775 n776 vdd 0 inv
X777 n776 n777 vdd 0 inv
X778 n777 n778 vdd 0 inv
X779 n778 n779 vdd 0 inv
X780 n779 n780 vdd 0 inv
X781 n780 n781 vdd 0 inv
X782 n781 n782 vdd 0 inv
X783 n782 n783 vdd 0 inv
X784 n783 n784 vdd 0 inv
X785 n784 n785 vdd 0 inv
X786 n785 n786 vdd 0 inv
X787 n786 n787 vdd 0 inv
X788 n787 n788 vdd 0 inv
X789 n788 n789 vdd 0 inv
X790 n789 n790 vdd 0 inv
X791 n790 n791 vdd 0 inv
X792 n791 n792 vdd 0 inv
X793 n792 n793 vdd 0 inv
X794 n793 n794 vdd 0 inv
X795 n794 n795 vdd 0 inv
X796 n795 n796 vdd 0 inv
X797 n796 n797 vdd 0 inv
X798 n797 n798 vdd 0 inv
X799 n798 n799 vdd 0 inv
X800 n799 n800 vdd 0 inv
X801 n800 n801 vdd 0 inv
X802 n801 n802 vdd 0 inv
X803 n802 n803 vdd 0 inv
X804 n803 n804 vdd 0 inv
X805 n804 n805 vdd 0 inv
X806 n805 n806 vdd 0 inv
X807 n806 n807 vdd 0 inv
X808 n807 n808 vdd 0 inv
X809 n808 n809 vdd 0 inv
X810 n809 n810 vdd 0 inv
X811 n810 n811 vdd 0 inv
X812 n811 n812 vdd 0 inv
X813 n812 n813 vdd 0 inv
X814 n813 n814 vdd 0 inv
X815 n814 n815 vdd 0 inv
X816 n815 n816 vdd 0 inv
X817 n816 n817 vdd 0 inv
X818 n817 n818 vdd 0 inv
X819 n818 n819 vdd 0 inv
X820 n819 n820 vdd 0 inv
X821 n820 n821 vdd 0 inv
X822 n821 n822 vdd 0 inv
X823 n822 n823 vdd 0 inv
X824 n823 n824 vdd 0 inv
X825 n824 n825 vdd 0 inv
X826 n825 n826 vdd 0 inv
X827 n826 n827 vdd 0 inv
X828 n827 n828 vdd 0 inv
X829 n828 n829 vdd 0 inv
X830 n829 n830 vdd 0 inv
X831 n830 n831 vdd 0 inv
X832 n831 n832 vdd 0 inv
X833 n832 n833 vdd 0 inv
X834 n833 n834 vdd 0 inv
X835 n834 n835 vdd 0 inv
X836 n835 n836 vdd 0 inv
X837 n836 n837 vdd 0 inv
X838 n837 n838 vdd 0 inv
X839 n838 n839 vdd 0 inv
X840 n839 n840 vdd 0 inv
X841 n840 n841 vdd 0 inv
X842 n841 n842 vdd 0 inv
X843 n842 n843 vdd 0 inv
X844 n843 n844 vdd 0 inv
X845 n844 n845 vdd 0 inv
X846 n845 n846 vdd 0 inv
X847 n846 n847 vdd 0 inv
X848 n847 n848 vdd 0 inv
X849 n848 n849 vdd 0 inv
X850 n849 n850 vdd 0 inv
X851 n850 n851 vdd 0 inv
X852 n851 n852 vdd 0 inv
X853 n852 n853 vdd 0 inv
X854 n853 n854 vdd 0 inv
X855 n854 n855 vdd 0 inv
X856 n855 n856 vdd 0 inv
X857 n856 n857 vdd 0 inv
X858 n857 n858 vdd 0 inv
X859 n858 n859 vdd 0 inv
X860 n859 n860 vdd 0 inv
X861 n860 n861 vdd 0 inv
X862 n861 n862 vdd 0 inv
X863 n862 n863 vdd 0 inv
X864 n863 n864 vdd 0 inv
X865 n864 n865 vdd 0 inv
X866 n865 n866 vdd 0 inv
X867 n866 n867 vdd 0 inv
X868 n867 n868 vdd 0 inv
X869 n868 n869 vdd 0 inv
X870 n869 n870 vdd 0 inv
X871 n870 n871 vdd 0 inv
X872 n871 n872 vdd 0 inv
X873 n872 n873 vdd 0 inv
X874 n873 n874 vdd 0 inv
X875 n874 n875 vdd 0 inv
X876 n875 n876 vdd 0 inv
X877 n876 n877 vdd 0 inv
X878 n877 n878 vdd 0 inv
X879 n878 n879 vdd 0 inv
X880 n879 n880 vdd 0 inv
X881 n880 n881 vdd 0 inv
X882 n881 n882 vdd 0 inv
X883 n882 n883 vdd 0 inv
X884 n883 n884 vdd 0 inv
X885 n884 n885 vdd 0 inv
X886 n885 n886 vdd 0 inv
X887 n886 n887 vdd 0 inv
X888 n887 n888 vdd 0 inv
X889 n888 n889 vdd 0 inv
X890 n889 n890 vdd 0 inv
X891 n890 n891 vdd 0 inv
X892 n891 n892 vdd 0 inv
X893 n892 n893 vdd 0 inv
X894 n893 n894 vdd 0 inv
X895 n894 n895 vdd 0 inv
X896 n895 n896 vdd 0 inv
X897 n896 n897 vdd 0 inv
X898 n897 n898 vdd 0 inv
X899 n898 n899 vdd 0 inv
X900 n899 n900 vdd 0 inv
X901 n900 n901 vdd 0 inv
X902 n901 n902 vdd 0 inv
X903 n902 n903 vdd 0 inv
X904 n903 n904 vdd 0 inv
X905 n904 n905 vdd 0 inv
X906 n905 n906 vdd 0 inv
X907 n906 n907 vdd 0 inv
X908 n907 n908 vdd 0 inv
X909 n908 n909 vdd 0 inv
X910 n909 n910 vdd 0 inv
X911 n910 n911 vdd 0 inv
X912 n911 n912 vdd 0 inv
X913 n912 n913 vdd 0 inv
X914 n913 n914 vdd 0 inv
X915 n914 n915 vdd 0 inv
X916 n915 n916 vdd 0 inv
X917 n916 n917 vdd 0 inv
X918 n917 n918 vdd 0 inv
X919 n918 n919 vdd 0 inv
X920 n919 n920 vdd 0 inv
X921 n920 n921 vdd 0 inv
X922 n921 n922 vdd 0 inv
X923 n922 n923 vdd 0 inv
X924 n923 n924 vdd 0 inv
X925 n924 n925 vdd 0 inv
X926 n925 n926 vdd 0 inv
X927 n926 n927 vdd 0 inv
X928 n927 n928 vdd 0 inv
X929 n928 n929 vdd 0 inv
X930 n929 n930 vdd 0 inv
X931 n930 n931 vdd 0 inv
X932 n931 n932 vdd 0 inv
X933 n932 n933 vdd 0 inv
X934 n933 n934 vdd 0 inv
X935 n934 n935 vdd 0 inv
X936 n935 n936 vdd 0 inv
X937 n936 n937 vdd 0 inv
X938 n937 n938 vdd 0 inv
X939 n938 n939 vdd 0 inv
X940 n939 n940 vdd 0 inv
X941 n940 n941 vdd 0 inv
X942 n941 n942 vdd 0 inv
X943 n942 n943 vdd 0 inv
X944 n943 n944 vdd 0 inv
X945 n944 n945 vdd 0 inv
X946 n945 n946 vdd 0 inv
X947 n946 n947 vdd 0 inv
X948 n947 n948 vdd 0 inv
X949 n948 n949 vdd 0 inv
X950 n949 n950 vdd 0 inv
X951 n950 n951 vdd 0 inv
X952 n951 n952 vdd 0 inv
X953 n952 n953 vdd 0 inv
X954 n953 n954 vdd 0 inv
X955 n954 n955 vdd 0 inv
X956 n955 n956 vdd 0 inv
X957 n956 n957 vdd 0 inv
X958 n957 n958 vdd 0 inv
X959 n958 n959 vdd 0 inv
X960 n959 n960 vdd 0 inv
X961 n960 n961 vdd 0 inv
X962 n961 n962 vdd 0 inv
X963 n962 n963 vdd 0 inv
X964 n963 n964 vdd 0 inv
X965 n964 n965 vdd 0 inv
X966 n965 n966 vdd 0 inv
X967 n966 n967 vdd 0 inv
X968 n967 n968 vdd 0 inv
X969 n968 n969 vdd 0 inv
X970 n969 n970 vdd 0 inv
X971 n970 n971 vdd 0 inv
X972 n971 n972 vdd 0 inv
X973 n972 n973 vdd 0 inv
X974 n973 n974 vdd 0 inv
X975 n974 n975 vdd 0 inv
X976 n975 n976 vdd 0 inv
X977 n976 n977 vdd 0 inv
X978 n977 n978 vdd 0 inv
X979 n978 n979 vdd 0 inv
X980 n979 n980 vdd 0 inv
X981 n980 n981 vdd 0 inv
X982 n981 n982 vdd 0 inv
X983 n982 n983 vdd 0 inv
X984 n983 n984 vdd 0 inv
X985 n984 n985 vdd 0 inv
X986 n985 n986 vdd 0 inv
X987 n986 n987 vdd 0 inv
X988 n987 n988 vdd 0 inv
X989 n988 n989 vdd 0 inv
X990 n989 n990 vdd 0 inv
X991 n990 n991 vdd 0 inv
X992 n991 n992 vdd 0 inv
X993 n992 n993 vdd 0 inv
X994 n993 n994 vdd 0 inv
X995 n994 n995 vdd 0 inv
X996 n995 n996 vdd 0 inv
X997 n996 n997 vdd 0 inv
X998 n997 n998 vdd 0 inv
X999 n998 n999 vdd 0 inv
X1000 n999 n1000 vdd 0 inv
X1001 n1000 n1001 vdd 0 inv
X1002 n1001 n1002 vdd 0 inv
X1003 n1002 n1003 vdd 0 inv
X1004 n1003 n1004 vdd 0 inv
X1005 n1004 n1005 vdd 0 inv
X1006 n1005 n1006 vdd 0 inv
X1007 n1006 n1007 vdd 0 inv
X1008 n1007 n1008 vdd 0 inv
X1009 n1008 n1009 vdd 0 inv
X1010 n1009 n1010 vdd 0 inv
X1011 n1010 n1011 vdd 0 inv
X1012 n1011 n1012 vdd 0 inv
X1013 n1012 n1013 vdd 0 inv
X1014 n1013 n1014 vdd 0 inv
X1015 n1014 n1015 vdd 0 inv
X1016 n1015 n1016 vdd 0 inv
X1017 n1016 n1017 vdd 0 inv
X1018 n1017 n1018 vdd 0 inv
X1019 n1018 n1019 vdd 0 inv
X1020 n1019 n1020 vdd 0 inv
X1021 n1020 n1021 vdd 0 inv
X1022 n1021 n1022 vdd 0 inv
X1023 n1022 n1023 vdd 0 inv
X1024 n1023 n1024 vdd 0 inv
X1025 n1024 n1025 vdd 0 inv
X1026 n1025 n1026 vdd 0 inv
X1027 n1026 n1027 vdd 0 inv
X1028 n1027 n1028 vdd 0 inv
X1029 n1028 n1029 vdd 0 inv
X1030 n1029 n1030 vdd 0 inv
X1031 n1030 n1031 vdd 0 inv
X1032 n1031 n1032 vdd 0 inv
X1033 n1032 n1033 vdd 0 inv
X1034 n1033 n1034 vdd 0 inv
X1035 n1034 n1035 vdd 0 inv
X1036 n1035 n1036 vdd 0 inv
X1037 n1036 n1037 vdd 0 inv
X1038 n1037 n1038 vdd 0 inv
X1039 n1038 n1039 vdd 0 inv
X1040 n1039 n1040 vdd 0 inv
X1041 n1040 n1041 vdd 0 inv
X1042 n1041 n1042 vdd 0 inv
X1043 n1042 n1043 vdd 0 inv
X1044 n1043 n1044 vdd 0 inv
X1045 n1044 n1045 vdd 0 inv
X1046 n1045 n1046 vdd 0 inv
X1047 n1046 n1047 vdd 0 inv
X1048 n1047 n1048 vdd 0 inv
X1049 n1048 n1049 vdd 0 inv
X1050 n1049 n1050 vdd 0 inv
X1051 n1050 n1051 vdd 0 inv
X1052 n1051 n1052 vdd 0 inv
X1053 n1052 n1053 vdd 0 inv
X1054 n1053 n1054 vdd 0 inv
X1055 n1054 n1055 vdd 0 inv
X1056 n1055 n1056 vdd 0 inv
X1057 n1056 n1057 vdd 0 inv
X1058 n1057 n1058 vdd 0 inv
X1059 n1058 n1059 vdd 0 inv
X1060 n1059 n1060 vdd 0 inv
X1061 n1060 n1061 vdd 0 inv
X1062 n1061 n1062 vdd 0 inv
X1063 n1062 n1063 vdd 0 inv
X1064 n1063 n1064 vdd 0 inv
X1065 n1064 n1065 vdd 0 inv
X1066 n1065 n1066 vdd 0 inv
X1067 n1066 n1067 vdd 0 inv
X1068 n1067 n1068 vdd 0 inv
X1069 n1068 n1069 vdd 0 inv
X1070 n1069 n1070 vdd 0 inv
X1071 n1070 n1071 vdd 0 inv
X1072 n1071 n1072 vdd 0 inv
X1073 n1072 n1073 vdd 0 inv
X1074 n1073 n1074 vdd 0 inv
X1075 n1074 n1075 vdd 0 inv
X1076 n1075 n1076 vdd 0 inv
X1077 n1076 n1077 vdd 0 inv
X1078 n1077 n1078 vdd 0 inv
X1079 n1078 n1079 vdd 0 inv
X1080 n1079 n1080 vdd 0 inv
X1081 n1080 n1081 vdd 0 inv
X1082 n1081 n1082 vdd 0 inv
X1083 n1082 n1083 vdd 0 inv
X1084 n1083 n1084 vdd 0 inv
X1085 n1084 n1085 vdd 0 inv
X1086 n1085 n1086 vdd 0 inv
X1087 n1086 n1087 vdd 0 inv
X1088 n1087 n1088 vdd 0 inv
X1089 n1088 n1089 vdd 0 inv
X1090 n1089 n1090 vdd 0 inv
X1091 n1090 n1091 vdd 0 inv
X1092 n1091 n1092 vdd 0 inv
X1093 n1092 n1093 vdd 0 inv
X1094 n1093 n1094 vdd 0 inv
X1095 n1094 n1095 vdd 0 inv
X1096 n1095 n1096 vdd 0 inv
X1097 n1096 n1097 vdd 0 inv
X1098 n1097 n1098 vdd 0 inv
X1099 n1098 n1099 vdd 0 inv
X1100 n1099 n1100 vdd 0 inv
X1101 n1100 n1101 vdd 0 inv
X1102 n1101 n1102 vdd 0 inv
X1103 n1102 n1103 vdd 0 inv
X1104 n1103 n1104 vdd 0 inv
X1105 n1104 n1105 vdd 0 inv
X1106 n1105 n1106 vdd 0 inv
X1107 n1106 n1107 vdd 0 inv
X1108 n1107 n1108 vdd 0 inv
X1109 n1108 n1109 vdd 0 inv
X1110 n1109 n1110 vdd 0 inv
X1111 n1110 n1111 vdd 0 inv
X1112 n1111 n1112 vdd 0 inv
X1113 n1112 n1113 vdd 0 inv
X1114 n1113 n1114 vdd 0 inv
X1115 n1114 n1115 vdd 0 inv
X1116 n1115 n1116 vdd 0 inv
X1117 n1116 n1117 vdd 0 inv
X1118 n1117 n1118 vdd 0 inv
X1119 n1118 n1119 vdd 0 inv
X1120 n1119 n1120 vdd 0 inv
X1121 n1120 n1121 vdd 0 inv
X1122 n1121 n1122 vdd 0 inv
X1123 n1122 n1123 vdd 0 inv
X1124 n1123 n1124 vdd 0 inv
X1125 n1124 n1125 vdd 0 inv
X1126 n1125 n1126 vdd 0 inv
X1127 n1126 n1127 vdd 0 inv
X1128 n1127 n1128 vdd 0 inv
X1129 n1128 n1129 vdd 0 inv
X1130 n1129 n1130 vdd 0 inv
X1131 n1130 n1131 vdd 0 inv
X1132 n1131 n1132 vdd 0 inv
X1133 n1132 n1133 vdd 0 inv
X1134 n1133 n1134 vdd 0 inv
X1135 n1134 n1135 vdd 0 inv
X1136 n1135 n1136 vdd 0 inv
X1137 n1136 n1137 vdd 0 inv
X1138 n1137 n1138 vdd 0 inv
X1139 n1138 n1139 vdd 0 inv
X1140 n1139 n1140 vdd 0 inv
X1141 n1140 n1141 vdd 0 inv
X1142 n1141 n1142 vdd 0 inv
X1143 n1142 n1143 vdd 0 inv
X1144 n1143 n1144 vdd 0 inv
X1145 n1144 n1145 vdd 0 inv
X1146 n1145 n1146 vdd 0 inv
X1147 n1146 n1147 vdd 0 inv
X1148 n1147 n1148 vdd 0 inv
X1149 n1148 n1149 vdd 0 inv
X1150 n1149 n1150 vdd 0 inv
X1151 n1150 n1151 vdd 0 inv
X1152 n1151 n1152 vdd 0 inv
X1153 n1152 n1153 vdd 0 inv
X1154 n1153 n1154 vdd 0 inv
X1155 n1154 n1155 vdd 0 inv
X1156 n1155 n1156 vdd 0 inv
X1157 n1156 n1157 vdd 0 inv
X1158 n1157 n1158 vdd 0 inv
X1159 n1158 n1159 vdd 0 inv
X1160 n1159 n1160 vdd 0 inv
X1161 n1160 n1161 vdd 0 inv
X1162 n1161 n1162 vdd 0 inv
X1163 n1162 n1163 vdd 0 inv
X1164 n1163 n1164 vdd 0 inv
X1165 n1164 n1165 vdd 0 inv
X1166 n1165 n1166 vdd 0 inv
X1167 n1166 n1167 vdd 0 inv
X1168 n1167 n1168 vdd 0 inv
X1169 n1168 n1169 vdd 0 inv
X1170 n1169 n1170 vdd 0 inv
X1171 n1170 n1171 vdd 0 inv
X1172 n1171 n1172 vdd 0 inv
X1173 n1172 n1173 vdd 0 inv
X1174 n1173 n1174 vdd 0 inv
X1175 n1174 n1175 vdd 0 inv
X1176 n1175 n1176 vdd 0 inv
X1177 n1176 n1177 vdd 0 inv
X1178 n1177 n1178 vdd 0 inv
X1179 n1178 n1179 vdd 0 inv
X1180 n1179 n1180 vdd 0 inv
X1181 n1180 n1181 vdd 0 inv
X1182 n1181 n1182 vdd 0 inv
X1183 n1182 n1183 vdd 0 inv
X1184 n1183 n1184 vdd 0 inv
X1185 n1184 n1185 vdd 0 inv
X1186 n1185 n1186 vdd 0 inv
X1187 n1186 n1187 vdd 0 inv
X1188 n1187 n1188 vdd 0 inv
X1189 n1188 n1189 vdd 0 inv
X1190 n1189 n1190 vdd 0 inv
X1191 n1190 n1191 vdd 0 inv
X1192 n1191 n1192 vdd 0 inv
X1193 n1192 n1193 vdd 0 inv
X1194 n1193 n1194 vdd 0 inv
X1195 n1194 n1195 vdd 0 inv
X1196 n1195 n1196 vdd 0 inv
X1197 n1196 n1197 vdd 0 inv
X1198 n1197 n1198 vdd 0 inv
X1199 n1198 n1199 vdd 0 inv
X1200 n1199 n1200 vdd 0 inv
X1201 n1200 n1201 vdd 0 inv
X1202 n1201 n1202 vdd 0 inv
X1203 n1202 n1203 vdd 0 inv
X1204 n1203 n1204 vdd 0 inv
X1205 n1204 n1205 vdd 0 inv
X1206 n1205 n1206 vdd 0 inv
X1207 n1206 n1207 vdd 0 inv
X1208 n1207 n1208 vdd 0 inv
X1209 n1208 n1209 vdd 0 inv
X1210 n1209 n1210 vdd 0 inv
X1211 n1210 n1211 vdd 0 inv
X1212 n1211 n1212 vdd 0 inv
X1213 n1212 n1213 vdd 0 inv
X1214 n1213 n1214 vdd 0 inv
X1215 n1214 n1215 vdd 0 inv
X1216 n1215 n1216 vdd 0 inv
X1217 n1216 n1217 vdd 0 inv
X1218 n1217 n1218 vdd 0 inv
X1219 n1218 n1219 vdd 0 inv
X1220 n1219 n1220 vdd 0 inv
X1221 n1220 n1221 vdd 0 inv
X1222 n1221 n1222 vdd 0 inv
X1223 n1222 n1223 vdd 0 inv
X1224 n1223 n1224 vdd 0 inv
X1225 n1224 n1225 vdd 0 inv
X1226 n1225 n1226 vdd 0 inv
X1227 n1226 n1227 vdd 0 inv
X1228 n1227 n1228 vdd 0 inv
X1229 n1228 n1229 vdd 0 inv
X1230 n1229 n1230 vdd 0 inv
X1231 n1230 n1231 vdd 0 inv
X1232 n1231 n1232 vdd 0 inv
X1233 n1232 n1233 vdd 0 inv
X1234 n1233 n1234 vdd 0 inv
X1235 n1234 n1235 vdd 0 inv
X1236 n1235 n1236 vdd 0 inv
X1237 n1236 n1237 vdd 0 inv
X1238 n1237 n1238 vdd 0 inv
X1239 n1238 n1239 vdd 0 inv
X1240 n1239 n1240 vdd 0 inv
X1241 n1240 n1241 vdd 0 inv
X1242 n1241 n1242 vdd 0 inv
X1243 n1242 n1243 vdd 0 inv
X1244 n1243 n1244 vdd 0 inv
X1245 n1244 n1245 vdd 0 inv
X1246 n1245 n1246 vdd 0 inv
X1247 n1246 n1247 vdd 0 inv
X1248 n1247 n1248 vdd 0 inv
X1249 n1248 n1249 vdd 0 inv
X1250 n1249 n1250 vdd 0 inv
X1251 n1250 n1251 vdd 0 inv
X1252 n1251 n1252 vdd 0 inv
X1253 n1252 n1253 vdd 0 inv
X1254 n1253 n1254 vdd 0 inv
X1255 n1254 n1255 vdd 0 inv
X1256 n1255 n1256 vdd 0 inv
X1257 n1256 n1257 vdd 0 inv
X1258 n1257 n1258 vdd 0 inv
X1259 n1258 n1259 vdd 0 inv
X1260 n1259 n1260 vdd 0 inv
X1261 n1260 n1261 vdd 0 inv
X1262 n1261 n1262 vdd 0 inv
X1263 n1262 n1263 vdd 0 inv
X1264 n1263 n1264 vdd 0 inv
X1265 n1264 n1265 vdd 0 inv
X1266 n1265 n1266 vdd 0 inv
X1267 n1266 n1267 vdd 0 inv
X1268 n1267 n1268 vdd 0 inv
X1269 n1268 n1269 vdd 0 inv
X1270 n1269 n1270 vdd 0 inv
X1271 n1270 n1271 vdd 0 inv
X1272 n1271 n1272 vdd 0 inv
X1273 n1272 n1273 vdd 0 inv
X1274 n1273 n1274 vdd 0 inv
X1275 n1274 n1275 vdd 0 inv
X1276 n1275 n1276 vdd 0 inv
X1277 n1276 n1277 vdd 0 inv
X1278 n1277 n1278 vdd 0 inv
X1279 n1278 n1279 vdd 0 inv
X1280 n1279 n1280 vdd 0 inv
X1281 n1280 n1281 vdd 0 inv
X1282 n1281 n1282 vdd 0 inv
X1283 n1282 n1283 vdd 0 inv
X1284 n1283 n1284 vdd 0 inv
X1285 n1284 n1285 vdd 0 inv
X1286 n1285 n1286 vdd 0 inv
X1287 n1286 n1287 vdd 0 inv
X1288 n1287 n1288 vdd 0 inv
X1289 n1288 n1289 vdd 0 inv
X1290 n1289 n1290 vdd 0 inv
X1291 n1290 n1291 vdd 0 inv
X1292 n1291 n1292 vdd 0 inv
X1293 n1292 n1293 vdd 0 inv
X1294 n1293 n1294 vdd 0 inv
X1295 n1294 n1295 vdd 0 inv
X1296 n1295 n1296 vdd 0 inv
X1297 n1296 n1297 vdd 0 inv
X1298 n1297 n1298 vdd 0 inv
X1299 n1298 n1299 vdd 0 inv
X1300 n1299 n1300 vdd 0 inv
X1301 n1300 n1301 vdd 0 inv
X1302 n1301 n1302 vdd 0 inv
X1303 n1302 n1303 vdd 0 inv
X1304 n1303 n1304 vdd 0 inv
X1305 n1304 n1305 vdd 0 inv
X1306 n1305 n1306 vdd 0 inv
X1307 n1306 n1307 vdd 0 inv
X1308 n1307 n1308 vdd 0 inv
X1309 n1308 n1309 vdd 0 inv
X1310 n1309 n1310 vdd 0 inv
X1311 n1310 n1311 vdd 0 inv
X1312 n1311 n1312 vdd 0 inv
X1313 n1312 n1313 vdd 0 inv
X1314 n1313 n1314 vdd 0 inv
X1315 n1314 n1315 vdd 0 inv
X1316 n1315 n1316 vdd 0 inv
X1317 n1316 n1317 vdd 0 inv
X1318 n1317 n1318 vdd 0 inv
X1319 n1318 n1319 vdd 0 inv
X1320 n1319 n1320 vdd 0 inv
X1321 n1320 n1321 vdd 0 inv
X1322 n1321 n1322 vdd 0 inv
X1323 n1322 n1323 vdd 0 inv
X1324 n1323 n1324 vdd 0 inv
X1325 n1324 n1325 vdd 0 inv
X1326 n1325 n1326 vdd 0 inv
X1327 n1326 n1327 vdd 0 inv
X1328 n1327 n1328 vdd 0 inv
X1329 n1328 n1329 vdd 0 inv
X1330 n1329 n1330 vdd 0 inv
X1331 n1330 n1331 vdd 0 inv
X1332 n1331 n1332 vdd 0 inv
X1333 n1332 n1333 vdd 0 inv
X1334 n1333 n1334 vdd 0 inv
X1335 n1334 n1335 vdd 0 inv
X1336 n1335 n1336 vdd 0 inv
X1337 n1336 n1337 vdd 0 inv
X1338 n1337 n1338 vdd 0 inv
X1339 n1338 n1339 vdd 0 inv
X1340 n1339 n1340 vdd 0 inv
X1341 n1340 n1341 vdd 0 inv
X1342 n1341 n1342 vdd 0 inv
X1343 n1342 n1343 vdd 0 inv
X1344 n1343 n1344 vdd 0 inv
X1345 n1344 n1345 vdd 0 inv
X1346 n1345 n1346 vdd 0 inv
X1347 n1346 n1347 vdd 0 inv
X1348 n1347 n1348 vdd 0 inv
X1349 n1348 n1349 vdd 0 inv
X1350 n1349 n1350 vdd 0 inv
X1351 n1350 n1351 vdd 0 inv
X1352 n1351 n1352 vdd 0 inv
X1353 n1352 n1353 vdd 0 inv
X1354 n1353 n1354 vdd 0 inv
X1355 n1354 n1355 vdd 0 inv
X1356 n1355 n1356 vdd 0 inv
X1357 n1356 n1357 vdd 0 inv
X1358 n1357 n1358 vdd 0 inv
X1359 n1358 n1359 vdd 0 inv
X1360 n1359 n1360 vdd 0 inv
X1361 n1360 n1361 vdd 0 inv
X1362 n1361 n1362 vdd 0 inv
X1363 n1362 n1363 vdd 0 inv
X1364 n1363 n1364 vdd 0 inv
X1365 n1364 n1365 vdd 0 inv
X1366 n1365 n1366 vdd 0 inv
X1367 n1366 n1367 vdd 0 inv
X1368 n1367 n1368 vdd 0 inv
X1369 n1368 n1369 vdd 0 inv
X1370 n1369 n1370 vdd 0 inv
X1371 n1370 n1371 vdd 0 inv
X1372 n1371 n1372 vdd 0 inv
X1373 n1372 n1373 vdd 0 inv
X1374 n1373 n1374 vdd 0 inv
X1375 n1374 n1375 vdd 0 inv
X1376 n1375 n1376 vdd 0 inv
X1377 n1376 n1377 vdd 0 inv
X1378 n1377 n1378 vdd 0 inv
X1379 n1378 n1379 vdd 0 inv
X1380 n1379 n1380 vdd 0 inv
X1381 n1380 n1381 vdd 0 inv
X1382 n1381 n1382 vdd 0 inv
X1383 n1382 n1383 vdd 0 inv
X1384 n1383 n1384 vdd 0 inv
X1385 n1384 n1385 vdd 0 inv
X1386 n1385 n1386 vdd 0 inv
X1387 n1386 n1387 vdd 0 inv
X1388 n1387 n1388 vdd 0 inv
X1389 n1388 n1389 vdd 0 inv
X1390 n1389 n1390 vdd 0 inv
X1391 n1390 n1391 vdd 0 inv
X1392 n1391 n1392 vdd 0 inv
X1393 n1392 n1393 vdd 0 inv
X1394 n1393 n1394 vdd 0 inv
X1395 n1394 n1395 vdd 0 inv
X1396 n1395 n1396 vdd 0 inv
X1397 n1396 n1397 vdd 0 inv
X1398 n1397 n1398 vdd 0 inv
X1399 n1398 n1399 vdd 0 inv
X1400 n1399 n1400 vdd 0 inv
X1401 n1400 n1401 vdd 0 inv
X1402 n1401 n1402 vdd 0 inv
X1403 n1402 n1403 vdd 0 inv
X1404 n1403 n1404 vdd 0 inv
X1405 n1404 n1405 vdd 0 inv
X1406 n1405 n1406 vdd 0 inv
X1407 n1406 n1407 vdd 0 inv
X1408 n1407 n1408 vdd 0 inv
X1409 n1408 n1409 vdd 0 inv
X1410 n1409 n1410 vdd 0 inv
X1411 n1410 n1411 vdd 0 inv
X1412 n1411 n1412 vdd 0 inv
X1413 n1412 n1413 vdd 0 inv
X1414 n1413 n1414 vdd 0 inv
X1415 n1414 n1415 vdd 0 inv
X1416 n1415 n1416 vdd 0 inv
X1417 n1416 n1417 vdd 0 inv
X1418 n1417 n1418 vdd 0 inv
X1419 n1418 n1419 vdd 0 inv
X1420 n1419 n1420 vdd 0 inv
X1421 n1420 n1421 vdd 0 inv
X1422 n1421 n1422 vdd 0 inv
X1423 n1422 n1423 vdd 0 inv
X1424 n1423 n1424 vdd 0 inv
X1425 n1424 n1425 vdd 0 inv
X1426 n1425 n1426 vdd 0 inv
X1427 n1426 n1427 vdd 0 inv
X1428 n1427 n1428 vdd 0 inv
X1429 n1428 n1429 vdd 0 inv
X1430 n1429 n1430 vdd 0 inv
X1431 n1430 n1431 vdd 0 inv
X1432 n1431 n1432 vdd 0 inv
X1433 n1432 n1433 vdd 0 inv
X1434 n1433 n1434 vdd 0 inv
X1435 n1434 n1435 vdd 0 inv
X1436 n1435 n1436 vdd 0 inv
X1437 n1436 n1437 vdd 0 inv
X1438 n1437 n1438 vdd 0 inv
X1439 n1438 n1439 vdd 0 inv
X1440 n1439 n1440 vdd 0 inv
X1441 n1440 n1441 vdd 0 inv
X1442 n1441 n1442 vdd 0 inv
X1443 n1442 n1443 vdd 0 inv
X1444 n1443 n1444 vdd 0 inv
X1445 n1444 n1445 vdd 0 inv
X1446 n1445 n1446 vdd 0 inv
X1447 n1446 n1447 vdd 0 inv
X1448 n1447 n1448 vdd 0 inv
X1449 n1448 n1449 vdd 0 inv
X1450 n1449 n1450 vdd 0 inv
X1451 n1450 n1451 vdd 0 inv
X1452 n1451 n1452 vdd 0 inv
X1453 n1452 n1453 vdd 0 inv
X1454 n1453 n1454 vdd 0 inv
X1455 n1454 n1455 vdd 0 inv
X1456 n1455 n1456 vdd 0 inv
X1457 n1456 n1457 vdd 0 inv
X1458 n1457 n1458 vdd 0 inv
X1459 n1458 n1459 vdd 0 inv
X1460 n1459 n1460 vdd 0 inv
X1461 n1460 n1461 vdd 0 inv
X1462 n1461 n1462 vdd 0 inv
X1463 n1462 n1463 vdd 0 inv
X1464 n1463 n1464 vdd 0 inv
X1465 n1464 n1465 vdd 0 inv
X1466 n1465 n1466 vdd 0 inv
X1467 n1466 n1467 vdd 0 inv
X1468 n1467 n1468 vdd 0 inv
X1469 n1468 n1469 vdd 0 inv
X1470 n1469 n1470 vdd 0 inv
X1471 n1470 n1471 vdd 0 inv
X1472 n1471 n1472 vdd 0 inv
X1473 n1472 n1473 vdd 0 inv
X1474 n1473 n1474 vdd 0 inv
X1475 n1474 n1475 vdd 0 inv
X1476 n1475 n1476 vdd 0 inv
X1477 n1476 n1477 vdd 0 inv
X1478 n1477 n1478 vdd 0 inv
X1479 n1478 n1479 vdd 0 inv
X1480 n1479 n1480 vdd 0 inv
X1481 n1480 n1481 vdd 0 inv
X1482 n1481 n1482 vdd 0 inv
X1483 n1482 n1483 vdd 0 inv
X1484 n1483 n1484 vdd 0 inv
X1485 n1484 n1485 vdd 0 inv
X1486 n1485 n1486 vdd 0 inv
X1487 n1486 n1487 vdd 0 inv
X1488 n1487 n1488 vdd 0 inv
X1489 n1488 n1489 vdd 0 inv
X1490 n1489 n1490 vdd 0 inv
X1491 n1490 n1491 vdd 0 inv
X1492 n1491 n1492 vdd 0 inv
X1493 n1492 n1493 vdd 0 inv
X1494 n1493 n1494 vdd 0 inv
X1495 n1494 n1495 vdd 0 inv
X1496 n1495 n1496 vdd 0 inv
X1497 n1496 n1497 vdd 0 inv
X1498 n1497 n1498 vdd 0 inv
X1499 n1498 n1499 vdd 0 inv
X1500 n1499 n1500 vdd 0 inv
X1501 n1500 n1501 vdd 0 inv
X1502 n1501 n1502 vdd 0 inv
X1503 n1502 n1503 vdd 0 inv
X1504 n1503 n1504 vdd 0 inv
X1505 n1504 n1505 vdd 0 inv
X1506 n1505 n1506 vdd 0 inv
X1507 n1506 n1507 vdd 0 inv
X1508 n1507 n1508 vdd 0 inv
X1509 n1508 n1509 vdd 0 inv
X1510 n1509 n1510 vdd 0 inv
X1511 n1510 n1511 vdd 0 inv
X1512 n1511 n1512 vdd 0 inv
X1513 n1512 n1513 vdd 0 inv
X1514 n1513 n1514 vdd 0 inv
X1515 n1514 n1515 vdd 0 inv
X1516 n1515 n1516 vdd 0 inv
X1517 n1516 n1517 vdd 0 inv
X1518 n1517 n1518 vdd 0 inv
X1519 n1518 n1519 vdd 0 inv
X1520 n1519 n1520 vdd 0 inv
X1521 n1520 n1521 vdd 0 inv
X1522 n1521 n1522 vdd 0 inv
X1523 n1522 n1523 vdd 0 inv
X1524 n1523 n1524 vdd 0 inv
X1525 n1524 n1525 vdd 0 inv
X1526 n1525 n1526 vdd 0 inv
X1527 n1526 n1527 vdd 0 inv
X1528 n1527 n1528 vdd 0 inv
X1529 n1528 n1529 vdd 0 inv
X1530 n1529 n1530 vdd 0 inv
X1531 n1530 n1531 vdd 0 inv
X1532 n1531 n1532 vdd 0 inv
X1533 n1532 n1533 vdd 0 inv
X1534 n1533 n1534 vdd 0 inv
X1535 n1534 n1535 vdd 0 inv
X1536 n1535 n1536 vdd 0 inv
X1537 n1536 n1537 vdd 0 inv
X1538 n1537 n1538 vdd 0 inv
X1539 n1538 n1539 vdd 0 inv
X1540 n1539 n1540 vdd 0 inv
X1541 n1540 n1541 vdd 0 inv
X1542 n1541 n1542 vdd 0 inv
X1543 n1542 n1543 vdd 0 inv
X1544 n1543 n1544 vdd 0 inv
X1545 n1544 n1545 vdd 0 inv
X1546 n1545 n1546 vdd 0 inv
X1547 n1546 n1547 vdd 0 inv
X1548 n1547 n1548 vdd 0 inv
X1549 n1548 n1549 vdd 0 inv
X1550 n1549 n1550 vdd 0 inv
X1551 n1550 n1551 vdd 0 inv
X1552 n1551 n1552 vdd 0 inv
X1553 n1552 n1553 vdd 0 inv
X1554 n1553 n1554 vdd 0 inv
X1555 n1554 n1555 vdd 0 inv
X1556 n1555 n1556 vdd 0 inv
X1557 n1556 n1557 vdd 0 inv
X1558 n1557 n1558 vdd 0 inv
X1559 n1558 n1559 vdd 0 inv
X1560 n1559 n1560 vdd 0 inv
X1561 n1560 n1561 vdd 0 inv
X1562 n1561 n1562 vdd 0 inv
X1563 n1562 n1563 vdd 0 inv
X1564 n1563 n1564 vdd 0 inv
X1565 n1564 n1565 vdd 0 inv
X1566 n1565 n1566 vdd 0 inv
X1567 n1566 n1567 vdd 0 inv
X1568 n1567 n1568 vdd 0 inv
X1569 n1568 n1569 vdd 0 inv
X1570 n1569 n1570 vdd 0 inv
X1571 n1570 n1571 vdd 0 inv
X1572 n1571 n1572 vdd 0 inv
X1573 n1572 n1573 vdd 0 inv
X1574 n1573 n1574 vdd 0 inv
X1575 n1574 n1575 vdd 0 inv
X1576 n1575 n1576 vdd 0 inv
X1577 n1576 n1577 vdd 0 inv
X1578 n1577 n1578 vdd 0 inv
X1579 n1578 n1579 vdd 0 inv
X1580 n1579 n1580 vdd 0 inv
X1581 n1580 n1581 vdd 0 inv
X1582 n1581 n1582 vdd 0 inv
X1583 n1582 n1583 vdd 0 inv
X1584 n1583 n1584 vdd 0 inv
X1585 n1584 n1585 vdd 0 inv
X1586 n1585 n1586 vdd 0 inv
X1587 n1586 n1587 vdd 0 inv
X1588 n1587 n1588 vdd 0 inv
X1589 n1588 n1589 vdd 0 inv
X1590 n1589 n1590 vdd 0 inv
X1591 n1590 n1591 vdd 0 inv
X1592 n1591 n1592 vdd 0 inv
X1593 n1592 n1593 vdd 0 inv
X1594 n1593 n1594 vdd 0 inv
X1595 n1594 n1595 vdd 0 inv
X1596 n1595 n1596 vdd 0 inv
X1597 n1596 n1597 vdd 0 inv
X1598 n1597 n1598 vdd 0 inv
X1599 n1598 n1599 vdd 0 inv
X1600 n1599 n1600 vdd 0 inv
X1601 n1600 n1601 vdd 0 inv
X1602 n1601 n1602 vdd 0 inv
X1603 n1602 n1603 vdd 0 inv
X1604 n1603 n1604 vdd 0 inv
X1605 n1604 n1605 vdd 0 inv
X1606 n1605 n1606 vdd 0 inv
X1607 n1606 n1607 vdd 0 inv
X1608 n1607 n1608 vdd 0 inv
X1609 n1608 n1609 vdd 0 inv
X1610 n1609 n1610 vdd 0 inv
X1611 n1610 n1611 vdd 0 inv
X1612 n1611 n1612 vdd 0 inv
X1613 n1612 n1613 vdd 0 inv
X1614 n1613 n1614 vdd 0 inv
X1615 n1614 n1615 vdd 0 inv
X1616 n1615 n1616 vdd 0 inv
X1617 n1616 n1617 vdd 0 inv
X1618 n1617 n1618 vdd 0 inv
X1619 n1618 n1619 vdd 0 inv
X1620 n1619 n1620 vdd 0 inv
X1621 n1620 n1621 vdd 0 inv
X1622 n1621 n1622 vdd 0 inv
X1623 n1622 n1623 vdd 0 inv
X1624 n1623 n1624 vdd 0 inv
X1625 n1624 n1625 vdd 0 inv
X1626 n1625 n1626 vdd 0 inv
X1627 n1626 n1627 vdd 0 inv
X1628 n1627 n1628 vdd 0 inv
X1629 n1628 n1629 vdd 0 inv
X1630 n1629 n1630 vdd 0 inv
X1631 n1630 n1631 vdd 0 inv
X1632 n1631 n1632 vdd 0 inv
X1633 n1632 n1633 vdd 0 inv
X1634 n1633 n1634 vdd 0 inv
X1635 n1634 n1635 vdd 0 inv
X1636 n1635 n1636 vdd 0 inv
X1637 n1636 n1637 vdd 0 inv
X1638 n1637 n1638 vdd 0 inv
X1639 n1638 n1639 vdd 0 inv
X1640 n1639 n1640 vdd 0 inv
X1641 n1640 n1641 vdd 0 inv
X1642 n1641 n1642 vdd 0 inv
X1643 n1642 n1643 vdd 0 inv
X1644 n1643 n1644 vdd 0 inv
X1645 n1644 n1645 vdd 0 inv
X1646 n1645 n1646 vdd 0 inv
X1647 n1646 n1647 vdd 0 inv
X1648 n1647 n1648 vdd 0 inv
X1649 n1648 n1649 vdd 0 inv
X1650 n1649 n1650 vdd 0 inv
X1651 n1650 n1651 vdd 0 inv
X1652 n1651 n1652 vdd 0 inv
X1653 n1652 n1653 vdd 0 inv
X1654 n1653 n1654 vdd 0 inv
X1655 n1654 n1655 vdd 0 inv
X1656 n1655 n1656 vdd 0 inv
X1657 n1656 n1657 vdd 0 inv
X1658 n1657 n1658 vdd 0 inv
X1659 n1658 n1659 vdd 0 inv
X1660 n1659 n1660 vdd 0 inv
X1661 n1660 n1661 vdd 0 inv
X1662 n1661 n1662 vdd 0 inv
X1663 n1662 n1663 vdd 0 inv
X1664 n1663 n1664 vdd 0 inv
X1665 n1664 n1665 vdd 0 inv
X1666 n1665 n1666 vdd 0 inv
X1667 n1666 n1667 vdd 0 inv
X1668 n1667 n1668 vdd 0 inv
X1669 n1668 n1669 vdd 0 inv
X1670 n1669 n1670 vdd 0 inv
X1671 n1670 n1671 vdd 0 inv
X1672 n1671 n1672 vdd 0 inv
X1673 n1672 n1673 vdd 0 inv
X1674 n1673 n1674 vdd 0 inv
X1675 n1674 n1675 vdd 0 inv
X1676 n1675 n1676 vdd 0 inv
X1677 n1676 n1677 vdd 0 inv
X1678 n1677 n1678 vdd 0 inv
X1679 n1678 n1679 vdd 0 inv
X1680 n1679 n1680 vdd 0 inv
X1681 n1680 n1681 vdd 0 inv
X1682 n1681 n1682 vdd 0 inv
X1683 n1682 n1683 vdd 0 inv
X1684 n1683 n1684 vdd 0 inv
X1685 n1684 n1685 vdd 0 inv
X1686 n1685 n1686 vdd 0 inv
X1687 n1686 n1687 vdd 0 inv
X1688 n1687 n1688 vdd 0 inv
X1689 n1688 n1689 vdd 0 inv
X1690 n1689 n1690 vdd 0 inv
X1691 n1690 n1691 vdd 0 inv
X1692 n1691 n1692 vdd 0 inv
X1693 n1692 n1693 vdd 0 inv
X1694 n1693 n1694 vdd 0 inv
X1695 n1694 n1695 vdd 0 inv
X1696 n1695 n1696 vdd 0 inv
X1697 n1696 n1697 vdd 0 inv
X1698 n1697 n1698 vdd 0 inv
X1699 n1698 n1699 vdd 0 inv
X1700 n1699 n1700 vdd 0 inv
X1701 n1700 n1701 vdd 0 inv
X1702 n1701 n1702 vdd 0 inv
X1703 n1702 n1703 vdd 0 inv
X1704 n1703 n1704 vdd 0 inv
X1705 n1704 n1705 vdd 0 inv
X1706 n1705 n1706 vdd 0 inv
X1707 n1706 n1707 vdd 0 inv
X1708 n1707 n1708 vdd 0 inv
X1709 n1708 n1709 vdd 0 inv
X1710 n1709 n1710 vdd 0 inv
X1711 n1710 n1711 vdd 0 inv
X1712 n1711 n1712 vdd 0 inv
X1713 n1712 n1713 vdd 0 inv
X1714 n1713 n1714 vdd 0 inv
X1715 n1714 n1715 vdd 0 inv
X1716 n1715 n1716 vdd 0 inv
X1717 n1716 n1717 vdd 0 inv
X1718 n1717 n1718 vdd 0 inv
X1719 n1718 n1719 vdd 0 inv
X1720 n1719 n1720 vdd 0 inv
X1721 n1720 n1721 vdd 0 inv
X1722 n1721 n1722 vdd 0 inv
X1723 n1722 n1723 vdd 0 inv
X1724 n1723 n1724 vdd 0 inv
X1725 n1724 n1725 vdd 0 inv
X1726 n1725 n1726 vdd 0 inv
X1727 n1726 n1727 vdd 0 inv
X1728 n1727 n1728 vdd 0 inv
X1729 n1728 n1729 vdd 0 inv
X1730 n1729 n1730 vdd 0 inv
X1731 n1730 n1731 vdd 0 inv
X1732 n1731 n1732 vdd 0 inv
X1733 n1732 n1733 vdd 0 inv
X1734 n1733 n1734 vdd 0 inv
X1735 n1734 n1735 vdd 0 inv
X1736 n1735 n1736 vdd 0 inv
X1737 n1736 n1737 vdd 0 inv
X1738 n1737 n1738 vdd 0 inv
X1739 n1738 n1739 vdd 0 inv
X1740 n1739 n1740 vdd 0 inv
X1741 n1740 n1741 vdd 0 inv
X1742 n1741 n1742 vdd 0 inv
X1743 n1742 n1743 vdd 0 inv
X1744 n1743 n1744 vdd 0 inv
X1745 n1744 n1745 vdd 0 inv
X1746 n1745 n1746 vdd 0 inv
X1747 n1746 n1747 vdd 0 inv
X1748 n1747 n1748 vdd 0 inv
X1749 n1748 n1749 vdd 0 inv
X1750 n1749 n1750 vdd 0 inv
X1751 n1750 n1751 vdd 0 inv
X1752 n1751 n1752 vdd 0 inv
X1753 n1752 n1753 vdd 0 inv
X1754 n1753 n1754 vdd 0 inv
X1755 n1754 n1755 vdd 0 inv
X1756 n1755 n1756 vdd 0 inv
X1757 n1756 n1757 vdd 0 inv
X1758 n1757 n1758 vdd 0 inv
X1759 n1758 n1759 vdd 0 inv
X1760 n1759 n1760 vdd 0 inv
X1761 n1760 n1761 vdd 0 inv
X1762 n1761 n1762 vdd 0 inv
X1763 n1762 n1763 vdd 0 inv
X1764 n1763 n1764 vdd 0 inv
X1765 n1764 n1765 vdd 0 inv
X1766 n1765 n1766 vdd 0 inv
X1767 n1766 n1767 vdd 0 inv
X1768 n1767 n1768 vdd 0 inv
X1769 n1768 n1769 vdd 0 inv
X1770 n1769 n1770 vdd 0 inv
X1771 n1770 n1771 vdd 0 inv
X1772 n1771 n1772 vdd 0 inv
X1773 n1772 n1773 vdd 0 inv
X1774 n1773 n1774 vdd 0 inv
X1775 n1774 n1775 vdd 0 inv
X1776 n1775 n1776 vdd 0 inv
X1777 n1776 n1777 vdd 0 inv
X1778 n1777 n1778 vdd 0 inv
X1779 n1778 n1779 vdd 0 inv
X1780 n1779 n1780 vdd 0 inv
X1781 n1780 n1781 vdd 0 inv
X1782 n1781 n1782 vdd 0 inv
X1783 n1782 n1783 vdd 0 inv
X1784 n1783 n1784 vdd 0 inv
X1785 n1784 n1785 vdd 0 inv
X1786 n1785 n1786 vdd 0 inv
X1787 n1786 n1787 vdd 0 inv
X1788 n1787 n1788 vdd 0 inv
X1789 n1788 n1789 vdd 0 inv
X1790 n1789 n1790 vdd 0 inv
X1791 n1790 n1791 vdd 0 inv
X1792 n1791 n1792 vdd 0 inv
X1793 n1792 n1793 vdd 0 inv
X1794 n1793 n1794 vdd 0 inv
X1795 n1794 n1795 vdd 0 inv
X1796 n1795 n1796 vdd 0 inv
X1797 n1796 n1797 vdd 0 inv
X1798 n1797 n1798 vdd 0 inv
X1799 n1798 n1799 vdd 0 inv
X1800 n1799 n1800 vdd 0 inv
X1801 n1800 n1801 vdd 0 inv
X1802 n1801 n1802 vdd 0 inv
X1803 n1802 n1803 vdd 0 inv
X1804 n1803 n1804 vdd 0 inv
X1805 n1804 n1805 vdd 0 inv
X1806 n1805 n1806 vdd 0 inv
X1807 n1806 n1807 vdd 0 inv
X1808 n1807 n1808 vdd 0 inv
X1809 n1808 n1809 vdd 0 inv
X1810 n1809 n1810 vdd 0 inv
X1811 n1810 n1811 vdd 0 inv
X1812 n1811 n1812 vdd 0 inv
X1813 n1812 n1813 vdd 0 inv
X1814 n1813 n1814 vdd 0 inv
X1815 n1814 n1815 vdd 0 inv
X1816 n1815 n1816 vdd 0 inv
X1817 n1816 n1817 vdd 0 inv
X1818 n1817 n1818 vdd 0 inv
X1819 n1818 n1819 vdd 0 inv
X1820 n1819 n1820 vdd 0 inv
X1821 n1820 n1821 vdd 0 inv
X1822 n1821 n1822 vdd 0 inv
X1823 n1822 n1823 vdd 0 inv
X1824 n1823 n1824 vdd 0 inv
X1825 n1824 n1825 vdd 0 inv
X1826 n1825 n1826 vdd 0 inv
X1827 n1826 n1827 vdd 0 inv
X1828 n1827 n1828 vdd 0 inv
X1829 n1828 n1829 vdd 0 inv
X1830 n1829 n1830 vdd 0 inv
X1831 n1830 n1831 vdd 0 inv
X1832 n1831 n1832 vdd 0 inv
X1833 n1832 n1833 vdd 0 inv
X1834 n1833 n1834 vdd 0 inv
X1835 n1834 n1835 vdd 0 inv
X1836 n1835 n1836 vdd 0 inv
X1837 n1836 n1837 vdd 0 inv
X1838 n1837 n1838 vdd 0 inv
X1839 n1838 n1839 vdd 0 inv
X1840 n1839 n1840 vdd 0 inv
X1841 n1840 n1841 vdd 0 inv
X1842 n1841 n1842 vdd 0 inv
X1843 n1842 n1843 vdd 0 inv
X1844 n1843 n1844 vdd 0 inv
X1845 n1844 n1845 vdd 0 inv
X1846 n1845 n1846 vdd 0 inv
X1847 n1846 n1847 vdd 0 inv
X1848 n1847 n1848 vdd 0 inv
X1849 n1848 n1849 vdd 0 inv
X1850 n1849 n1850 vdd 0 inv
X1851 n1850 n1851 vdd 0 inv
X1852 n1851 n1852 vdd 0 inv
X1853 n1852 n1853 vdd 0 inv
X1854 n1853 n1854 vdd 0 inv
X1855 n1854 n1855 vdd 0 inv
X1856 n1855 n1856 vdd 0 inv
X1857 n1856 n1857 vdd 0 inv
X1858 n1857 n1858 vdd 0 inv
X1859 n1858 n1859 vdd 0 inv
X1860 n1859 n1860 vdd 0 inv
X1861 n1860 n1861 vdd 0 inv
X1862 n1861 n1862 vdd 0 inv
X1863 n1862 n1863 vdd 0 inv
X1864 n1863 n1864 vdd 0 inv
X1865 n1864 n1865 vdd 0 inv
X1866 n1865 n1866 vdd 0 inv
X1867 n1866 n1867 vdd 0 inv
X1868 n1867 n1868 vdd 0 inv
X1869 n1868 n1869 vdd 0 inv
X1870 n1869 n1870 vdd 0 inv
X1871 n1870 n1871 vdd 0 inv
X1872 n1871 n1872 vdd 0 inv
X1873 n1872 n1873 vdd 0 inv
X1874 n1873 n1874 vdd 0 inv
X1875 n1874 n1875 vdd 0 inv
X1876 n1875 n1876 vdd 0 inv
X1877 n1876 n1877 vdd 0 inv
X1878 n1877 n1878 vdd 0 inv
X1879 n1878 n1879 vdd 0 inv
X1880 n1879 n1880 vdd 0 inv
X1881 n1880 n1881 vdd 0 inv
X1882 n1881 n1882 vdd 0 inv
X1883 n1882 n1883 vdd 0 inv
X1884 n1883 n1884 vdd 0 inv
X1885 n1884 n1885 vdd 0 inv
X1886 n1885 n1886 vdd 0 inv
X1887 n1886 n1887 vdd 0 inv
X1888 n1887 n1888 vdd 0 inv
X1889 n1888 n1889 vdd 0 inv
X1890 n1889 n1890 vdd 0 inv
X1891 n1890 n1891 vdd 0 inv
X1892 n1891 n1892 vdd 0 inv
X1893 n1892 n1893 vdd 0 inv
X1894 n1893 n1894 vdd 0 inv
X1895 n1894 n1895 vdd 0 inv
X1896 n1895 n1896 vdd 0 inv
X1897 n1896 n1897 vdd 0 inv
X1898 n1897 n1898 vdd 0 inv
X1899 n1898 n1899 vdd 0 inv
X1900 n1899 n1900 vdd 0 inv
X1901 n1900 n1901 vdd 0 inv
X1902 n1901 n1902 vdd 0 inv
X1903 n1902 n1903 vdd 0 inv
X1904 n1903 n1904 vdd 0 inv
X1905 n1904 n1905 vdd 0 inv
X1906 n1905 n1906 vdd 0 inv
X1907 n1906 n1907 vdd 0 inv
X1908 n1907 n1908 vdd 0 inv
X1909 n1908 n1909 vdd 0 inv
X1910 n1909 n1910 vdd 0 inv
X1911 n1910 n1911 vdd 0 inv
X1912 n1911 n1912 vdd 0 inv
X1913 n1912 n1913 vdd 0 inv
X1914 n1913 n1914 vdd 0 inv
X1915 n1914 n1915 vdd 0 inv
X1916 n1915 n1916 vdd 0 inv
X1917 n1916 n1917 vdd 0 inv
X1918 n1917 n1918 vdd 0 inv
X1919 n1918 n1919 vdd 0 inv
X1920 n1919 n1920 vdd 0 inv
X1921 n1920 n1921 vdd 0 inv
X1922 n1921 n1922 vdd 0 inv
X1923 n1922 n1923 vdd 0 inv
X1924 n1923 n1924 vdd 0 inv
X1925 n1924 n1925 vdd 0 inv
X1926 n1925 n1926 vdd 0 inv
X1927 n1926 n1927 vdd 0 inv
X1928 n1927 n1928 vdd 0 inv
X1929 n1928 n1929 vdd 0 inv
X1930 n1929 n1930 vdd 0 inv
X1931 n1930 n1931 vdd 0 inv
X1932 n1931 n1932 vdd 0 inv
X1933 n1932 n1933 vdd 0 inv
X1934 n1933 n1934 vdd 0 inv
X1935 n1934 n1935 vdd 0 inv
X1936 n1935 n1936 vdd 0 inv
X1937 n1936 n1937 vdd 0 inv
X1938 n1937 n1938 vdd 0 inv
X1939 n1938 n1939 vdd 0 inv
X1940 n1939 n1940 vdd 0 inv
X1941 n1940 n1941 vdd 0 inv
X1942 n1941 n1942 vdd 0 inv
X1943 n1942 n1943 vdd 0 inv
X1944 n1943 n1944 vdd 0 inv
X1945 n1944 n1945 vdd 0 inv
X1946 n1945 n1946 vdd 0 inv
X1947 n1946 n1947 vdd 0 inv
X1948 n1947 n1948 vdd 0 inv
X1949 n1948 n1949 vdd 0 inv
X1950 n1949 n1950 vdd 0 inv
X1951 n1950 n1951 vdd 0 inv
X1952 n1951 n1952 vdd 0 inv
X1953 n1952 n1953 vdd 0 inv
X1954 n1953 n1954 vdd 0 inv
X1955 n1954 n1955 vdd 0 inv
X1956 n1955 n1956 vdd 0 inv
X1957 n1956 n1957 vdd 0 inv
X1958 n1957 n1958 vdd 0 inv
X1959 n1958 n1959 vdd 0 inv
X1960 n1959 n1960 vdd 0 inv
X1961 n1960 n1961 vdd 0 inv
X1962 n1961 n1962 vdd 0 inv
X1963 n1962 n1963 vdd 0 inv
X1964 n1963 n1964 vdd 0 inv
X1965 n1964 n1965 vdd 0 inv
X1966 n1965 n1966 vdd 0 inv
X1967 n1966 n1967 vdd 0 inv
X1968 n1967 n1968 vdd 0 inv
X1969 n1968 n1969 vdd 0 inv
X1970 n1969 n1970 vdd 0 inv
X1971 n1970 n1971 vdd 0 inv
X1972 n1971 n1972 vdd 0 inv
X1973 n1972 n1973 vdd 0 inv
X1974 n1973 n1974 vdd 0 inv
X1975 n1974 n1975 vdd 0 inv
X1976 n1975 n1976 vdd 0 inv
X1977 n1976 n1977 vdd 0 inv
X1978 n1977 n1978 vdd 0 inv
X1979 n1978 n1979 vdd 0 inv
X1980 n1979 n1980 vdd 0 inv
X1981 n1980 n1981 vdd 0 inv
X1982 n1981 n1982 vdd 0 inv
X1983 n1982 n1983 vdd 0 inv
X1984 n1983 n1984 vdd 0 inv
X1985 n1984 n1985 vdd 0 inv
X1986 n1985 n1986 vdd 0 inv
X1987 n1986 n1987 vdd 0 inv
X1988 n1987 n1988 vdd 0 inv
X1989 n1988 n1989 vdd 0 inv
X1990 n1989 n1990 vdd 0 inv
X1991 n1990 n1991 vdd 0 inv
X1992 n1991 n1992 vdd 0 inv
X1993 n1992 n1993 vdd 0 inv
X1994 n1993 n1994 vdd 0 inv
X1995 n1994 n1995 vdd 0 inv
X1996 n1995 n1996 vdd 0 inv
X1997 n1996 n1997 vdd 0 inv
X1998 n1997 n1998 vdd 0 inv
X1999 n1998 n1999 vdd 0 inv
X2000 n1999 out vdd 0 inv

* Load capacitance
CL out 0 1e-14

.control
  * load osdi files
  pre_osdi ../../osdi/sg13g2_moslv_inv_chain.osdi

  tran 1e-10 1e-07 0 1e-10

  * print performance and resource usage
  rusage all

  * write output to file
  set wr_vecnames
  set wr_singlescale
  wrdata check/tb_moslv_inv_chain_N2000_tt_tailored.sp.out v(in) v(out) i(VDD)
  * clean exit after simulation
  set noaskquit
  quit
.endc

.end
