* CMOS inverter chain

.include "../models/sg13g2_moslv_mod_osdi.lib"

.options noacct
.options nomod
.options nopage
.options klu
.options reltol=1e-4

VDD vdd 0 1.2
VIN in 0 PULSE(0 1.2 10n 100p 100p 10n 20n)

* Inverter subcircuit
.subckt inv in out vdd gnd
X1 out in vdd vdd sg13_lv_pmos w=1e-06 l=2e-07
X2 out in gnd gnd sg13_lv_nmos w=5e-07 l=2e-07
.ends

* Inverter instances
X1 in n1 vdd 0 inv
X2 n1 n2 vdd 0 inv
X3 n2 n3 vdd 0 inv
X4 n3 n4 vdd 0 inv
X5 n4 n5 vdd 0 inv
X6 n5 n6 vdd 0 inv
X7 n6 n7 vdd 0 inv
X8 n7 n8 vdd 0 inv
X9 n8 n9 vdd 0 inv
X10 n9 n10 vdd 0 inv
X11 n10 n11 vdd 0 inv
X12 n11 n12 vdd 0 inv
X13 n12 n13 vdd 0 inv
X14 n13 n14 vdd 0 inv
X15 n14 n15 vdd 0 inv
X16 n15 n16 vdd 0 inv
X17 n16 n17 vdd 0 inv
X18 n17 n18 vdd 0 inv
X19 n18 n19 vdd 0 inv
X20 n19 n20 vdd 0 inv
X21 n20 n21 vdd 0 inv
X22 n21 n22 vdd 0 inv
X23 n22 n23 vdd 0 inv
X24 n23 n24 vdd 0 inv
X25 n24 n25 vdd 0 inv
X26 n25 n26 vdd 0 inv
X27 n26 n27 vdd 0 inv
X28 n27 n28 vdd 0 inv
X29 n28 n29 vdd 0 inv
X30 n29 n30 vdd 0 inv
X31 n30 n31 vdd 0 inv
X32 n31 n32 vdd 0 inv
X33 n32 n33 vdd 0 inv
X34 n33 n34 vdd 0 inv
X35 n34 n35 vdd 0 inv
X36 n35 n36 vdd 0 inv
X37 n36 n37 vdd 0 inv
X38 n37 n38 vdd 0 inv
X39 n38 n39 vdd 0 inv
X40 n39 n40 vdd 0 inv
X41 n40 n41 vdd 0 inv
X42 n41 n42 vdd 0 inv
X43 n42 n43 vdd 0 inv
X44 n43 n44 vdd 0 inv
X45 n44 n45 vdd 0 inv
X46 n45 n46 vdd 0 inv
X47 n46 n47 vdd 0 inv
X48 n47 n48 vdd 0 inv
X49 n48 n49 vdd 0 inv
X50 n49 n50 vdd 0 inv
X51 n50 n51 vdd 0 inv
X52 n51 n52 vdd 0 inv
X53 n52 n53 vdd 0 inv
X54 n53 n54 vdd 0 inv
X55 n54 n55 vdd 0 inv
X56 n55 n56 vdd 0 inv
X57 n56 n57 vdd 0 inv
X58 n57 n58 vdd 0 inv
X59 n58 n59 vdd 0 inv
X60 n59 n60 vdd 0 inv
X61 n60 n61 vdd 0 inv
X62 n61 n62 vdd 0 inv
X63 n62 n63 vdd 0 inv
X64 n63 n64 vdd 0 inv
X65 n64 n65 vdd 0 inv
X66 n65 n66 vdd 0 inv
X67 n66 n67 vdd 0 inv
X68 n67 n68 vdd 0 inv
X69 n68 n69 vdd 0 inv
X70 n69 n70 vdd 0 inv
X71 n70 n71 vdd 0 inv
X72 n71 n72 vdd 0 inv
X73 n72 n73 vdd 0 inv
X74 n73 n74 vdd 0 inv
X75 n74 n75 vdd 0 inv
X76 n75 n76 vdd 0 inv
X77 n76 n77 vdd 0 inv
X78 n77 n78 vdd 0 inv
X79 n78 n79 vdd 0 inv
X80 n79 n80 vdd 0 inv
X81 n80 n81 vdd 0 inv
X82 n81 n82 vdd 0 inv
X83 n82 n83 vdd 0 inv
X84 n83 n84 vdd 0 inv
X85 n84 n85 vdd 0 inv
X86 n85 n86 vdd 0 inv
X87 n86 n87 vdd 0 inv
X88 n87 n88 vdd 0 inv
X89 n88 n89 vdd 0 inv
X90 n89 n90 vdd 0 inv
X91 n90 n91 vdd 0 inv
X92 n91 n92 vdd 0 inv
X93 n92 n93 vdd 0 inv
X94 n93 n94 vdd 0 inv
X95 n94 n95 vdd 0 inv
X96 n95 n96 vdd 0 inv
X97 n96 n97 vdd 0 inv
X98 n97 n98 vdd 0 inv
X99 n98 n99 vdd 0 inv
X100 n99 n100 vdd 0 inv
X101 n100 n101 vdd 0 inv
X102 n101 n102 vdd 0 inv
X103 n102 n103 vdd 0 inv
X104 n103 n104 vdd 0 inv
X105 n104 n105 vdd 0 inv
X106 n105 n106 vdd 0 inv
X107 n106 n107 vdd 0 inv
X108 n107 n108 vdd 0 inv
X109 n108 n109 vdd 0 inv
X110 n109 n110 vdd 0 inv
X111 n110 n111 vdd 0 inv
X112 n111 n112 vdd 0 inv
X113 n112 n113 vdd 0 inv
X114 n113 n114 vdd 0 inv
X115 n114 n115 vdd 0 inv
X116 n115 n116 vdd 0 inv
X117 n116 n117 vdd 0 inv
X118 n117 n118 vdd 0 inv
X119 n118 n119 vdd 0 inv
X120 n119 n120 vdd 0 inv
X121 n120 n121 vdd 0 inv
X122 n121 n122 vdd 0 inv
X123 n122 n123 vdd 0 inv
X124 n123 n124 vdd 0 inv
X125 n124 n125 vdd 0 inv
X126 n125 n126 vdd 0 inv
X127 n126 n127 vdd 0 inv
X128 n127 n128 vdd 0 inv
X129 n128 n129 vdd 0 inv
X130 n129 n130 vdd 0 inv
X131 n130 n131 vdd 0 inv
X132 n131 n132 vdd 0 inv
X133 n132 n133 vdd 0 inv
X134 n133 n134 vdd 0 inv
X135 n134 n135 vdd 0 inv
X136 n135 n136 vdd 0 inv
X137 n136 n137 vdd 0 inv
X138 n137 n138 vdd 0 inv
X139 n138 n139 vdd 0 inv
X140 n139 n140 vdd 0 inv
X141 n140 n141 vdd 0 inv
X142 n141 n142 vdd 0 inv
X143 n142 n143 vdd 0 inv
X144 n143 n144 vdd 0 inv
X145 n144 n145 vdd 0 inv
X146 n145 n146 vdd 0 inv
X147 n146 n147 vdd 0 inv
X148 n147 n148 vdd 0 inv
X149 n148 n149 vdd 0 inv
X150 n149 n150 vdd 0 inv
X151 n150 n151 vdd 0 inv
X152 n151 n152 vdd 0 inv
X153 n152 n153 vdd 0 inv
X154 n153 n154 vdd 0 inv
X155 n154 n155 vdd 0 inv
X156 n155 n156 vdd 0 inv
X157 n156 n157 vdd 0 inv
X158 n157 n158 vdd 0 inv
X159 n158 n159 vdd 0 inv
X160 n159 n160 vdd 0 inv
X161 n160 n161 vdd 0 inv
X162 n161 n162 vdd 0 inv
X163 n162 n163 vdd 0 inv
X164 n163 n164 vdd 0 inv
X165 n164 n165 vdd 0 inv
X166 n165 n166 vdd 0 inv
X167 n166 n167 vdd 0 inv
X168 n167 n168 vdd 0 inv
X169 n168 n169 vdd 0 inv
X170 n169 n170 vdd 0 inv
X171 n170 n171 vdd 0 inv
X172 n171 n172 vdd 0 inv
X173 n172 n173 vdd 0 inv
X174 n173 n174 vdd 0 inv
X175 n174 n175 vdd 0 inv
X176 n175 n176 vdd 0 inv
X177 n176 n177 vdd 0 inv
X178 n177 n178 vdd 0 inv
X179 n178 n179 vdd 0 inv
X180 n179 n180 vdd 0 inv
X181 n180 n181 vdd 0 inv
X182 n181 n182 vdd 0 inv
X183 n182 n183 vdd 0 inv
X184 n183 n184 vdd 0 inv
X185 n184 n185 vdd 0 inv
X186 n185 n186 vdd 0 inv
X187 n186 n187 vdd 0 inv
X188 n187 n188 vdd 0 inv
X189 n188 n189 vdd 0 inv
X190 n189 n190 vdd 0 inv
X191 n190 n191 vdd 0 inv
X192 n191 n192 vdd 0 inv
X193 n192 n193 vdd 0 inv
X194 n193 n194 vdd 0 inv
X195 n194 n195 vdd 0 inv
X196 n195 n196 vdd 0 inv
X197 n196 n197 vdd 0 inv
X198 n197 n198 vdd 0 inv
X199 n198 n199 vdd 0 inv
X200 n199 n200 vdd 0 inv
X201 n200 n201 vdd 0 inv
X202 n201 n202 vdd 0 inv
X203 n202 n203 vdd 0 inv
X204 n203 n204 vdd 0 inv
X205 n204 n205 vdd 0 inv
X206 n205 n206 vdd 0 inv
X207 n206 n207 vdd 0 inv
X208 n207 n208 vdd 0 inv
X209 n208 n209 vdd 0 inv
X210 n209 n210 vdd 0 inv
X211 n210 n211 vdd 0 inv
X212 n211 n212 vdd 0 inv
X213 n212 n213 vdd 0 inv
X214 n213 n214 vdd 0 inv
X215 n214 n215 vdd 0 inv
X216 n215 n216 vdd 0 inv
X217 n216 n217 vdd 0 inv
X218 n217 n218 vdd 0 inv
X219 n218 n219 vdd 0 inv
X220 n219 n220 vdd 0 inv
X221 n220 n221 vdd 0 inv
X222 n221 n222 vdd 0 inv
X223 n222 n223 vdd 0 inv
X224 n223 n224 vdd 0 inv
X225 n224 n225 vdd 0 inv
X226 n225 n226 vdd 0 inv
X227 n226 n227 vdd 0 inv
X228 n227 n228 vdd 0 inv
X229 n228 n229 vdd 0 inv
X230 n229 n230 vdd 0 inv
X231 n230 n231 vdd 0 inv
X232 n231 n232 vdd 0 inv
X233 n232 n233 vdd 0 inv
X234 n233 n234 vdd 0 inv
X235 n234 n235 vdd 0 inv
X236 n235 n236 vdd 0 inv
X237 n236 n237 vdd 0 inv
X238 n237 n238 vdd 0 inv
X239 n238 n239 vdd 0 inv
X240 n239 n240 vdd 0 inv
X241 n240 n241 vdd 0 inv
X242 n241 n242 vdd 0 inv
X243 n242 n243 vdd 0 inv
X244 n243 n244 vdd 0 inv
X245 n244 n245 vdd 0 inv
X246 n245 n246 vdd 0 inv
X247 n246 n247 vdd 0 inv
X248 n247 n248 vdd 0 inv
X249 n248 n249 vdd 0 inv
X250 n249 n250 vdd 0 inv
X251 n250 n251 vdd 0 inv
X252 n251 n252 vdd 0 inv
X253 n252 n253 vdd 0 inv
X254 n253 n254 vdd 0 inv
X255 n254 n255 vdd 0 inv
X256 n255 n256 vdd 0 inv
X257 n256 n257 vdd 0 inv
X258 n257 n258 vdd 0 inv
X259 n258 n259 vdd 0 inv
X260 n259 n260 vdd 0 inv
X261 n260 n261 vdd 0 inv
X262 n261 n262 vdd 0 inv
X263 n262 n263 vdd 0 inv
X264 n263 n264 vdd 0 inv
X265 n264 n265 vdd 0 inv
X266 n265 n266 vdd 0 inv
X267 n266 n267 vdd 0 inv
X268 n267 n268 vdd 0 inv
X269 n268 n269 vdd 0 inv
X270 n269 n270 vdd 0 inv
X271 n270 n271 vdd 0 inv
X272 n271 n272 vdd 0 inv
X273 n272 n273 vdd 0 inv
X274 n273 n274 vdd 0 inv
X275 n274 n275 vdd 0 inv
X276 n275 n276 vdd 0 inv
X277 n276 n277 vdd 0 inv
X278 n277 n278 vdd 0 inv
X279 n278 n279 vdd 0 inv
X280 n279 n280 vdd 0 inv
X281 n280 n281 vdd 0 inv
X282 n281 n282 vdd 0 inv
X283 n282 n283 vdd 0 inv
X284 n283 n284 vdd 0 inv
X285 n284 n285 vdd 0 inv
X286 n285 n286 vdd 0 inv
X287 n286 n287 vdd 0 inv
X288 n287 n288 vdd 0 inv
X289 n288 n289 vdd 0 inv
X290 n289 n290 vdd 0 inv
X291 n290 n291 vdd 0 inv
X292 n291 n292 vdd 0 inv
X293 n292 n293 vdd 0 inv
X294 n293 n294 vdd 0 inv
X295 n294 n295 vdd 0 inv
X296 n295 n296 vdd 0 inv
X297 n296 n297 vdd 0 inv
X298 n297 n298 vdd 0 inv
X299 n298 n299 vdd 0 inv
X300 n299 n300 vdd 0 inv
X301 n300 n301 vdd 0 inv
X302 n301 n302 vdd 0 inv
X303 n302 n303 vdd 0 inv
X304 n303 n304 vdd 0 inv
X305 n304 n305 vdd 0 inv
X306 n305 n306 vdd 0 inv
X307 n306 n307 vdd 0 inv
X308 n307 n308 vdd 0 inv
X309 n308 n309 vdd 0 inv
X310 n309 n310 vdd 0 inv
X311 n310 n311 vdd 0 inv
X312 n311 n312 vdd 0 inv
X313 n312 n313 vdd 0 inv
X314 n313 n314 vdd 0 inv
X315 n314 n315 vdd 0 inv
X316 n315 n316 vdd 0 inv
X317 n316 n317 vdd 0 inv
X318 n317 n318 vdd 0 inv
X319 n318 n319 vdd 0 inv
X320 n319 n320 vdd 0 inv
X321 n320 n321 vdd 0 inv
X322 n321 n322 vdd 0 inv
X323 n322 n323 vdd 0 inv
X324 n323 n324 vdd 0 inv
X325 n324 n325 vdd 0 inv
X326 n325 n326 vdd 0 inv
X327 n326 n327 vdd 0 inv
X328 n327 n328 vdd 0 inv
X329 n328 n329 vdd 0 inv
X330 n329 n330 vdd 0 inv
X331 n330 n331 vdd 0 inv
X332 n331 n332 vdd 0 inv
X333 n332 n333 vdd 0 inv
X334 n333 n334 vdd 0 inv
X335 n334 n335 vdd 0 inv
X336 n335 n336 vdd 0 inv
X337 n336 n337 vdd 0 inv
X338 n337 n338 vdd 0 inv
X339 n338 n339 vdd 0 inv
X340 n339 n340 vdd 0 inv
X341 n340 n341 vdd 0 inv
X342 n341 n342 vdd 0 inv
X343 n342 n343 vdd 0 inv
X344 n343 n344 vdd 0 inv
X345 n344 n345 vdd 0 inv
X346 n345 n346 vdd 0 inv
X347 n346 n347 vdd 0 inv
X348 n347 n348 vdd 0 inv
X349 n348 n349 vdd 0 inv
X350 n349 n350 vdd 0 inv
X351 n350 n351 vdd 0 inv
X352 n351 n352 vdd 0 inv
X353 n352 n353 vdd 0 inv
X354 n353 n354 vdd 0 inv
X355 n354 n355 vdd 0 inv
X356 n355 n356 vdd 0 inv
X357 n356 n357 vdd 0 inv
X358 n357 n358 vdd 0 inv
X359 n358 n359 vdd 0 inv
X360 n359 n360 vdd 0 inv
X361 n360 n361 vdd 0 inv
X362 n361 n362 vdd 0 inv
X363 n362 n363 vdd 0 inv
X364 n363 n364 vdd 0 inv
X365 n364 n365 vdd 0 inv
X366 n365 n366 vdd 0 inv
X367 n366 n367 vdd 0 inv
X368 n367 n368 vdd 0 inv
X369 n368 n369 vdd 0 inv
X370 n369 n370 vdd 0 inv
X371 n370 n371 vdd 0 inv
X372 n371 n372 vdd 0 inv
X373 n372 n373 vdd 0 inv
X374 n373 n374 vdd 0 inv
X375 n374 n375 vdd 0 inv
X376 n375 n376 vdd 0 inv
X377 n376 n377 vdd 0 inv
X378 n377 n378 vdd 0 inv
X379 n378 n379 vdd 0 inv
X380 n379 n380 vdd 0 inv
X381 n380 n381 vdd 0 inv
X382 n381 n382 vdd 0 inv
X383 n382 n383 vdd 0 inv
X384 n383 n384 vdd 0 inv
X385 n384 n385 vdd 0 inv
X386 n385 n386 vdd 0 inv
X387 n386 n387 vdd 0 inv
X388 n387 n388 vdd 0 inv
X389 n388 n389 vdd 0 inv
X390 n389 n390 vdd 0 inv
X391 n390 n391 vdd 0 inv
X392 n391 n392 vdd 0 inv
X393 n392 n393 vdd 0 inv
X394 n393 n394 vdd 0 inv
X395 n394 n395 vdd 0 inv
X396 n395 n396 vdd 0 inv
X397 n396 n397 vdd 0 inv
X398 n397 n398 vdd 0 inv
X399 n398 n399 vdd 0 inv
X400 n399 n400 vdd 0 inv
X401 n400 n401 vdd 0 inv
X402 n401 n402 vdd 0 inv
X403 n402 n403 vdd 0 inv
X404 n403 n404 vdd 0 inv
X405 n404 n405 vdd 0 inv
X406 n405 n406 vdd 0 inv
X407 n406 n407 vdd 0 inv
X408 n407 n408 vdd 0 inv
X409 n408 n409 vdd 0 inv
X410 n409 n410 vdd 0 inv
X411 n410 n411 vdd 0 inv
X412 n411 n412 vdd 0 inv
X413 n412 n413 vdd 0 inv
X414 n413 n414 vdd 0 inv
X415 n414 n415 vdd 0 inv
X416 n415 n416 vdd 0 inv
X417 n416 n417 vdd 0 inv
X418 n417 n418 vdd 0 inv
X419 n418 n419 vdd 0 inv
X420 n419 n420 vdd 0 inv
X421 n420 n421 vdd 0 inv
X422 n421 n422 vdd 0 inv
X423 n422 n423 vdd 0 inv
X424 n423 n424 vdd 0 inv
X425 n424 n425 vdd 0 inv
X426 n425 n426 vdd 0 inv
X427 n426 n427 vdd 0 inv
X428 n427 n428 vdd 0 inv
X429 n428 n429 vdd 0 inv
X430 n429 n430 vdd 0 inv
X431 n430 n431 vdd 0 inv
X432 n431 n432 vdd 0 inv
X433 n432 n433 vdd 0 inv
X434 n433 n434 vdd 0 inv
X435 n434 n435 vdd 0 inv
X436 n435 n436 vdd 0 inv
X437 n436 n437 vdd 0 inv
X438 n437 n438 vdd 0 inv
X439 n438 n439 vdd 0 inv
X440 n439 n440 vdd 0 inv
X441 n440 n441 vdd 0 inv
X442 n441 n442 vdd 0 inv
X443 n442 n443 vdd 0 inv
X444 n443 n444 vdd 0 inv
X445 n444 n445 vdd 0 inv
X446 n445 n446 vdd 0 inv
X447 n446 n447 vdd 0 inv
X448 n447 n448 vdd 0 inv
X449 n448 n449 vdd 0 inv
X450 n449 n450 vdd 0 inv
X451 n450 n451 vdd 0 inv
X452 n451 n452 vdd 0 inv
X453 n452 n453 vdd 0 inv
X454 n453 n454 vdd 0 inv
X455 n454 n455 vdd 0 inv
X456 n455 n456 vdd 0 inv
X457 n456 n457 vdd 0 inv
X458 n457 n458 vdd 0 inv
X459 n458 n459 vdd 0 inv
X460 n459 n460 vdd 0 inv
X461 n460 n461 vdd 0 inv
X462 n461 n462 vdd 0 inv
X463 n462 n463 vdd 0 inv
X464 n463 n464 vdd 0 inv
X465 n464 n465 vdd 0 inv
X466 n465 n466 vdd 0 inv
X467 n466 n467 vdd 0 inv
X468 n467 n468 vdd 0 inv
X469 n468 n469 vdd 0 inv
X470 n469 n470 vdd 0 inv
X471 n470 n471 vdd 0 inv
X472 n471 n472 vdd 0 inv
X473 n472 n473 vdd 0 inv
X474 n473 n474 vdd 0 inv
X475 n474 n475 vdd 0 inv
X476 n475 n476 vdd 0 inv
X477 n476 n477 vdd 0 inv
X478 n477 n478 vdd 0 inv
X479 n478 n479 vdd 0 inv
X480 n479 n480 vdd 0 inv
X481 n480 n481 vdd 0 inv
X482 n481 n482 vdd 0 inv
X483 n482 n483 vdd 0 inv
X484 n483 n484 vdd 0 inv
X485 n484 n485 vdd 0 inv
X486 n485 n486 vdd 0 inv
X487 n486 n487 vdd 0 inv
X488 n487 n488 vdd 0 inv
X489 n488 n489 vdd 0 inv
X490 n489 n490 vdd 0 inv
X491 n490 n491 vdd 0 inv
X492 n491 n492 vdd 0 inv
X493 n492 n493 vdd 0 inv
X494 n493 n494 vdd 0 inv
X495 n494 n495 vdd 0 inv
X496 n495 n496 vdd 0 inv
X497 n496 n497 vdd 0 inv
X498 n497 n498 vdd 0 inv
X499 n498 n499 vdd 0 inv
X500 n499 n500 vdd 0 inv
X501 n500 n501 vdd 0 inv
X502 n501 n502 vdd 0 inv
X503 n502 n503 vdd 0 inv
X504 n503 n504 vdd 0 inv
X505 n504 n505 vdd 0 inv
X506 n505 n506 vdd 0 inv
X507 n506 n507 vdd 0 inv
X508 n507 n508 vdd 0 inv
X509 n508 n509 vdd 0 inv
X510 n509 n510 vdd 0 inv
X511 n510 n511 vdd 0 inv
X512 n511 n512 vdd 0 inv
X513 n512 n513 vdd 0 inv
X514 n513 n514 vdd 0 inv
X515 n514 n515 vdd 0 inv
X516 n515 n516 vdd 0 inv
X517 n516 n517 vdd 0 inv
X518 n517 n518 vdd 0 inv
X519 n518 n519 vdd 0 inv
X520 n519 n520 vdd 0 inv
X521 n520 n521 vdd 0 inv
X522 n521 n522 vdd 0 inv
X523 n522 n523 vdd 0 inv
X524 n523 n524 vdd 0 inv
X525 n524 n525 vdd 0 inv
X526 n525 n526 vdd 0 inv
X527 n526 n527 vdd 0 inv
X528 n527 n528 vdd 0 inv
X529 n528 n529 vdd 0 inv
X530 n529 n530 vdd 0 inv
X531 n530 n531 vdd 0 inv
X532 n531 n532 vdd 0 inv
X533 n532 n533 vdd 0 inv
X534 n533 n534 vdd 0 inv
X535 n534 n535 vdd 0 inv
X536 n535 n536 vdd 0 inv
X537 n536 n537 vdd 0 inv
X538 n537 n538 vdd 0 inv
X539 n538 n539 vdd 0 inv
X540 n539 n540 vdd 0 inv
X541 n540 n541 vdd 0 inv
X542 n541 n542 vdd 0 inv
X543 n542 n543 vdd 0 inv
X544 n543 n544 vdd 0 inv
X545 n544 n545 vdd 0 inv
X546 n545 n546 vdd 0 inv
X547 n546 n547 vdd 0 inv
X548 n547 n548 vdd 0 inv
X549 n548 n549 vdd 0 inv
X550 n549 n550 vdd 0 inv
X551 n550 n551 vdd 0 inv
X552 n551 n552 vdd 0 inv
X553 n552 n553 vdd 0 inv
X554 n553 n554 vdd 0 inv
X555 n554 n555 vdd 0 inv
X556 n555 n556 vdd 0 inv
X557 n556 n557 vdd 0 inv
X558 n557 n558 vdd 0 inv
X559 n558 n559 vdd 0 inv
X560 n559 n560 vdd 0 inv
X561 n560 n561 vdd 0 inv
X562 n561 n562 vdd 0 inv
X563 n562 n563 vdd 0 inv
X564 n563 n564 vdd 0 inv
X565 n564 n565 vdd 0 inv
X566 n565 n566 vdd 0 inv
X567 n566 n567 vdd 0 inv
X568 n567 n568 vdd 0 inv
X569 n568 n569 vdd 0 inv
X570 n569 n570 vdd 0 inv
X571 n570 n571 vdd 0 inv
X572 n571 n572 vdd 0 inv
X573 n572 n573 vdd 0 inv
X574 n573 n574 vdd 0 inv
X575 n574 n575 vdd 0 inv
X576 n575 n576 vdd 0 inv
X577 n576 n577 vdd 0 inv
X578 n577 n578 vdd 0 inv
X579 n578 n579 vdd 0 inv
X580 n579 n580 vdd 0 inv
X581 n580 n581 vdd 0 inv
X582 n581 n582 vdd 0 inv
X583 n582 n583 vdd 0 inv
X584 n583 n584 vdd 0 inv
X585 n584 n585 vdd 0 inv
X586 n585 n586 vdd 0 inv
X587 n586 n587 vdd 0 inv
X588 n587 n588 vdd 0 inv
X589 n588 n589 vdd 0 inv
X590 n589 n590 vdd 0 inv
X591 n590 n591 vdd 0 inv
X592 n591 n592 vdd 0 inv
X593 n592 n593 vdd 0 inv
X594 n593 n594 vdd 0 inv
X595 n594 n595 vdd 0 inv
X596 n595 n596 vdd 0 inv
X597 n596 n597 vdd 0 inv
X598 n597 n598 vdd 0 inv
X599 n598 n599 vdd 0 inv
X600 n599 n600 vdd 0 inv
X601 n600 n601 vdd 0 inv
X602 n601 n602 vdd 0 inv
X603 n602 n603 vdd 0 inv
X604 n603 n604 vdd 0 inv
X605 n604 n605 vdd 0 inv
X606 n605 n606 vdd 0 inv
X607 n606 n607 vdd 0 inv
X608 n607 n608 vdd 0 inv
X609 n608 n609 vdd 0 inv
X610 n609 n610 vdd 0 inv
X611 n610 n611 vdd 0 inv
X612 n611 n612 vdd 0 inv
X613 n612 n613 vdd 0 inv
X614 n613 n614 vdd 0 inv
X615 n614 n615 vdd 0 inv
X616 n615 n616 vdd 0 inv
X617 n616 n617 vdd 0 inv
X618 n617 n618 vdd 0 inv
X619 n618 n619 vdd 0 inv
X620 n619 n620 vdd 0 inv
X621 n620 n621 vdd 0 inv
X622 n621 n622 vdd 0 inv
X623 n622 n623 vdd 0 inv
X624 n623 n624 vdd 0 inv
X625 n624 n625 vdd 0 inv
X626 n625 n626 vdd 0 inv
X627 n626 n627 vdd 0 inv
X628 n627 n628 vdd 0 inv
X629 n628 n629 vdd 0 inv
X630 n629 n630 vdd 0 inv
X631 n630 n631 vdd 0 inv
X632 n631 n632 vdd 0 inv
X633 n632 n633 vdd 0 inv
X634 n633 n634 vdd 0 inv
X635 n634 n635 vdd 0 inv
X636 n635 n636 vdd 0 inv
X637 n636 n637 vdd 0 inv
X638 n637 n638 vdd 0 inv
X639 n638 n639 vdd 0 inv
X640 n639 n640 vdd 0 inv
X641 n640 n641 vdd 0 inv
X642 n641 n642 vdd 0 inv
X643 n642 n643 vdd 0 inv
X644 n643 n644 vdd 0 inv
X645 n644 n645 vdd 0 inv
X646 n645 n646 vdd 0 inv
X647 n646 n647 vdd 0 inv
X648 n647 n648 vdd 0 inv
X649 n648 n649 vdd 0 inv
X650 n649 n650 vdd 0 inv
X651 n650 n651 vdd 0 inv
X652 n651 n652 vdd 0 inv
X653 n652 n653 vdd 0 inv
X654 n653 n654 vdd 0 inv
X655 n654 n655 vdd 0 inv
X656 n655 n656 vdd 0 inv
X657 n656 n657 vdd 0 inv
X658 n657 n658 vdd 0 inv
X659 n658 n659 vdd 0 inv
X660 n659 n660 vdd 0 inv
X661 n660 n661 vdd 0 inv
X662 n661 n662 vdd 0 inv
X663 n662 n663 vdd 0 inv
X664 n663 n664 vdd 0 inv
X665 n664 n665 vdd 0 inv
X666 n665 n666 vdd 0 inv
X667 n666 n667 vdd 0 inv
X668 n667 n668 vdd 0 inv
X669 n668 n669 vdd 0 inv
X670 n669 n670 vdd 0 inv
X671 n670 n671 vdd 0 inv
X672 n671 n672 vdd 0 inv
X673 n672 n673 vdd 0 inv
X674 n673 n674 vdd 0 inv
X675 n674 n675 vdd 0 inv
X676 n675 n676 vdd 0 inv
X677 n676 n677 vdd 0 inv
X678 n677 n678 vdd 0 inv
X679 n678 n679 vdd 0 inv
X680 n679 n680 vdd 0 inv
X681 n680 n681 vdd 0 inv
X682 n681 n682 vdd 0 inv
X683 n682 n683 vdd 0 inv
X684 n683 n684 vdd 0 inv
X685 n684 n685 vdd 0 inv
X686 n685 n686 vdd 0 inv
X687 n686 n687 vdd 0 inv
X688 n687 n688 vdd 0 inv
X689 n688 n689 vdd 0 inv
X690 n689 n690 vdd 0 inv
X691 n690 n691 vdd 0 inv
X692 n691 n692 vdd 0 inv
X693 n692 n693 vdd 0 inv
X694 n693 n694 vdd 0 inv
X695 n694 n695 vdd 0 inv
X696 n695 n696 vdd 0 inv
X697 n696 n697 vdd 0 inv
X698 n697 n698 vdd 0 inv
X699 n698 n699 vdd 0 inv
X700 n699 n700 vdd 0 inv
X701 n700 n701 vdd 0 inv
X702 n701 n702 vdd 0 inv
X703 n702 n703 vdd 0 inv
X704 n703 n704 vdd 0 inv
X705 n704 n705 vdd 0 inv
X706 n705 n706 vdd 0 inv
X707 n706 n707 vdd 0 inv
X708 n707 n708 vdd 0 inv
X709 n708 n709 vdd 0 inv
X710 n709 n710 vdd 0 inv
X711 n710 n711 vdd 0 inv
X712 n711 n712 vdd 0 inv
X713 n712 n713 vdd 0 inv
X714 n713 n714 vdd 0 inv
X715 n714 n715 vdd 0 inv
X716 n715 n716 vdd 0 inv
X717 n716 n717 vdd 0 inv
X718 n717 n718 vdd 0 inv
X719 n718 n719 vdd 0 inv
X720 n719 n720 vdd 0 inv
X721 n720 n721 vdd 0 inv
X722 n721 n722 vdd 0 inv
X723 n722 n723 vdd 0 inv
X724 n723 n724 vdd 0 inv
X725 n724 n725 vdd 0 inv
X726 n725 n726 vdd 0 inv
X727 n726 n727 vdd 0 inv
X728 n727 n728 vdd 0 inv
X729 n728 n729 vdd 0 inv
X730 n729 n730 vdd 0 inv
X731 n730 n731 vdd 0 inv
X732 n731 n732 vdd 0 inv
X733 n732 n733 vdd 0 inv
X734 n733 n734 vdd 0 inv
X735 n734 n735 vdd 0 inv
X736 n735 n736 vdd 0 inv
X737 n736 n737 vdd 0 inv
X738 n737 n738 vdd 0 inv
X739 n738 n739 vdd 0 inv
X740 n739 n740 vdd 0 inv
X741 n740 n741 vdd 0 inv
X742 n741 n742 vdd 0 inv
X743 n742 n743 vdd 0 inv
X744 n743 n744 vdd 0 inv
X745 n744 n745 vdd 0 inv
X746 n745 n746 vdd 0 inv
X747 n746 n747 vdd 0 inv
X748 n747 n748 vdd 0 inv
X749 n748 n749 vdd 0 inv
X750 n749 n750 vdd 0 inv
X751 n750 n751 vdd 0 inv
X752 n751 n752 vdd 0 inv
X753 n752 n753 vdd 0 inv
X754 n753 n754 vdd 0 inv
X755 n754 n755 vdd 0 inv
X756 n755 n756 vdd 0 inv
X757 n756 n757 vdd 0 inv
X758 n757 n758 vdd 0 inv
X759 n758 n759 vdd 0 inv
X760 n759 n760 vdd 0 inv
X761 n760 n761 vdd 0 inv
X762 n761 n762 vdd 0 inv
X763 n762 n763 vdd 0 inv
X764 n763 n764 vdd 0 inv
X765 n764 n765 vdd 0 inv
X766 n765 n766 vdd 0 inv
X767 n766 n767 vdd 0 inv
X768 n767 n768 vdd 0 inv
X769 n768 n769 vdd 0 inv
X770 n769 n770 vdd 0 inv
X771 n770 n771 vdd 0 inv
X772 n771 n772 vdd 0 inv
X773 n772 n773 vdd 0 inv
X774 n773 n774 vdd 0 inv
X775 n774 n775 vdd 0 inv
X776 n775 n776 vdd 0 inv
X777 n776 n777 vdd 0 inv
X778 n777 n778 vdd 0 inv
X779 n778 n779 vdd 0 inv
X780 n779 n780 vdd 0 inv
X781 n780 n781 vdd 0 inv
X782 n781 n782 vdd 0 inv
X783 n782 n783 vdd 0 inv
X784 n783 n784 vdd 0 inv
X785 n784 n785 vdd 0 inv
X786 n785 n786 vdd 0 inv
X787 n786 n787 vdd 0 inv
X788 n787 n788 vdd 0 inv
X789 n788 n789 vdd 0 inv
X790 n789 n790 vdd 0 inv
X791 n790 n791 vdd 0 inv
X792 n791 n792 vdd 0 inv
X793 n792 n793 vdd 0 inv
X794 n793 n794 vdd 0 inv
X795 n794 n795 vdd 0 inv
X796 n795 n796 vdd 0 inv
X797 n796 n797 vdd 0 inv
X798 n797 n798 vdd 0 inv
X799 n798 n799 vdd 0 inv
X800 n799 n800 vdd 0 inv
X801 n800 n801 vdd 0 inv
X802 n801 n802 vdd 0 inv
X803 n802 n803 vdd 0 inv
X804 n803 n804 vdd 0 inv
X805 n804 n805 vdd 0 inv
X806 n805 n806 vdd 0 inv
X807 n806 n807 vdd 0 inv
X808 n807 n808 vdd 0 inv
X809 n808 n809 vdd 0 inv
X810 n809 n810 vdd 0 inv
X811 n810 n811 vdd 0 inv
X812 n811 n812 vdd 0 inv
X813 n812 n813 vdd 0 inv
X814 n813 n814 vdd 0 inv
X815 n814 n815 vdd 0 inv
X816 n815 n816 vdd 0 inv
X817 n816 n817 vdd 0 inv
X818 n817 n818 vdd 0 inv
X819 n818 n819 vdd 0 inv
X820 n819 n820 vdd 0 inv
X821 n820 n821 vdd 0 inv
X822 n821 n822 vdd 0 inv
X823 n822 n823 vdd 0 inv
X824 n823 n824 vdd 0 inv
X825 n824 n825 vdd 0 inv
X826 n825 n826 vdd 0 inv
X827 n826 n827 vdd 0 inv
X828 n827 n828 vdd 0 inv
X829 n828 n829 vdd 0 inv
X830 n829 n830 vdd 0 inv
X831 n830 n831 vdd 0 inv
X832 n831 n832 vdd 0 inv
X833 n832 n833 vdd 0 inv
X834 n833 n834 vdd 0 inv
X835 n834 n835 vdd 0 inv
X836 n835 n836 vdd 0 inv
X837 n836 n837 vdd 0 inv
X838 n837 n838 vdd 0 inv
X839 n838 n839 vdd 0 inv
X840 n839 n840 vdd 0 inv
X841 n840 n841 vdd 0 inv
X842 n841 n842 vdd 0 inv
X843 n842 n843 vdd 0 inv
X844 n843 n844 vdd 0 inv
X845 n844 n845 vdd 0 inv
X846 n845 n846 vdd 0 inv
X847 n846 n847 vdd 0 inv
X848 n847 n848 vdd 0 inv
X849 n848 n849 vdd 0 inv
X850 n849 n850 vdd 0 inv
X851 n850 n851 vdd 0 inv
X852 n851 n852 vdd 0 inv
X853 n852 n853 vdd 0 inv
X854 n853 n854 vdd 0 inv
X855 n854 n855 vdd 0 inv
X856 n855 n856 vdd 0 inv
X857 n856 n857 vdd 0 inv
X858 n857 n858 vdd 0 inv
X859 n858 n859 vdd 0 inv
X860 n859 n860 vdd 0 inv
X861 n860 n861 vdd 0 inv
X862 n861 n862 vdd 0 inv
X863 n862 n863 vdd 0 inv
X864 n863 n864 vdd 0 inv
X865 n864 n865 vdd 0 inv
X866 n865 n866 vdd 0 inv
X867 n866 n867 vdd 0 inv
X868 n867 n868 vdd 0 inv
X869 n868 n869 vdd 0 inv
X870 n869 n870 vdd 0 inv
X871 n870 n871 vdd 0 inv
X872 n871 n872 vdd 0 inv
X873 n872 n873 vdd 0 inv
X874 n873 n874 vdd 0 inv
X875 n874 n875 vdd 0 inv
X876 n875 n876 vdd 0 inv
X877 n876 n877 vdd 0 inv
X878 n877 n878 vdd 0 inv
X879 n878 n879 vdd 0 inv
X880 n879 n880 vdd 0 inv
X881 n880 n881 vdd 0 inv
X882 n881 n882 vdd 0 inv
X883 n882 n883 vdd 0 inv
X884 n883 n884 vdd 0 inv
X885 n884 n885 vdd 0 inv
X886 n885 n886 vdd 0 inv
X887 n886 n887 vdd 0 inv
X888 n887 n888 vdd 0 inv
X889 n888 n889 vdd 0 inv
X890 n889 n890 vdd 0 inv
X891 n890 n891 vdd 0 inv
X892 n891 n892 vdd 0 inv
X893 n892 n893 vdd 0 inv
X894 n893 n894 vdd 0 inv
X895 n894 n895 vdd 0 inv
X896 n895 n896 vdd 0 inv
X897 n896 n897 vdd 0 inv
X898 n897 n898 vdd 0 inv
X899 n898 n899 vdd 0 inv
X900 n899 n900 vdd 0 inv
X901 n900 n901 vdd 0 inv
X902 n901 n902 vdd 0 inv
X903 n902 n903 vdd 0 inv
X904 n903 n904 vdd 0 inv
X905 n904 n905 vdd 0 inv
X906 n905 n906 vdd 0 inv
X907 n906 n907 vdd 0 inv
X908 n907 n908 vdd 0 inv
X909 n908 n909 vdd 0 inv
X910 n909 n910 vdd 0 inv
X911 n910 n911 vdd 0 inv
X912 n911 n912 vdd 0 inv
X913 n912 n913 vdd 0 inv
X914 n913 n914 vdd 0 inv
X915 n914 n915 vdd 0 inv
X916 n915 n916 vdd 0 inv
X917 n916 n917 vdd 0 inv
X918 n917 n918 vdd 0 inv
X919 n918 n919 vdd 0 inv
X920 n919 n920 vdd 0 inv
X921 n920 n921 vdd 0 inv
X922 n921 n922 vdd 0 inv
X923 n922 n923 vdd 0 inv
X924 n923 n924 vdd 0 inv
X925 n924 n925 vdd 0 inv
X926 n925 n926 vdd 0 inv
X927 n926 n927 vdd 0 inv
X928 n927 n928 vdd 0 inv
X929 n928 n929 vdd 0 inv
X930 n929 n930 vdd 0 inv
X931 n930 n931 vdd 0 inv
X932 n931 n932 vdd 0 inv
X933 n932 n933 vdd 0 inv
X934 n933 n934 vdd 0 inv
X935 n934 n935 vdd 0 inv
X936 n935 n936 vdd 0 inv
X937 n936 n937 vdd 0 inv
X938 n937 n938 vdd 0 inv
X939 n938 n939 vdd 0 inv
X940 n939 n940 vdd 0 inv
X941 n940 n941 vdd 0 inv
X942 n941 n942 vdd 0 inv
X943 n942 n943 vdd 0 inv
X944 n943 n944 vdd 0 inv
X945 n944 n945 vdd 0 inv
X946 n945 n946 vdd 0 inv
X947 n946 n947 vdd 0 inv
X948 n947 n948 vdd 0 inv
X949 n948 n949 vdd 0 inv
X950 n949 n950 vdd 0 inv
X951 n950 n951 vdd 0 inv
X952 n951 n952 vdd 0 inv
X953 n952 n953 vdd 0 inv
X954 n953 n954 vdd 0 inv
X955 n954 n955 vdd 0 inv
X956 n955 n956 vdd 0 inv
X957 n956 n957 vdd 0 inv
X958 n957 n958 vdd 0 inv
X959 n958 n959 vdd 0 inv
X960 n959 n960 vdd 0 inv
X961 n960 n961 vdd 0 inv
X962 n961 n962 vdd 0 inv
X963 n962 n963 vdd 0 inv
X964 n963 n964 vdd 0 inv
X965 n964 n965 vdd 0 inv
X966 n965 n966 vdd 0 inv
X967 n966 n967 vdd 0 inv
X968 n967 n968 vdd 0 inv
X969 n968 n969 vdd 0 inv
X970 n969 n970 vdd 0 inv
X971 n970 n971 vdd 0 inv
X972 n971 n972 vdd 0 inv
X973 n972 n973 vdd 0 inv
X974 n973 n974 vdd 0 inv
X975 n974 n975 vdd 0 inv
X976 n975 n976 vdd 0 inv
X977 n976 n977 vdd 0 inv
X978 n977 n978 vdd 0 inv
X979 n978 n979 vdd 0 inv
X980 n979 n980 vdd 0 inv
X981 n980 n981 vdd 0 inv
X982 n981 n982 vdd 0 inv
X983 n982 n983 vdd 0 inv
X984 n983 n984 vdd 0 inv
X985 n984 n985 vdd 0 inv
X986 n985 n986 vdd 0 inv
X987 n986 n987 vdd 0 inv
X988 n987 n988 vdd 0 inv
X989 n988 n989 vdd 0 inv
X990 n989 n990 vdd 0 inv
X991 n990 n991 vdd 0 inv
X992 n991 n992 vdd 0 inv
X993 n992 n993 vdd 0 inv
X994 n993 n994 vdd 0 inv
X995 n994 n995 vdd 0 inv
X996 n995 n996 vdd 0 inv
X997 n996 n997 vdd 0 inv
X998 n997 n998 vdd 0 inv
X999 n998 n999 vdd 0 inv
X1000 n999 out vdd 0 inv

* Load capacitance
CL out 0 1e-14

.control
  * load osdi files
  pre_osdi ../../osdi/sg13g2_moslv.osdi

  * save only so that storage does not scale with chain size
  save v(in) v(out)

  tran 0.1n 110n 0 0.1n

  * print performance and resource usage
  rusage all

  * write output to file
  set wr_vecnames
  set wr_singlescale
  wrdata check/tb_moslv_inv_chain_N1000_tt_paramset.sp.out v(in) v(out)
  * clean exit after simulation
  set noaskquit
  quit
.endc

.end
