* CMOS inverter chain

.model sg13_lv_nmos sg13g2_lv_nmos_psp_model
.model sg13_lv_pmos sg13g2_lv_pmos_psp_model

.options noacct
.options nomod
.options nopage
.options klu
.options reltol=1e-4

VDD vdd 0 1.2
VIN in 0 PULSE(0 1.2 10n 100p 100p 10n 20n)

* Inverter subcircuit
.subckt inv in out vdd gnd
N1 out in vdd vdd sg13_lv_pmos
N2 out in gnd gnd sg13_lv_nmos
.ends

* Inverter instances
X1 in n1 vdd 0 inv
X2 n1 n2 vdd 0 inv
X3 n2 n3 vdd 0 inv
X4 n3 n4 vdd 0 inv
X5 n4 n5 vdd 0 inv
X6 n5 n6 vdd 0 inv
X7 n6 n7 vdd 0 inv
X8 n7 n8 vdd 0 inv
X9 n8 n9 vdd 0 inv
X10 n9 n10 vdd 0 inv
X11 n10 n11 vdd 0 inv
X12 n11 n12 vdd 0 inv
X13 n12 n13 vdd 0 inv
X14 n13 n14 vdd 0 inv
X15 n14 n15 vdd 0 inv
X16 n15 n16 vdd 0 inv
X17 n16 n17 vdd 0 inv
X18 n17 n18 vdd 0 inv
X19 n18 n19 vdd 0 inv
X20 n19 n20 vdd 0 inv
X21 n20 n21 vdd 0 inv
X22 n21 n22 vdd 0 inv
X23 n22 n23 vdd 0 inv
X24 n23 n24 vdd 0 inv
X25 n24 n25 vdd 0 inv
X26 n25 n26 vdd 0 inv
X27 n26 n27 vdd 0 inv
X28 n27 n28 vdd 0 inv
X29 n28 n29 vdd 0 inv
X30 n29 n30 vdd 0 inv
X31 n30 n31 vdd 0 inv
X32 n31 n32 vdd 0 inv
X33 n32 n33 vdd 0 inv
X34 n33 n34 vdd 0 inv
X35 n34 n35 vdd 0 inv
X36 n35 n36 vdd 0 inv
X37 n36 n37 vdd 0 inv
X38 n37 n38 vdd 0 inv
X39 n38 n39 vdd 0 inv
X40 n39 n40 vdd 0 inv
X41 n40 n41 vdd 0 inv
X42 n41 n42 vdd 0 inv
X43 n42 n43 vdd 0 inv
X44 n43 n44 vdd 0 inv
X45 n44 n45 vdd 0 inv
X46 n45 n46 vdd 0 inv
X47 n46 n47 vdd 0 inv
X48 n47 n48 vdd 0 inv
X49 n48 n49 vdd 0 inv
X50 n49 n50 vdd 0 inv
X51 n50 n51 vdd 0 inv
X52 n51 n52 vdd 0 inv
X53 n52 n53 vdd 0 inv
X54 n53 n54 vdd 0 inv
X55 n54 n55 vdd 0 inv
X56 n55 n56 vdd 0 inv
X57 n56 n57 vdd 0 inv
X58 n57 n58 vdd 0 inv
X59 n58 n59 vdd 0 inv
X60 n59 n60 vdd 0 inv
X61 n60 n61 vdd 0 inv
X62 n61 n62 vdd 0 inv
X63 n62 n63 vdd 0 inv
X64 n63 n64 vdd 0 inv
X65 n64 n65 vdd 0 inv
X66 n65 n66 vdd 0 inv
X67 n66 n67 vdd 0 inv
X68 n67 n68 vdd 0 inv
X69 n68 n69 vdd 0 inv
X70 n69 n70 vdd 0 inv
X71 n70 n71 vdd 0 inv
X72 n71 n72 vdd 0 inv
X73 n72 n73 vdd 0 inv
X74 n73 n74 vdd 0 inv
X75 n74 n75 vdd 0 inv
X76 n75 n76 vdd 0 inv
X77 n76 n77 vdd 0 inv
X78 n77 n78 vdd 0 inv
X79 n78 n79 vdd 0 inv
X80 n79 n80 vdd 0 inv
X81 n80 n81 vdd 0 inv
X82 n81 n82 vdd 0 inv
X83 n82 n83 vdd 0 inv
X84 n83 n84 vdd 0 inv
X85 n84 n85 vdd 0 inv
X86 n85 n86 vdd 0 inv
X87 n86 n87 vdd 0 inv
X88 n87 n88 vdd 0 inv
X89 n88 n89 vdd 0 inv
X90 n89 n90 vdd 0 inv
X91 n90 n91 vdd 0 inv
X92 n91 n92 vdd 0 inv
X93 n92 n93 vdd 0 inv
X94 n93 n94 vdd 0 inv
X95 n94 n95 vdd 0 inv
X96 n95 n96 vdd 0 inv
X97 n96 n97 vdd 0 inv
X98 n97 n98 vdd 0 inv
X99 n98 n99 vdd 0 inv
X100 n99 n100 vdd 0 inv
X101 n100 n101 vdd 0 inv
X102 n101 n102 vdd 0 inv
X103 n102 n103 vdd 0 inv
X104 n103 n104 vdd 0 inv
X105 n104 n105 vdd 0 inv
X106 n105 n106 vdd 0 inv
X107 n106 n107 vdd 0 inv
X108 n107 n108 vdd 0 inv
X109 n108 n109 vdd 0 inv
X110 n109 n110 vdd 0 inv
X111 n110 n111 vdd 0 inv
X112 n111 n112 vdd 0 inv
X113 n112 n113 vdd 0 inv
X114 n113 n114 vdd 0 inv
X115 n114 n115 vdd 0 inv
X116 n115 n116 vdd 0 inv
X117 n116 n117 vdd 0 inv
X118 n117 n118 vdd 0 inv
X119 n118 n119 vdd 0 inv
X120 n119 n120 vdd 0 inv
X121 n120 n121 vdd 0 inv
X122 n121 n122 vdd 0 inv
X123 n122 n123 vdd 0 inv
X124 n123 n124 vdd 0 inv
X125 n124 n125 vdd 0 inv
X126 n125 n126 vdd 0 inv
X127 n126 n127 vdd 0 inv
X128 n127 n128 vdd 0 inv
X129 n128 n129 vdd 0 inv
X130 n129 n130 vdd 0 inv
X131 n130 n131 vdd 0 inv
X132 n131 n132 vdd 0 inv
X133 n132 n133 vdd 0 inv
X134 n133 n134 vdd 0 inv
X135 n134 n135 vdd 0 inv
X136 n135 n136 vdd 0 inv
X137 n136 n137 vdd 0 inv
X138 n137 n138 vdd 0 inv
X139 n138 n139 vdd 0 inv
X140 n139 n140 vdd 0 inv
X141 n140 n141 vdd 0 inv
X142 n141 n142 vdd 0 inv
X143 n142 n143 vdd 0 inv
X144 n143 n144 vdd 0 inv
X145 n144 n145 vdd 0 inv
X146 n145 n146 vdd 0 inv
X147 n146 n147 vdd 0 inv
X148 n147 n148 vdd 0 inv
X149 n148 n149 vdd 0 inv
X150 n149 n150 vdd 0 inv
X151 n150 n151 vdd 0 inv
X152 n151 n152 vdd 0 inv
X153 n152 n153 vdd 0 inv
X154 n153 n154 vdd 0 inv
X155 n154 n155 vdd 0 inv
X156 n155 n156 vdd 0 inv
X157 n156 n157 vdd 0 inv
X158 n157 n158 vdd 0 inv
X159 n158 n159 vdd 0 inv
X160 n159 n160 vdd 0 inv
X161 n160 n161 vdd 0 inv
X162 n161 n162 vdd 0 inv
X163 n162 n163 vdd 0 inv
X164 n163 n164 vdd 0 inv
X165 n164 n165 vdd 0 inv
X166 n165 n166 vdd 0 inv
X167 n166 n167 vdd 0 inv
X168 n167 n168 vdd 0 inv
X169 n168 n169 vdd 0 inv
X170 n169 n170 vdd 0 inv
X171 n170 n171 vdd 0 inv
X172 n171 n172 vdd 0 inv
X173 n172 n173 vdd 0 inv
X174 n173 n174 vdd 0 inv
X175 n174 n175 vdd 0 inv
X176 n175 n176 vdd 0 inv
X177 n176 n177 vdd 0 inv
X178 n177 n178 vdd 0 inv
X179 n178 n179 vdd 0 inv
X180 n179 n180 vdd 0 inv
X181 n180 n181 vdd 0 inv
X182 n181 n182 vdd 0 inv
X183 n182 n183 vdd 0 inv
X184 n183 n184 vdd 0 inv
X185 n184 n185 vdd 0 inv
X186 n185 n186 vdd 0 inv
X187 n186 n187 vdd 0 inv
X188 n187 n188 vdd 0 inv
X189 n188 n189 vdd 0 inv
X190 n189 n190 vdd 0 inv
X191 n190 n191 vdd 0 inv
X192 n191 n192 vdd 0 inv
X193 n192 n193 vdd 0 inv
X194 n193 n194 vdd 0 inv
X195 n194 n195 vdd 0 inv
X196 n195 n196 vdd 0 inv
X197 n196 n197 vdd 0 inv
X198 n197 n198 vdd 0 inv
X199 n198 n199 vdd 0 inv
X200 n199 n200 vdd 0 inv
X201 n200 n201 vdd 0 inv
X202 n201 n202 vdd 0 inv
X203 n202 n203 vdd 0 inv
X204 n203 n204 vdd 0 inv
X205 n204 n205 vdd 0 inv
X206 n205 n206 vdd 0 inv
X207 n206 n207 vdd 0 inv
X208 n207 n208 vdd 0 inv
X209 n208 n209 vdd 0 inv
X210 n209 n210 vdd 0 inv
X211 n210 n211 vdd 0 inv
X212 n211 n212 vdd 0 inv
X213 n212 n213 vdd 0 inv
X214 n213 n214 vdd 0 inv
X215 n214 n215 vdd 0 inv
X216 n215 n216 vdd 0 inv
X217 n216 n217 vdd 0 inv
X218 n217 n218 vdd 0 inv
X219 n218 n219 vdd 0 inv
X220 n219 n220 vdd 0 inv
X221 n220 n221 vdd 0 inv
X222 n221 n222 vdd 0 inv
X223 n222 n223 vdd 0 inv
X224 n223 n224 vdd 0 inv
X225 n224 n225 vdd 0 inv
X226 n225 n226 vdd 0 inv
X227 n226 n227 vdd 0 inv
X228 n227 n228 vdd 0 inv
X229 n228 n229 vdd 0 inv
X230 n229 n230 vdd 0 inv
X231 n230 n231 vdd 0 inv
X232 n231 n232 vdd 0 inv
X233 n232 n233 vdd 0 inv
X234 n233 n234 vdd 0 inv
X235 n234 n235 vdd 0 inv
X236 n235 n236 vdd 0 inv
X237 n236 n237 vdd 0 inv
X238 n237 n238 vdd 0 inv
X239 n238 n239 vdd 0 inv
X240 n239 n240 vdd 0 inv
X241 n240 n241 vdd 0 inv
X242 n241 n242 vdd 0 inv
X243 n242 n243 vdd 0 inv
X244 n243 n244 vdd 0 inv
X245 n244 n245 vdd 0 inv
X246 n245 n246 vdd 0 inv
X247 n246 n247 vdd 0 inv
X248 n247 n248 vdd 0 inv
X249 n248 n249 vdd 0 inv
X250 n249 n250 vdd 0 inv
X251 n250 n251 vdd 0 inv
X252 n251 n252 vdd 0 inv
X253 n252 n253 vdd 0 inv
X254 n253 n254 vdd 0 inv
X255 n254 n255 vdd 0 inv
X256 n255 n256 vdd 0 inv
X257 n256 n257 vdd 0 inv
X258 n257 n258 vdd 0 inv
X259 n258 n259 vdd 0 inv
X260 n259 n260 vdd 0 inv
X261 n260 n261 vdd 0 inv
X262 n261 n262 vdd 0 inv
X263 n262 n263 vdd 0 inv
X264 n263 n264 vdd 0 inv
X265 n264 n265 vdd 0 inv
X266 n265 n266 vdd 0 inv
X267 n266 n267 vdd 0 inv
X268 n267 n268 vdd 0 inv
X269 n268 n269 vdd 0 inv
X270 n269 n270 vdd 0 inv
X271 n270 n271 vdd 0 inv
X272 n271 n272 vdd 0 inv
X273 n272 n273 vdd 0 inv
X274 n273 n274 vdd 0 inv
X275 n274 n275 vdd 0 inv
X276 n275 n276 vdd 0 inv
X277 n276 n277 vdd 0 inv
X278 n277 n278 vdd 0 inv
X279 n278 n279 vdd 0 inv
X280 n279 n280 vdd 0 inv
X281 n280 n281 vdd 0 inv
X282 n281 n282 vdd 0 inv
X283 n282 n283 vdd 0 inv
X284 n283 n284 vdd 0 inv
X285 n284 n285 vdd 0 inv
X286 n285 n286 vdd 0 inv
X287 n286 n287 vdd 0 inv
X288 n287 n288 vdd 0 inv
X289 n288 n289 vdd 0 inv
X290 n289 n290 vdd 0 inv
X291 n290 n291 vdd 0 inv
X292 n291 n292 vdd 0 inv
X293 n292 n293 vdd 0 inv
X294 n293 n294 vdd 0 inv
X295 n294 n295 vdd 0 inv
X296 n295 n296 vdd 0 inv
X297 n296 n297 vdd 0 inv
X298 n297 n298 vdd 0 inv
X299 n298 n299 vdd 0 inv
X300 n299 n300 vdd 0 inv
X301 n300 n301 vdd 0 inv
X302 n301 n302 vdd 0 inv
X303 n302 n303 vdd 0 inv
X304 n303 n304 vdd 0 inv
X305 n304 n305 vdd 0 inv
X306 n305 n306 vdd 0 inv
X307 n306 n307 vdd 0 inv
X308 n307 n308 vdd 0 inv
X309 n308 n309 vdd 0 inv
X310 n309 n310 vdd 0 inv
X311 n310 n311 vdd 0 inv
X312 n311 n312 vdd 0 inv
X313 n312 n313 vdd 0 inv
X314 n313 n314 vdd 0 inv
X315 n314 n315 vdd 0 inv
X316 n315 n316 vdd 0 inv
X317 n316 n317 vdd 0 inv
X318 n317 n318 vdd 0 inv
X319 n318 n319 vdd 0 inv
X320 n319 n320 vdd 0 inv
X321 n320 n321 vdd 0 inv
X322 n321 n322 vdd 0 inv
X323 n322 n323 vdd 0 inv
X324 n323 n324 vdd 0 inv
X325 n324 n325 vdd 0 inv
X326 n325 n326 vdd 0 inv
X327 n326 n327 vdd 0 inv
X328 n327 n328 vdd 0 inv
X329 n328 n329 vdd 0 inv
X330 n329 n330 vdd 0 inv
X331 n330 n331 vdd 0 inv
X332 n331 n332 vdd 0 inv
X333 n332 n333 vdd 0 inv
X334 n333 n334 vdd 0 inv
X335 n334 n335 vdd 0 inv
X336 n335 n336 vdd 0 inv
X337 n336 n337 vdd 0 inv
X338 n337 n338 vdd 0 inv
X339 n338 n339 vdd 0 inv
X340 n339 n340 vdd 0 inv
X341 n340 n341 vdd 0 inv
X342 n341 n342 vdd 0 inv
X343 n342 n343 vdd 0 inv
X344 n343 n344 vdd 0 inv
X345 n344 n345 vdd 0 inv
X346 n345 n346 vdd 0 inv
X347 n346 n347 vdd 0 inv
X348 n347 n348 vdd 0 inv
X349 n348 n349 vdd 0 inv
X350 n349 n350 vdd 0 inv
X351 n350 n351 vdd 0 inv
X352 n351 n352 vdd 0 inv
X353 n352 n353 vdd 0 inv
X354 n353 n354 vdd 0 inv
X355 n354 n355 vdd 0 inv
X356 n355 n356 vdd 0 inv
X357 n356 n357 vdd 0 inv
X358 n357 n358 vdd 0 inv
X359 n358 n359 vdd 0 inv
X360 n359 n360 vdd 0 inv
X361 n360 n361 vdd 0 inv
X362 n361 n362 vdd 0 inv
X363 n362 n363 vdd 0 inv
X364 n363 n364 vdd 0 inv
X365 n364 n365 vdd 0 inv
X366 n365 n366 vdd 0 inv
X367 n366 n367 vdd 0 inv
X368 n367 n368 vdd 0 inv
X369 n368 n369 vdd 0 inv
X370 n369 n370 vdd 0 inv
X371 n370 n371 vdd 0 inv
X372 n371 n372 vdd 0 inv
X373 n372 n373 vdd 0 inv
X374 n373 n374 vdd 0 inv
X375 n374 n375 vdd 0 inv
X376 n375 n376 vdd 0 inv
X377 n376 n377 vdd 0 inv
X378 n377 n378 vdd 0 inv
X379 n378 n379 vdd 0 inv
X380 n379 n380 vdd 0 inv
X381 n380 n381 vdd 0 inv
X382 n381 n382 vdd 0 inv
X383 n382 n383 vdd 0 inv
X384 n383 n384 vdd 0 inv
X385 n384 n385 vdd 0 inv
X386 n385 n386 vdd 0 inv
X387 n386 n387 vdd 0 inv
X388 n387 n388 vdd 0 inv
X389 n388 n389 vdd 0 inv
X390 n389 n390 vdd 0 inv
X391 n390 n391 vdd 0 inv
X392 n391 n392 vdd 0 inv
X393 n392 n393 vdd 0 inv
X394 n393 n394 vdd 0 inv
X395 n394 n395 vdd 0 inv
X396 n395 n396 vdd 0 inv
X397 n396 n397 vdd 0 inv
X398 n397 n398 vdd 0 inv
X399 n398 n399 vdd 0 inv
X400 n399 n400 vdd 0 inv
X401 n400 n401 vdd 0 inv
X402 n401 n402 vdd 0 inv
X403 n402 n403 vdd 0 inv
X404 n403 n404 vdd 0 inv
X405 n404 n405 vdd 0 inv
X406 n405 n406 vdd 0 inv
X407 n406 n407 vdd 0 inv
X408 n407 n408 vdd 0 inv
X409 n408 n409 vdd 0 inv
X410 n409 n410 vdd 0 inv
X411 n410 n411 vdd 0 inv
X412 n411 n412 vdd 0 inv
X413 n412 n413 vdd 0 inv
X414 n413 n414 vdd 0 inv
X415 n414 n415 vdd 0 inv
X416 n415 n416 vdd 0 inv
X417 n416 n417 vdd 0 inv
X418 n417 n418 vdd 0 inv
X419 n418 n419 vdd 0 inv
X420 n419 n420 vdd 0 inv
X421 n420 n421 vdd 0 inv
X422 n421 n422 vdd 0 inv
X423 n422 n423 vdd 0 inv
X424 n423 n424 vdd 0 inv
X425 n424 n425 vdd 0 inv
X426 n425 n426 vdd 0 inv
X427 n426 n427 vdd 0 inv
X428 n427 n428 vdd 0 inv
X429 n428 n429 vdd 0 inv
X430 n429 n430 vdd 0 inv
X431 n430 n431 vdd 0 inv
X432 n431 n432 vdd 0 inv
X433 n432 n433 vdd 0 inv
X434 n433 n434 vdd 0 inv
X435 n434 n435 vdd 0 inv
X436 n435 n436 vdd 0 inv
X437 n436 n437 vdd 0 inv
X438 n437 n438 vdd 0 inv
X439 n438 n439 vdd 0 inv
X440 n439 n440 vdd 0 inv
X441 n440 n441 vdd 0 inv
X442 n441 n442 vdd 0 inv
X443 n442 n443 vdd 0 inv
X444 n443 n444 vdd 0 inv
X445 n444 n445 vdd 0 inv
X446 n445 n446 vdd 0 inv
X447 n446 n447 vdd 0 inv
X448 n447 n448 vdd 0 inv
X449 n448 n449 vdd 0 inv
X450 n449 n450 vdd 0 inv
X451 n450 n451 vdd 0 inv
X452 n451 n452 vdd 0 inv
X453 n452 n453 vdd 0 inv
X454 n453 n454 vdd 0 inv
X455 n454 n455 vdd 0 inv
X456 n455 n456 vdd 0 inv
X457 n456 n457 vdd 0 inv
X458 n457 n458 vdd 0 inv
X459 n458 n459 vdd 0 inv
X460 n459 n460 vdd 0 inv
X461 n460 n461 vdd 0 inv
X462 n461 n462 vdd 0 inv
X463 n462 n463 vdd 0 inv
X464 n463 n464 vdd 0 inv
X465 n464 n465 vdd 0 inv
X466 n465 n466 vdd 0 inv
X467 n466 n467 vdd 0 inv
X468 n467 n468 vdd 0 inv
X469 n468 n469 vdd 0 inv
X470 n469 n470 vdd 0 inv
X471 n470 n471 vdd 0 inv
X472 n471 n472 vdd 0 inv
X473 n472 n473 vdd 0 inv
X474 n473 n474 vdd 0 inv
X475 n474 n475 vdd 0 inv
X476 n475 n476 vdd 0 inv
X477 n476 n477 vdd 0 inv
X478 n477 n478 vdd 0 inv
X479 n478 n479 vdd 0 inv
X480 n479 n480 vdd 0 inv
X481 n480 n481 vdd 0 inv
X482 n481 n482 vdd 0 inv
X483 n482 n483 vdd 0 inv
X484 n483 n484 vdd 0 inv
X485 n484 n485 vdd 0 inv
X486 n485 n486 vdd 0 inv
X487 n486 n487 vdd 0 inv
X488 n487 n488 vdd 0 inv
X489 n488 n489 vdd 0 inv
X490 n489 n490 vdd 0 inv
X491 n490 n491 vdd 0 inv
X492 n491 n492 vdd 0 inv
X493 n492 n493 vdd 0 inv
X494 n493 n494 vdd 0 inv
X495 n494 n495 vdd 0 inv
X496 n495 n496 vdd 0 inv
X497 n496 n497 vdd 0 inv
X498 n497 n498 vdd 0 inv
X499 n498 n499 vdd 0 inv
X500 n499 out vdd 0 inv

* Load capacitance
CL out 0 1e-14

.control
  set num_threads = 2

  * load osdi files
  pre_osdi ../../osdi/sg13g2_moslv_tailored.osdi

  * save only so that storage does not scale with chain size
  save v(in) v(out)

  tran 0.1n 110n 0 0.1n

  * print performance and resource usage
  rusage all

  * write output to file
  set wr_vecnames
  set wr_singlescale
  wrdata check/tb_moslv_inv_chain_N500_tt_tailored.sp.out v(in) v(out)
  * clean exit after simulation
  set noaskquit
  quit
.endc

.end
