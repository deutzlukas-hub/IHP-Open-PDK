//******************************************************************************
//                                                                             *
// Library:      SG13G2_dev                                                    *
// Technologies: SG13G2                                                        *
//                                                                             *
// Model:        PSP 103.8.2 (PSPNQS variant)                                  *
// Revision:     200310                                                        *
//                                                                             *
//******************************************************************************
//                                                                             *
// Copyright 2023 IHP PDK Authors                                              *
//                                                                             *
// Licensed under the Apache License, Version 2.0 (the "License");             *
// you may not use this file except in compliance with the License.            *
// You may obtain a copy of the License at                                     *
//                                                                             *
//     https://www.apache.org/licenses/LICENSE-2.0                             *
//                                                                             *
// Unless required by applicable law or agreed to in writing, software         *
// distributed under the License is distributed on an "AS IS" BASIS,           *
// WITHOUT WARRANTIES OR CONDITIONS OF ANY KIND, either express or implied.    *
// See the License for the specific language governing permissions and         *
// limitations under the License.                                              *
//                                                                             *
//******************************************************************************
//
//
//******************************************************************************
// NMOS MOSLV RF paramset                                       *
//******************************************************************************

(* desc="sg13g2 Low-Voltage NMOS RF paramset without mismatch" *)
paramset sg13g2_lv_nmos_psp PSPNQS103VA
    parameter real w = 0.35u from [0.15u:10u];
    parameter real l = 0.34u from [0.13u:10u];
    parameter integer ng = 1 from [1:inf);
    parameter real m = 1.0 from (0:inf);
    parameter integer mm_ok = 0 from [0:0];
    parameter real trise = 0.0;
    parameter real as = 0.0 from [0:inf);
    parameter real ad = 0.0 from [0:inf);
    parameter real pd = 0.0 from [0:inf);
    parameter real ps = 0.0 from [0:inf);
    parameter integer pre_layout = 1 from [0:1];
    parameter integer rfmode = 1 from [1:1];
    .LEVEL = 103.8;
    .TYPE = 1;
    .W = w;
    .L = l;
    .NF = ng;
    .MULT = m;
    .AS = as;
    .AD = ad;
    .PS = ps;
    .PD = pd;
    .TR = 27.0;
    .DTA = trise;
    .NGCON = 2.0;
    .DELVTO = 0.0;
    .FACTUO = 1.0;
    .SWGEO = 1.0;
    .SWIGATE = 1.0;
    .SWIMPACT = 1.0;
    .SWGIDL = 1.0;
    .SWJUNCAP = 3.0;
    .SWJUNASYM = 0.0;
    .SWNUD = 0.0;
    .SWEDGE = 0.0;
    .SWDELVTAC = 0.0;
    .SWIGN = 1.0;
    .QMC = 1.0;
    .LVARO = 0.0;
    .LVARL = 0.0;
    .LVARW = 0.0;
    .LAP = 2.9423e-08;
    .WVARO = 0.0;
    .WVARL = 0.0;
    .WVARW = 0.0;
    .WOT = -1e-08;
    .DLQ = -1.3721e-08 - ((1 - pre_layout) * 2e-08) + rfmode * (-1.5368e-08 + (ng < 3 ? 4e-08 : 0));
    .DWQ = -1e-08 + rfmode * 4.8062e-07;
    .VFBO = -0.94312 * corner_moslv.sg13g2_lv_nmos_vfbo;
    .VFBL = 0.013965;
    .VFBW = -0.027122;
    .VFBLW = 0.0044814;
    .STVFBO = 0.00068785;
    .STVFBL = 2.8624e-05;
    .STVFBW = -1.8689e-05;
    .STVFBLW = 5.1435e-07;
    .ST2VFBO = 0.0;
    .TOXO = 2.2404e-09 * corner_moslv.sg13g2_lv_nmos_toxo;
    .EPSROXO = 3.9;
    .NSUBO = 1.0483e+23;
    .NSUBW = 7.5708;
    .WSEG = 5.3426e-06;
    .NPCK = 1.743e+21;
    .NPCKW = -1.484;
    .WSEGP = 1e-08;
    .LPCK = 3.171e-07;
    .LPCKW = 0.0;
    .FOL1 = -0.0091066;
    .FOL2 = 0.0021139;
    .FACNEFFACO = 1.0;
    .FACNEFFACL = 0.0;
    .FACNEFFACW = 0.0;
    .FACNEFFACLW = 0.0;
    .GFACNUDO = 1.0;
    .GFACNUDL = 0.0;
    .GFACNUDLEXP = 1.0;
    .GFACNUDW = 0.0;
    .GFACNUDLW = 0.0;
    .VSBNUDO = 0.0;
    .DVSBNUDO = 1.0;
    .VNSUBO = 0.0;
    .NSLPO = 0.05;
    .DNSUBO = 4.4409e-16;
    .DPHIBO = -0.25737 * corner_moslv.sg13g2_lv_nmos_dphibo;
    .DPHIBL = 0.24027 * corner_moslv.sg13g2_lv_nmos_dphibl;
    .DPHIBLEXP = 0.068979;
    .DPHIBW = 0.0168 * corner_moslv.sg13g2_lv_nmos_dphibw;
    .DPHIBLW = -0.0036959 * corner_moslv.sg13g2_lv_nmos_dphiblw;
    .DELVTACO = 0.0;
    .DELVTACL = 0.0;
    .DELVTACLEXP = 1.0;
    .DELVTACW = 0.0;
    .DELVTACLW = 0.0;
    .NPO = 4.6457e+26;
    .NPL = 0.0;
    .TOXOVO = 2.2404e-09 * corner_moslv.sg13g2_lv_nmos_toxovo;
    .TOXOVDO = 2e-09;
    .LOV = 2.9423e-08 - (1 - pre_layout) * 9e-09;
    .LOVD = 0.0;
    .NOVO = 3.5714e+25;
    .NOVDO = 5e+25;
    .CTO = 0.054556;
    .CTL = 0.015058 * corner_moslv.sg13g2_lv_nmos_ctl;
    .CTLEXP = 0.85719;
    .CTW = -0.096878;
    .CTLW = 0.008767;
    .CTGO = 0.0;
    .CTBO = 0.0;
    .STCTO = 1.0;
    .CFL = 8.9001e-08;
    .CFLEXP = 3.9688;
    .CFW = -0.17956;
    .CFBO = 0.6952;
    .CFDO = 0.0;
    .PSCEL = 0.0;
    .PSCELEXP = 2.0;
    .PSCEW = 0.0;
    .PSCEBO = 0.0;
    .PSCEDO = 0.0;
    .UO = 0.045582;
    .FBET1 = 12.168;
    .FBET1W = 0.38931;
    .LP1 = 5.1674e-09;
    .LP1W = -0.1544;
    .FBET2 = -2.302;
    .LP2 = 1.9441e-08;
    .BETW1 = -0.020925;
    .BETW2 = 0.0087681;
    .WBET = 5.9171e-08;
    .STBETO = 2.4165;
    .STBETL = -0.036997;
    .STBETW = 0.0046613;
    .STBETLW = 0.0062828;
    .MUEO = 0.77874;
    .MUEW = 0.030943 * corner_moslv.sg13g2_lv_nmos_muew;
    .STMUEO = 0.98971;
    .THEMUO = 2.0546 * corner_moslv.sg13g2_lv_nmos_themuo;
    .STTHEMUO = 4.441e-15;
    .CSO = 0.3164;
    .CSL = 0.12341;
    .CSLEXP = 1.1398;
    .CSW = 0.19805;
    .CSLW = -0.00044184;
    .STCSO = 2.9406;
    .THECSO = 1.1822;
    .STTHECSO = 0.0;
    .XCORO = 0.053934;
    .XCORL = -0.11292;
    .XCORW = -0.10913;
    .XCORLW = -0.014959;
    .STXCORO = 2.0;
    .FETAO = 1.0;
    .RSW1 = 130.0 * corner_moslv.sg13g2_lv_nmos_rsw1;
    .RSW2 = 0.0;
    .STRSO = -0.49693;
    .RSBO = -0.099725;
    .RSGO = 0.074518;
    .THESATO = 0.39843;
    .THESATL = 0.43388 * corner_moslv.sg13g2_lv_nmos_thesatl;
    .THESATLEXP = 1.0316;
    .THESATW = 0.12825 * corner_moslv.sg13g2_lv_nmos_thesatw;
    .THESATLW = -0.0044 * corner_moslv.sg13g2_lv_nmos_thesatlw;
    .STTHESATO = 2.7784;
    .STTHESATL = -0.091893;
    .STTHESATW = -0.065908;
    .STTHESATLW = 0.01292;
    .THESATBO = 0.08213;
    .THESATGO = 0.1146;
    .AXO = 13.547;
    .AXL = 1.0186;
    .ALPL = 0.0088345;
    .ALPLEXP = 0.68143;
    .ALPW = 1.0825;
    .ALP1L1 = 0.021138;
    .ALP1LEXP = 0.25;
    .ALP1L2 = 0.04044;
    .ALP1W = -0.077622;
    .ALP2L1 = 2.6817;
    .ALP2LEXP = 0.25;
    .ALP2L2 = 0.0;
    .ALP2W = -0.13012;
    .VPO = 0.32224;
    .A1O = 6.239;
    .A1L = 0.052176;
    .A1W = -0.052179;
    .A2O = 17.75;
    .STA2O = 0.068723;
    .A3O = 0.708;
    .A3L = -0.045201;
    .A3W = -0.041992;
    .A4O = 0.04649;
    .A4L = 0.0;
    .A4W = 1.581e-16;
    .GCOO = 10.0;
    .IGINVLW = 121290.0 * (1 + 2.4761e-07 / l) * (1 - 2.1167e-08 / w);
    .IGOVW = 3026.8;
    .IGOVDW = 0.0;
    .STIGO = 2.9949;
    .GC2O = 0.8413;
    .GC3O = -0.4698;
    .CHIBO = 3.1;
    .AGIDLW = 0.001262;
    .AGIDLDW = 0.0;
    .BGIDLO = 19.92;
    .BGIDLDO = 41.0;
    .STBGIDLO = 0.0;
    .STBGIDLDO = 0.0;
    .CGIDLO = 0.06641;
    .CGIDLDO = 0.0;
    .CGBOVL = 4.4409e-28;
    .CFRDW = 0.0;
    .FNTO = 1.0;
    .FNTEXCL = 0.0;
    .NFALW = 7.616e+25;
    .NFBLW = 1026000000.0;
    .NFCLW = -5e-08;
    .EFO = 1.0;
    .LINTNOI = -3.7e-08;
    .ALPNOI = 1.869;
    .WEDGE = 1e-08;
    .WEDGEW = 0.0;
    .VFBEDGEO = -1.0;
    .STVFBEDGEO = 0.0005;
    .STVFBEDGEL = 0.0;
    .STVFBEDGEW = 0.0;
    .STVFBEDGELW = 0.0;
    .DPHIBEDGEO = 0.0;
    .DPHIBEDGEL = 0.0;
    .DPHIBEDGELEXP = 1.0;
    .DPHIBEDGEW = 0.0;
    .DPHIBEDGELW = 0.0;
    .NSUBEDGEO = 5e+23;
    .NSUBEDGEL = 0.0;
    .NSUBEDGELEXP = 1.0;
    .NSUBEDGEW = 0.0;
    .NSUBEDGELW = 0.0;
    .CTEDGEO = 0.0;
    .CTEDGEL = 0.0;
    .CTEDGELEXP = 1.0;
    .FBETEDGE = 0.0;
    .LPEDGE = 1e-08;
    .BETEDGEW = 0.0;
    .STBETEDGEO = 1.0;
    .STBETEDGEL = 0.0;
    .STBETEDGEW = 0.0;
    .STBETEDGELW = 0.0;
    .PSCEEDGEL = 0.0;
    .PSCEEDGELEXP = 2.0;
    .PSCEEDGEW = 0.0;
    .PSCEBEDGEO = 0.0;
    .PSCEDEDGEO = 0.0;
    .CFEDGEL = 0.0;
    .CFEDGELEXP = 2.0;
    .CFEDGEW = 0.0;
    .CFDEDGEO = 0.0;
    .CFBEDGEO = 0.0;
    .FNTEDGEO = 1.0;
    .NFAEDGELW = 8e+22;
    .NFBEDGELW = 30000000.0;
    .NFCEDGELW = 0.0;
    .EFEDGEO = 1.0;
    .SAREF = 1e-06;
    .SBREF = 1e-06;
    .WLOD = 0.0;
    .KUO = 0.0;
    .KVSAT = 0.0;
    .TKUO = 0.0;
    .LKUO = 0.0;
    .WKUO = 0.0;
    .PKUO = 0.0;
    .LLODKUO = 0.0;
    .WLODKUO = 0.0;
    .KVTHO = 0.0;
    .LKVTHO = 0.0;
    .WKVTHO = 0.0;
    .PKVTHO = 0.0;
    .LLODVTH = 0.0;
    .WLODVTH = 0.0;
    .STETAO = 0.0;
    .LODETAO = 1.0;
    .SCREF = 1e-06;
    .WEB = 0.0;
    .WEC = 0.0;
    .KVTHOWEO = 0.0;
    .KVTHOWEL = 0.0;
    .KVTHOWEW = 0.0;
    .KVTHOWELW = 0.0;
    .KUOWEO = 0.0;
    .KUOWEL = 0.0;
    .KUOWEW = 0.0;
    .KUOWELW = 0.0;
    .TRJ = 21.0;
    .SWJUNEXP = 0.0;
    .IMAX = 0.0015358;
    .FREV = 1000.0;
    .CJORBOT = 0.00097636 * corner_moslv.sg13g2_lv_nmos_cjorbot;
    .CJORSTI = 2.5279e-11 * corner_moslv.sg13g2_lv_nmos_cjorsti;
    .CJORGAT = 3e-11 * corner_moslv.sg13g2_lv_nmos_cjorgat;
    .VBIRBOT = 0.70829;
    .VBIRSTI = 0.79368;
    .VBIRGAT = 2.0;
    .PBOT = 0.31309;
    .PSTI = 0.27362;
    .PGAT = 0.5424;
    .CJORBOTD = 0.001;
    .CJORSTID = 1e-09;
    .CJORGATD = 1e-09;
    .VBIRBOTD = 1.0;
    .VBIRSTID = 1.0;
    .VBIRGATD = 1.0;
    .PBOTD = 0.5;
    .PSTID = 0.5;
    .PGATD = 0.5;
    .PHIGBOT = 1.1136;
    .PHIGSTI = 1.3844;
    .PHIGGAT = 1.16;
    .IDSATRBOT = 6.3087e-08;
    .IDSATRSTI = 1.9278e-15;
    .IDSATRGAT = 0.0;
    .CSRHBOT = 100.0;
    .CSRHSTI = 0.0001;
    .CSRHGAT = 6.682e-06;
    .XJUNSTI = 1.5783e-07;
    .XJUNGAT = 0.0001;
    .PHIGBOTD = 1.16;
    .PHIGSTID = 1.16;
    .PHIGGATD = 1.16;
    .IDSATRBOTD = 1e-12;
    .IDSATRSTID = 1e-18;
    .IDSATRGATD = 1e-18;
    .CSRHBOTD = 100.0;
    .CSRHSTID = 0.0001;
    .CSRHGATD = 0.0001;
    .XJUNSTID = 1e-07;
    .XJUNGATD = 1e-07;
    .CTATBOT = 100.0;
    .CTATSTI = 0.0001;
    .CTATGAT = 0.0001;
    .MEFFTATBOT = 5.204;
    .MEFFTATSTI = 3.364;
    .MEFFTATGAT = 0.25;
    .CTATBOTD = 100.0;
    .CTATSTID = 0.0001;
    .CTATGATD = 0.0001;
    .MEFFTATBOTD = 0.25;
    .MEFFTATSTID = 0.25;
    .MEFFTATGATD = 0.25;
    .CBBTBOT = 1e-12;
    .CBBTSTI = 1e-21;
    .CBBTGAT = 1e-18;
    .FBBTRBOT = 1000000000.0;
    .FBBTRSTI = 1000000000.0;
    .FBBTRGAT = 1000000000.0;
    .STFBBTBOT = -0.001;
    .STFBBTSTI = -0.001;
    .STFBBTGAT = -0.001;
    .CBBTBOTD = 1e-12;
    .CBBTSTID = 1e-18;
    .CBBTGATD = 1e-18;
    .FBBTRBOTD = 1000000000.0;
    .FBBTRSTID = 1000000000.0;
    .FBBTRGATD = 1000000000.0;
    .STFBBTBOTD = -0.001;
    .STFBBTSTID = -0.001;
    .STFBBTGATD = -0.001;
    .VBRBOT = 10.0;
    .VBRSTI = 10.0;
    .VBRGAT = 10.0;
    .PBRBOT = 4.0;
    .PBRSTI = 4.0;
    .PBRGAT = 4.0;
    .VBRBOTD = 10.0;
    .VBRSTID = 10.0;
    .VBRGATD = 10.0;
    .PBRBOTD = 4.0;
    .PBRSTID = 4.0;
    .PBRGATD = 4.0;
    .VJUNREF = 2.5;
    .FJUNQ = 0.03;
    .VJUNREFD = 2.5;
    .FJUNQD = 0.03;
    .RINT = 1.3025e-11;
    .RVPOLY = 0.0;
    .DLSIL = 0.0;
    .RSH = 0.0;
    .RSHD = 0.0;
    .MUNQSO = 1.0;
    .SWNQS = rfmode * 5.0;
    .CFRW = ((1 - rfmode) * 2e-16 + rfmode * (1e-18 + pre_layout * (ng > 0 ? 3.8525e-17 : 0))) / ng;
    .RSHG = rfmode * 3.0;
    .RGO = rfmode * 40.0;
    .RBULKO = rfmode * 0.002 * ng / w;
    .RWELLO = rfmode * 0.002 * ng / w;
    .RJUNSO = rfmode * 5000.0 * l / w;
    .RJUNDO = rfmode * 5000.0 * l / w;
    .SWSOA = 0.0;
    .VGS_MAX = 1.6;
    .VGD_MAX = 1.6;
    .VGB_MAX = 1.6;
    .VDS_MAX = 1.6;
    .VDB_MAX = 1.6;
    .VSB_MAX = 1.6;
endparamset

(* desc="sg13g2 Low-Voltage NMOS RF paramset with mismatch" *)
paramset sg13g2_lv_nmos_psp PSPNQS103VA
    parameter real w = 0.35u from [0.15u:10u];
    parameter real l = 0.34u from [0.13u:10u];
    parameter integer ng = 1 from [1:inf);
    parameter real m = 1.0 from (0:inf);
    parameter integer mm_ok = 1 from [1:1];
    parameter real trise = 0.0;
    parameter real as = 0.0 from [0:inf);
    parameter real ad = 0.0 from [0:inf);
    parameter real pd = 0.0 from [0:inf);
    parameter real ps = 0.0 from [0:inf);
    parameter integer pre_layout = 1 from [0:1];
    parameter integer rfmode = 1 from [1:1];
    // local mismatch parameters (zero-mean offset, matches moscap convention)
    localparam real mm_scale = sqrt(m * l * w * 1.0e12);
    localparam real delvto_sig = 0.0039 / mm_scale;
    localparam real factuo_sig = 0.0050 / mm_scale;
    localparam real mm_w = $rdist_normal(1, 0, 4e-9, "instance");
    localparam real mm_l = $rdist_normal(2, 0, 2e-9, "instance");
    localparam real mm_delvto = $rdist_normal(3, 0, delvto_sig, "instance");
    localparam real mm_factuo = $rdist_normal(4, 0, factuo_sig, "instance");
    .LEVEL = 103.8;
    .TYPE = 1;
    .W = w + mm_w;
    .L = l + mm_l;
    .NF = ng;
    .MULT = m;
    .AS = as;
    .AD = ad;
    .PS = ps;
    .PD = pd;
    .TR = 27.0;
    .DTA = trise;
    .NGCON = 2.0;
    .DELVTO = 0.0 + mm_delvto;
    .FACTUO = 1.0 + mm_factuo;
    .SWGEO = 1.0;
    .SWIGATE = 1.0;
    .SWIMPACT = 1.0;
    .SWGIDL = 1.0;
    .SWJUNCAP = 3.0;
    .SWJUNASYM = 0.0;
    .SWNUD = 0.0;
    .SWEDGE = 0.0;
    .SWDELVTAC = 0.0;
    .SWIGN = 1.0;
    .QMC = 1.0;
    .LVARO = 0.0;
    .LVARL = 0.0;
    .LVARW = 0.0;
    .LAP = 2.9423e-08;
    .WVARO = 0.0;
    .WVARL = 0.0;
    .WVARW = 0.0;
    .WOT = -1e-08;
    .DLQ = -1.3721e-08 - ((1 - pre_layout) * 2e-08) + rfmode * (-1.5368e-08 + (ng < 3 ? 4e-08 : 0));
    .DWQ = -1e-08 + rfmode * 4.8062e-07;
    .VFBO = -0.94312 * corner_moslv.sg13g2_lv_nmos_vfbo;
    .VFBL = 0.013965;
    .VFBW = -0.027122;
    .VFBLW = 0.0044814;
    .STVFBO = 0.00068785;
    .STVFBL = 2.8624e-05;
    .STVFBW = -1.8689e-05;
    .STVFBLW = 5.1435e-07;
    .ST2VFBO = 0.0;
    .TOXO = 2.2404e-09 * corner_moslv.sg13g2_lv_nmos_toxo;
    .EPSROXO = 3.9;
    .NSUBO = 1.0483e+23;
    .NSUBW = 7.5708;
    .WSEG = 5.3426e-06;
    .NPCK = 1.743e+21;
    .NPCKW = -1.484;
    .WSEGP = 1e-08;
    .LPCK = 3.171e-07;
    .LPCKW = 0.0;
    .FOL1 = -0.0091066;
    .FOL2 = 0.0021139;
    .FACNEFFACO = 1.0;
    .FACNEFFACL = 0.0;
    .FACNEFFACW = 0.0;
    .FACNEFFACLW = 0.0;
    .GFACNUDO = 1.0;
    .GFACNUDL = 0.0;
    .GFACNUDLEXP = 1.0;
    .GFACNUDW = 0.0;
    .GFACNUDLW = 0.0;
    .VSBNUDO = 0.0;
    .DVSBNUDO = 1.0;
    .VNSUBO = 0.0;
    .NSLPO = 0.05;
    .DNSUBO = 4.4409e-16;
    .DPHIBO = -0.25737 * corner_moslv.sg13g2_lv_nmos_dphibo;
    .DPHIBL = 0.24027 * corner_moslv.sg13g2_lv_nmos_dphibl;
    .DPHIBLEXP = 0.068979;
    .DPHIBW = 0.0168 * corner_moslv.sg13g2_lv_nmos_dphibw;
    .DPHIBLW = -0.0036959 * corner_moslv.sg13g2_lv_nmos_dphiblw;
    .DELVTACO = 0.0;
    .DELVTACL = 0.0;
    .DELVTACLEXP = 1.0;
    .DELVTACW = 0.0;
    .DELVTACLW = 0.0;
    .NPO = 4.6457e+26;
    .NPL = 0.0;
    .TOXOVO = 2.2404e-09 * corner_moslv.sg13g2_lv_nmos_toxovo;
    .TOXOVDO = 2e-09;
    .LOV = 2.9423e-08 - (1 - pre_layout) * 9e-09;
    .LOVD = 0.0;
    .NOVO = 3.5714e+25;
    .NOVDO = 5e+25;
    .CTO = 0.054556;
    .CTL = 0.015058 * corner_moslv.sg13g2_lv_nmos_ctl;
    .CTLEXP = 0.85719;
    .CTW = -0.096878;
    .CTLW = 0.008767;
    .CTGO = 0.0;
    .CTBO = 0.0;
    .STCTO = 1.0;
    .CFL = 8.9001e-08;
    .CFLEXP = 3.9688;
    .CFW = -0.17956;
    .CFBO = 0.6952;
    .CFDO = 0.0;
    .PSCEL = 0.0;
    .PSCELEXP = 2.0;
    .PSCEW = 0.0;
    .PSCEBO = 0.0;
    .PSCEDO = 0.0;
    .UO = 0.045582;
    .FBET1 = 12.168;
    .FBET1W = 0.38931;
    .LP1 = 5.1674e-09;
    .LP1W = -0.1544;
    .FBET2 = -2.302;
    .LP2 = 1.9441e-08;
    .BETW1 = -0.020925;
    .BETW2 = 0.0087681;
    .WBET = 5.9171e-08;
    .STBETO = 2.4165;
    .STBETL = -0.036997;
    .STBETW = 0.0046613;
    .STBETLW = 0.0062828;
    .MUEO = 0.77874;
    .MUEW = 0.030943 * corner_moslv.sg13g2_lv_nmos_muew;
    .STMUEO = 0.98971;
    .THEMUO = 2.0546 * corner_moslv.sg13g2_lv_nmos_themuo;
    .STTHEMUO = 4.441e-15;
    .CSO = 0.3164;
    .CSL = 0.12341;
    .CSLEXP = 1.1398;
    .CSW = 0.19805;
    .CSLW = -0.00044184;
    .STCSO = 2.9406;
    .THECSO = 1.1822;
    .STTHECSO = 0.0;
    .XCORO = 0.053934;
    .XCORL = -0.11292;
    .XCORW = -0.10913;
    .XCORLW = -0.014959;
    .STXCORO = 2.0;
    .FETAO = 1.0;
    .RSW1 = 130.0 * corner_moslv.sg13g2_lv_nmos_rsw1;
    .RSW2 = 0.0;
    .STRSO = -0.49693;
    .RSBO = -0.099725;
    .RSGO = 0.074518;
    .THESATO = 0.39843;
    .THESATL = 0.43388 * corner_moslv.sg13g2_lv_nmos_thesatl;
    .THESATLEXP = 1.0316;
    .THESATW = 0.12825 * corner_moslv.sg13g2_lv_nmos_thesatw;
    .THESATLW = -0.0044 * corner_moslv.sg13g2_lv_nmos_thesatlw;
    .STTHESATO = 2.7784;
    .STTHESATL = -0.091893;
    .STTHESATW = -0.065908;
    .STTHESATLW = 0.01292;
    .THESATBO = 0.08213;
    .THESATGO = 0.1146;
    .AXO = 13.547;
    .AXL = 1.0186;
    .ALPL = 0.0088345;
    .ALPLEXP = 0.68143;
    .ALPW = 1.0825;
    .ALP1L1 = 0.021138;
    .ALP1LEXP = 0.25;
    .ALP1L2 = 0.04044;
    .ALP1W = -0.077622;
    .ALP2L1 = 2.6817;
    .ALP2LEXP = 0.25;
    .ALP2L2 = 0.0;
    .ALP2W = -0.13012;
    .VPO = 0.32224;
    .A1O = 6.239;
    .A1L = 0.052176;
    .A1W = -0.052179;
    .A2O = 17.75;
    .STA2O = 0.068723;
    .A3O = 0.708;
    .A3L = -0.045201;
    .A3W = -0.041992;
    .A4O = 0.04649;
    .A4L = 0.0;
    .A4W = 1.581e-16;
    .GCOO = 10.0;
    .IGINVLW = 121290.0 * (1 + 2.4761e-07 / l) * (1 - 2.1167e-08 / w);
    .IGOVW = 3026.8;
    .IGOVDW = 0.0;
    .STIGO = 2.9949;
    .GC2O = 0.8413;
    .GC3O = -0.4698;
    .CHIBO = 3.1;
    .AGIDLW = 0.001262;
    .AGIDLDW = 0.0;
    .BGIDLO = 19.92;
    .BGIDLDO = 41.0;
    .STBGIDLO = 0.0;
    .STBGIDLDO = 0.0;
    .CGIDLO = 0.06641;
    .CGIDLDO = 0.0;
    .CGBOVL = 4.4409e-28;
    .CFRDW = 0.0;
    .FNTO = 1.0;
    .FNTEXCL = 0.0;
    .NFALW = 7.616e+25;
    .NFBLW = 1026000000.0;
    .NFCLW = -5e-08;
    .EFO = 1.0;
    .LINTNOI = -3.7e-08;
    .ALPNOI = 1.869;
    .WEDGE = 1e-08;
    .WEDGEW = 0.0;
    .VFBEDGEO = -1.0;
    .STVFBEDGEO = 0.0005;
    .STVFBEDGEL = 0.0;
    .STVFBEDGEW = 0.0;
    .STVFBEDGELW = 0.0;
    .DPHIBEDGEO = 0.0;
    .DPHIBEDGEL = 0.0;
    .DPHIBEDGELEXP = 1.0;
    .DPHIBEDGEW = 0.0;
    .DPHIBEDGELW = 0.0;
    .NSUBEDGEO = 5e+23;
    .NSUBEDGEL = 0.0;
    .NSUBEDGELEXP = 1.0;
    .NSUBEDGEW = 0.0;
    .NSUBEDGELW = 0.0;
    .CTEDGEO = 0.0;
    .CTEDGEL = 0.0;
    .CTEDGELEXP = 1.0;
    .FBETEDGE = 0.0;
    .LPEDGE = 1e-08;
    .BETEDGEW = 0.0;
    .STBETEDGEO = 1.0;
    .STBETEDGEL = 0.0;
    .STBETEDGEW = 0.0;
    .STBETEDGELW = 0.0;
    .PSCEEDGEL = 0.0;
    .PSCEEDGELEXP = 2.0;
    .PSCEEDGEW = 0.0;
    .PSCEBEDGEO = 0.0;
    .PSCEDEDGEO = 0.0;
    .CFEDGEL = 0.0;
    .CFEDGELEXP = 2.0;
    .CFEDGEW = 0.0;
    .CFDEDGEO = 0.0;
    .CFBEDGEO = 0.0;
    .FNTEDGEO = 1.0;
    .NFAEDGELW = 8e+22;
    .NFBEDGELW = 30000000.0;
    .NFCEDGELW = 0.0;
    .EFEDGEO = 1.0;
    .SAREF = 1e-06;
    .SBREF = 1e-06;
    .WLOD = 0.0;
    .KUO = 0.0;
    .KVSAT = 0.0;
    .TKUO = 0.0;
    .LKUO = 0.0;
    .WKUO = 0.0;
    .PKUO = 0.0;
    .LLODKUO = 0.0;
    .WLODKUO = 0.0;
    .KVTHO = 0.0;
    .LKVTHO = 0.0;
    .WKVTHO = 0.0;
    .PKVTHO = 0.0;
    .LLODVTH = 0.0;
    .WLODVTH = 0.0;
    .STETAO = 0.0;
    .LODETAO = 1.0;
    .SCREF = 1e-06;
    .WEB = 0.0;
    .WEC = 0.0;
    .KVTHOWEO = 0.0;
    .KVTHOWEL = 0.0;
    .KVTHOWEW = 0.0;
    .KVTHOWELW = 0.0;
    .KUOWEO = 0.0;
    .KUOWEL = 0.0;
    .KUOWEW = 0.0;
    .KUOWELW = 0.0;
    .TRJ = 21.0;
    .SWJUNEXP = 0.0;
    .IMAX = 0.0015358;
    .FREV = 1000.0;
    .CJORBOT = 0.00097636 * corner_moslv.sg13g2_lv_nmos_cjorbot;
    .CJORSTI = 2.5279e-11 * corner_moslv.sg13g2_lv_nmos_cjorsti;
    .CJORGAT = 3e-11 * corner_moslv.sg13g2_lv_nmos_cjorgat;
    .VBIRBOT = 0.70829;
    .VBIRSTI = 0.79368;
    .VBIRGAT = 2.0;
    .PBOT = 0.31309;
    .PSTI = 0.27362;
    .PGAT = 0.5424;
    .CJORBOTD = 0.001;
    .CJORSTID = 1e-09;
    .CJORGATD = 1e-09;
    .VBIRBOTD = 1.0;
    .VBIRSTID = 1.0;
    .VBIRGATD = 1.0;
    .PBOTD = 0.5;
    .PSTID = 0.5;
    .PGATD = 0.5;
    .PHIGBOT = 1.1136;
    .PHIGSTI = 1.3844;
    .PHIGGAT = 1.16;
    .IDSATRBOT = 6.3087e-08;
    .IDSATRSTI = 1.9278e-15;
    .IDSATRGAT = 0.0;
    .CSRHBOT = 100.0;
    .CSRHSTI = 0.0001;
    .CSRHGAT = 6.682e-06;
    .XJUNSTI = 1.5783e-07;
    .XJUNGAT = 0.0001;
    .PHIGBOTD = 1.16;
    .PHIGSTID = 1.16;
    .PHIGGATD = 1.16;
    .IDSATRBOTD = 1e-12;
    .IDSATRSTID = 1e-18;
    .IDSATRGATD = 1e-18;
    .CSRHBOTD = 100.0;
    .CSRHSTID = 0.0001;
    .CSRHGATD = 0.0001;
    .XJUNSTID = 1e-07;
    .XJUNGATD = 1e-07;
    .CTATBOT = 100.0;
    .CTATSTI = 0.0001;
    .CTATGAT = 0.0001;
    .MEFFTATBOT = 5.204;
    .MEFFTATSTI = 3.364;
    .MEFFTATGAT = 0.25;
    .CTATBOTD = 100.0;
    .CTATSTID = 0.0001;
    .CTATGATD = 0.0001;
    .MEFFTATBOTD = 0.25;
    .MEFFTATSTID = 0.25;
    .MEFFTATGATD = 0.25;
    .CBBTBOT = 1e-12;
    .CBBTSTI = 1e-21;
    .CBBTGAT = 1e-18;
    .FBBTRBOT = 1000000000.0;
    .FBBTRSTI = 1000000000.0;
    .FBBTRGAT = 1000000000.0;
    .STFBBTBOT = -0.001;
    .STFBBTSTI = -0.001;
    .STFBBTGAT = -0.001;
    .CBBTBOTD = 1e-12;
    .CBBTSTID = 1e-18;
    .CBBTGATD = 1e-18;
    .FBBTRBOTD = 1000000000.0;
    .FBBTRSTID = 1000000000.0;
    .FBBTRGATD = 1000000000.0;
    .STFBBTBOTD = -0.001;
    .STFBBTSTID = -0.001;
    .STFBBTGATD = -0.001;
    .VBRBOT = 10.0;
    .VBRSTI = 10.0;
    .VBRGAT = 10.0;
    .PBRBOT = 4.0;
    .PBRSTI = 4.0;
    .PBRGAT = 4.0;
    .VBRBOTD = 10.0;
    .VBRSTID = 10.0;
    .VBRGATD = 10.0;
    .PBRBOTD = 4.0;
    .PBRSTID = 4.0;
    .PBRGATD = 4.0;
    .VJUNREF = 2.5;
    .FJUNQ = 0.03;
    .VJUNREFD = 2.5;
    .FJUNQD = 0.03;
    .RINT = 1.3025e-11;
    .RVPOLY = 0.0;
    .DLSIL = 0.0;
    .RSH = 0.0;
    .RSHD = 0.0;
    .MUNQSO = 1.0;
    .SWNQS = rfmode * 5.0;
    .CFRW = ((1 - rfmode) * 2e-16 + rfmode * (1e-18 + pre_layout * (ng > 0 ? 3.8525e-17 : 0))) / ng;
    .RSHG = rfmode * 3.0;
    .RGO = rfmode * 40.0;
    .RBULKO = rfmode * 0.002 * ng / w;
    .RWELLO = rfmode * 0.002 * ng / w;
    .RJUNSO = rfmode * 5000.0 * l / w;
    .RJUNDO = rfmode * 5000.0 * l / w;
    .SWSOA = 0.0;
    .VGS_MAX = 1.6;
    .VGD_MAX = 1.6;
    .VGB_MAX = 1.6;
    .VDS_MAX = 1.6;
    .VDB_MAX = 1.6;
    .VSB_MAX = 1.6;
endparamset
