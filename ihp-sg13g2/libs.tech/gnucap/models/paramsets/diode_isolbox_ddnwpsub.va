//******************************************************************************
//                                                                             *
// Copyright 2026 IHP PDK Authors                                              *
//                                                                             *
// Licensed under the Apache License, Version 2.0 (the "License");             *
// you may not use this file except in compliance with the License.            *
// You may obtain a copy of the License at                                     *
//                                                                             *
//     https://www.apache.org/licenses/LICENSE-2.0                             *
//                                                                             *
// Unless required by applicable law or agreed to in writing, software         *
// distributed under the License is distributed on an "AS IS" BASIS,           *
// WITHOUT WARRANTIES OR CONDITIONS OF ANY KIND, either express or implied.    *
// See the License for the specific language governing permissions and         *
// limitations under the License.                                              *
//                                                                             *
//******************************************************************************

//*************************************
// Device: isolbox
// Testfield: T327
// Technology: all IHP 0u13 technologies (SG13S, SG13G2)
// Lot: PQE701
// Wafer: 08
// Chip: 6,4;6,5
// DUTs: IS102..107;IS202...IS210
// Temperature range: -40°C ... +125°C
// DC range: -80V ... 1V (depending on pWellBlock width)
// Operator: Teply
// Date: 2016-03-31
// Remarks: bipolar effect NOT taken into account
//          model is designed for reverse direction of the diodes
//          NO statistics
//          initial model
//************************************

//******************************************************************************
// isolbox ddnwpsub paramsets
//******************************************************************************

(* desc="dsub_mod: SPICE area diode of nwell-sub clamp, BV=94.7 V, L196." *)
paramset dsub_mod sp_diode
    parameter real area = 1 from [0:inf);
    parameter real pj = 0 from [0:inf);
    .area = area;
    .pj   = pj;
    .level = 1;
    .tlev  = 2;
    .tlevc = 0;
    .tnom  = 27;
    .is   = 4.052e-18;
    .n    = 1.01;
    .ikf  = 1.023e-9;
    .xti  = 2.112;
    .bv   = 94.7;
    .nbv  = 6;
    .tcv  = -422.386e-6;
    .isr  = 86e-18;
    .rs   = 5e5;
endparamset

(* desc="dsubedge0_mod: SPICE sidewall, xds<0.6 branch, L205." *)
paramset dsubedge0_mod sp_diode
    parameter real area = 1 from [0:inf);
    parameter real pj = 0 from [0:inf);
    .area = area;
    .pj   = pj;
    .level = 1;
    .tlev  = 2;
    .tlevc = 0;
    .tnom  = 27;
    .is   = 4.052e-18;
    .n    = 1.01;
    .jsw  = 17.26e-18;
    .ikf  = 1.023e-9;
    .xti  = 2.112;
    .bv   = 13.54;
    .tcv  = -747.415e-6;
    .isr  = 10e-18;
    .nbv  = 0.5;
    .rs   = 10e3;
endparamset

(* desc="dsubedgexds_mod: SPICE sidewall, xds>=0.6 branch, L218." *)
paramset dsubedgexds_mod sp_diode
    parameter real area = 1 from [0:inf);
    parameter real pj = 0 from [0:inf);
    parameter real xds = 0.6 from (0:inf);
    .area = area;
    .pj   = pj;
    .level = 1;
    .tlev  = 2;
    .tlevc = 0;
    .tnom  = 27;
    .is = 4.052e-18;
    .n = 1.01;
    .jsw = 17.26e-18;
    .ikf = 1.023e-9;
    .xti = 2.112;
    .bv  = -11.70818 - 8.218455*xds + 9.586918 * ln(xds) + 51.45397 * sqrt(xds);
    .tcv = -980.73e-6;
    .nbv= 5.452942 + (0.4699715 - 5.452942) / pow(1 + pow(xds / 0.982607, 308.6349), 0.005495705);
    .isr = 1e-16;
    .rs  = 28e3;
endparamset

(* desc="doutcapcorner_mod: SPICE corner-cap diode of nwell-sub clamp, L225." *)
paramset doutcapcorner_mod sp_diode
    parameter real area = 1 from [0:inf);
    parameter real pj = 0 from [0:inf);
    parameter real xds = 0 from (0:inf);
    localparam real cjsw_v = (389.8354 - 784.332 * xds + 736.9852 * pow(xds, 1.33) - 91.4155 * xds * xds + 5.388092 * xds * xds * xds) * 1e-18;
    localparam real mjsw_v = 0.3029153 + 16.37804 * xds - 16.45657 *pow(xds, 0.9972906);
    localparam real php_v  = 0.05502945 + ((0.51 - 0.05502945) / (1 + pow(xds / 1.059131, 7.087824)));
    localparam real bv_v   = 213.2898 + (145 - 213.2898) / pow(1 + pow(xds / 0.9145351, 38.88081), 0.02169905);
    .area = area;
    .pj   = pj;
    .level = 1;
    .tlev  = 2;
    .tlevc = 0;
    .tnom  = 27;
    .jsw  = 1e-25;
    .cjsw = cjsw_v;
    .mjsw = mjsw_v;
    .php  = php_v;
    .bv   = bv_v;
    .nbv  = 200;
endparamset

(* desc="doutcaparea_mod: SPICE area-cap diode of nwell-sub clamp, L239." *)
paramset doutcaparea_mod sp_diode
    parameter real area = 1 from [0:inf);
    parameter real pj = 0 from [0:inf);
    parameter real xds = 0 from (0:inf);
    localparam real cjsw_v = (471.3008 - 320.939 * xds + 91.4155 * xds * xds - 5.388092 *xds * xds * xds) * 1e-18;
    localparam real mjsw_v = 0.2842892 - 0.1665323 *xds + 0.06902971 * xds * xds - 0.004775717*xds*xds*xds;
    localparam real php_v  = 0.6372219 - 0.6615502*sqrt(xds) + 0.2246224*xds - 0.0005250178*xds*xds*xds;
    localparam real bv_v   = 262.7082 + ((154.5533 - 262.7082) / (1 + pow(xds / 3.044691, 1.691568)));
    .area = area;
    .pj   = pj;
    .level = 1;
    .tlev  = 2;
    .tlevc = 0;
    .tnom  = 27;
    .is   = 1e-25;
    .cjo  = 70.13e-18;
    .m    = 0.3874;
    .vj   = 0.3357;
    .cjsw = cjsw_v;
    .mjsw = mjsw_v;
    .php  = php_v;
    .bv   = bv_v;
    .nbv  = 200;
endparamset
