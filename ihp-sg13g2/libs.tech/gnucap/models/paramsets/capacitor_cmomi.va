//******************************************************************************
//                                                                             *
// Copyright 2026 IHP PDK Authors                                              *
//                                                                             *
// Licensed under the Apache License, Version 2.0 (the "License");             *
// you may not use this file except in compliance with the License.            *
// You may obtain a copy of the License at                                     *
//                                                                             *
//     https://www.apache.org/licenses/LICENSE-2.0                             *
//                                                                             *
// Unless required by applicable law or agreed to in writing, software         *
// distributed under the License is distributed on an "AS IS" BASIS,           *
// WITHOUT WARRANTIES OR CONDITIONS OF ANY KIND, either express or implied.    *
// See the License for the specific language governing permissions and         *
// limitations under the License.                                              *
//                                                                             *
//******************************************************************************

//******************************************************************************
// cmomi - interdigitated MoM capacitor paramset
//
// cap_cmomi is a self-contained behavioural RF model (its own series/shunt
// equivalent circuit), not a parallel-plate primitive, so unlike cmim_core it
// is NOT decomposed onto sp_capacitor. This paramset wraps the behavioural
// module cap_cmomi (shared source ../../verilog-a/cap_cmomi/cap_cmomi.va,
// byte-for-byte the code the ngspice OSDI build uses) and only pins the g2
// named-device defaults, exactly as `paramset rsil r3_cmc` wraps the resistor
// CMC primitive.
//
// cap_cmomi has no characterised corner/mismatch spread yet (returns nominal
// in every corner; pending silicon), so there are no corner cross-references
// here. The mm_ok selector is declared (mm_ok = 0, the no-mismatch case) but
// not mapped -- cap_cmomi has no mm_ok port -- so it is an
// accepted-but-unused selector, just like cmim_core above.  It reserves the
// mm_ok = 1 overload slot: when the spread is characterised, add an
// mm_ok = 1 from [1:1] variant the same way the resistor paramsets do.
//
// Terminals PLUS, MINUS, SUB are inherited from the module; tie SUB to ground
// for the classic 2-terminal use (the ngspice wrapper subckt and the gnucap
// testbench both do this).
//******************************************************************************

(* desc="cmomi cap_cmomi behavioural paramset, without mismatch" *)
paramset cmomi cap_cmomi
    (* desc="Device width",  units="m" *)
    parameter real    w        = 5e-6 from (0.0:inf);
    (* desc="Device length", units="m" *)
    parameter real    l        = 5e-6 from (0.0:inf);
    (* desc="Minimum number of metal segments" *)
    parameter integer mmin     = 1    from [1:8];
    (* desc="Maximum number of metal segments" *)
    parameter integer mmax     = 5    from [1:8];
    (* desc="Feeding topology selector (0..2)" *)
    parameter integer feed     = 2    from [0:2];
    (* desc="Sub-block selector (0 or 1)" *)
    parameter integer subblock = 0    from [0:1];
    (* desc="Enable mismatch" *)
    parameter integer mm_ok    = 0    from [0:0];
    .w        = w;
    .l        = l;
    .mmin     = mmin;
    .mmax     = mmax;
    .feed     = feed;
    .subblock = subblock;
endparamset
