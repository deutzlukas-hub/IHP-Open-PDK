//#######################################################################
//
// Copyright 2025 IHP PDK Authors
//
// Licensed under the Apache License, Version 2.0 (the "License");
// you may not use this file except in compliance with the License.
// You may obtain a copy of the License at
//
//    https://www.apache.org/licenses/LICENSE-2.0
//
// Unless required by applicable law or agreed to in writing, software
// distributed under the License is distributed on an "AS IS" BASIS,
// WITHOUT WARRANTIES OR CONDITIONS OF ANY KIND, either express or implied.
// See the License for the specific language governing permissions and
// limitations under the License.
//
//#######################################################################

// Diode corner modules
// Ported from `ngspice/models/cornerDIO.lib` to Verilog-A.

// Typical corner.
module dio_tt();
    localparam real schottky_nbl1_is = 1.28;
    localparam real schottky_nbl1_kf = 1.0;
endmodule

// Typical statistical corner.
module dio_tt_stat();
    localparam real schottky_nbl1_is_norm = 1.28;
    localparam real schottky_nbl1_kf_norm = 1.0;
endmodule

// Slow (-3 sigma) corner.
module dio_ss();
    localparam real schottky_nbl1_is = 0.85;
    localparam real schottky_nbl1_kf = 0.4;
endmodule

// Fast (+3 sigma) corner.
module dio_ff();
    localparam real schottky_nbl1_is = 1.92;
    localparam real schottky_nbl1_kf = 1.61;
endmodule
