//******************************************************************************
//
// Library:      SG13G2_dev
// Technologies: SG13G2
//
// Model:        PSP 108.3.2
// Revision:     200310
//
//******************************************************************************
//
// Copyright 2023 IHP PDK Authors
//
// Licensed under the Apache License, Version 2.0 (the "License");
// you may not use this file except in compliance with the License.
// You may obtain a copy of the License at
//
//     https://www.apache.org/licenses/LICENSE-2.0
//
// Unless required by applicable law or agreed to in writing, software
// distributed under the License is distributed on an "AS IS" BASIS,
// WITHOUT WARRANTIES OR CONDITIONS OF ANY KIND, either express or implied.
// See the License for the specific language governing permissions and
// limitations under the License.
//
//******************************************************************************
//******************************************************************************
//
//
//              C O M M O N    SG 13  M O S     M O D E L S
//
//
//******************************************************************************
//
// NOTE: do not include this file directly in the netlist, use models.typ, .bcs or .wcs only
//
//
//
//******************************************************************************
// variable C section
//******************************************************************************
//
//
//******************************************************************************
// MOS transistor section
//******************************************************************************

// MOS-Subckt with D/S-overlap possibility
//
//       z1              z2            z1
//   ----------------------------------------
//   |          |   |         |   |         |
//   |    S     | G |   D     | G |    S    |  w/ng, >=0.15u
//   |          |   |         |   |         |
//   ----------------------------------------
//
//  z1=0.34u, z2=0.38u
//
// Parameters as,ad,ps,pd are calculated automatically, if <= 0
//
// NOTE:
// values are one-sigma deviations (1/3 of min-max)

//******************************************************************************

//******************************************************************************
// Verilog-A MOSLV device modules
// Ported from `ngspice/models/sg13g2_moslv_mod*.lib`
//
// Modifications:
// - Fixed values for SPICE instance parameter ngcon, delvto, and factuo are
//   assigned in the paramsets.
// - SWSOA parameter is set to zero in paramset TODO: user settable?
// - pre_layout, rfmode and mm_ok parameters are forwarded to paramset
//
// (c) Lukas Deutz 2026
//******************************************************************************

//******************************************************************************
// NMOS
//******************************************************************************

// TODO: make modules paramsets once nested (chained) paramsets are supported

(* desc="SG13G2 Low-Voltage NMOS module" *)
module sg13_lv_nmos(d, g, s, b);
    inout d, g, s, b;
    electrical d, g, s, b;

    (* desc="Device width", units="m" *)
    parameter real w = 0.35u from (0:1e99); // TODO: 1e99->inf once fixed
    (* desc="Device length", units="m" *)
    parameter real l = 0.34u from [0.13u:10u];
    (* desc="Number of fingers" *)
    parameter integer ng = 1 from [1:1e99); // TODO: 1e99->inf once fixed
    (* desc="Instance multiplicity" *)
    parameter real m = 1.0 from (0:1e99); // TODO: 1e99->inf once fixed;
    (* desc="Enable mismatch" *)
    parameter integer mm_ok = 0 from [0:1];
    (* desc="Temperature offset w.r.t. ambient temperature" *)
    parameter real trise = 0.0;
    (* desc="Enable pre-layout parasitic modelling" *)
    parameter integer pre_layout = 1 from [0:1];
    (* desc="Select psp103_nqs RF model" *)
    parameter integer rfmode = 0 from [0:1];

    localparam real wf = w / ng from [0.15u:10u];
    localparam real z1 = 0.34e-6;
    localparam real z2 = 0.38e-6;
    localparam integer k = ng / 2;
    localparam integer p = ng % 2;
    localparam real as = wf * ((2 - p) * z1 + (k - 1 + p) * z2);
    localparam real ad = wf * (p * z1 + k * z2);
    localparam real pd = 2 * (wf * (k + 1) + (2 - p) * z1 + (k - 1 + p) * z2);
    localparam real ps = 2 * (wf * (k + p) + p * z1 + k * z2);
    // TODO: linebreak when supported
    sg13g2_lv_nmos_psp #(.w(w), .l(l), .ng(ng), .m(m), .mm_ok(mm_ok), .trise(trise), .as(as), .ad(ad), .pd(pd), .ps(ps), .pre_layout(pre_layout), .rfmode(rfmode)) Nsg13_lv_nmos(d, g, s, b);
endmodule

(* desc="SG13G2 Low-Voltage NMOS module" *)
module sg13_lv_nmos_TODO(d, g, s, b);
    inout d, g, s, b;
    electrical d, g, s, b;

    (* desc="Device width", units="m" *)
    parameter real w = 0.35u from (0:1e99); // TODO: 1e99->inf once fixed
    (* desc="Device length", units="m" *)
    parameter real l = 0.34u from [0.13u:10u];
    (* desc="Number of fingers" *)
    parameter integer ng = 1 from [1:1e99); // TODO: 1e99->inf once fixed
    (* desc="Instance multiplicity" *)
    parameter real m = 1.0 from (0:1e99); // TODO: 1e99->inf once fixed;
    (* desc="Enable mismatch" *)
    parameter integer mm_ok = 0 from [0:1];
    (* desc="Temperature offset w.r.t. ambient temperature" *)
    parameter real trise = 0.0;
    (* desc="Source diffusion area", units="m^2" *)
    parameter real as = 0.0 from [0:inf);
    (* desc="Drain diffusion area", units="m^2" *)
    parameter real ad = 0.0 from [0:inf);
    (* desc="Drain diffusion perimeter", units="m" *)
    parameter real pd = 0.0 from [0:inf);
    (* desc="Source diffusion perimeter", units="m" *)
    parameter real ps = 0.0 from [0:inf);
    (* desc="Enable pre-layout parasitic modelling" *)
    parameter integer pre_layout = 1 from [0:1];
    (* desc="Select psp103_nqs RF model" *)
    parameter integer rfmode = 0 from [0:1];

    localparam real wf = w / ng from [0.15u:10u];
    // TODO: linebreak when supported
    sg13g2_lv_nmos_psp #(.w(w), .l(l), .ng(ng), .m(m), .mm_ok(mm_ok), .trise(trise), .as(as), .ad(ad), .pd(pd), .ps(ps), .pre_layout(pre_layout), .rfmode(rfmode)) Nsg13_lv_nmos(d, g, s, b);
endmodule

//******************************************************************************
// PMOS
//******************************************************************************

(* desc="SG13G2 Low-Voltage PMOS module" *)
module sg13_lv_pmos(d, g, s, b);
    inout d, g, s, b;
    electrical d, g, s, b;

    (* desc="Device width", units="m" *)
    parameter real w = 0.35u from (0:1e99); // TODO: 1e99->inf once fixed
    (* desc="Device length", units="m" *)
    parameter real l = 0.28u from [0.13u:10u];
    (* desc="Number of fingers" *)
    parameter integer ng = 1 from [1:1e99); // TODO: 1e99->inf once fixed
    (* desc="Instance multiplicity" *)
    parameter real m = 1.0;
    (* desc="Enable mismatch" *)
    parameter integer mm_ok = 0 from [0:1];
    (* desc="Temperature offset w.r.t. ambient temperature" *)
    parameter real trise = 0.0;
    (* desc="Enable pre-layout parasitic modelling" *)
    parameter integer pre_layout = 1 from [0:1];
    (* desc="Select psp103_nqs RF model" *)
    parameter integer rfmode = 0 from [0:1];

    localparam real wf = w / ng from [0.15u:10u];
    localparam real z1 = 0.34e-6;
    localparam real z2 = 0.38e-6;
    localparam integer k = ng / 2;
    localparam integer p = ng % 2;
    localparam real as = wf * ((2 - p) * z1 + (k - 1 + p) * z2);
    localparam real ad = wf * (p * z1 + k * z2);
    localparam real pd = 2 * (wf * (k + 1) + (2 - p) * z1 + (k - 1 + p) * z2);
    localparam real ps = 2 * (wf * (k + p) + p * z1 + k * z2);
    // TODO: linebreak when supported
    sg13g2_lv_pmos_psp #(.w(w), .l(l), .ng(ng), .m(m), .mm_ok(mm_ok), .trise(trise), .as(as), .ad(ad), .pd(pd), .ps(ps), .pre_layout(pre_layout), .rfmode(rfmode)) Nsg13_lv_pmos(d, g, s, b);
endmodule

(* desc="SG13G2 Low-Voltage PMOS module" *)
module sg13_lv_pmos_TODO(d, g, s, b);
    inout d, g, s, b;
    electrical d, g, s, b;

    (* desc="Device width", units="m" *)
    parameter real w = 0.35u from (0:1e99); // TODO: 1e99->inf once fixed
    (* desc="Device length", units="m" *)
    parameter real l = 0.28u from [0.13u:10u];
    (* desc="Number of fingers" *)
    parameter integer ng = 1 from [1:1e99); // TODO: 1e99->inf once fixed
    (* desc="Instance multiplicity" *)
    parameter real m = 1.0;
    (* desc="Enable mismatch" *)
    parameter integer mm_ok = 0 from [0:1];
    (* desc="Temperature offset w.r.t. ambient temperature" *)
    parameter real trise = 0.0;
    (* desc="Source diffusion area", units="m^2" *)
    parameter real as = 0.0 from [0:inf);
    (* desc="Drain diffusion area", units="m^2" *)
    parameter real ad = 0.0 from [0:inf);
    (* desc="Drain diffusion perimeter", units="m" *)
    parameter real pd = 0.0 from [0:inf);
    (* desc="Source diffusion perimeter", units="m" *)
    parameter real ps = 0.0 from [0:inf);
    (* desc="Enable pre-layout parasitic modelling" *)
    parameter integer pre_layout = 1 from [0:1];
    (* desc="Select psp103_nqs RF model" *)
    parameter integer rfmode = 0 from [0:1];

    localparam real wf = w / ng from [0.15u:10u];
    // TODO: linebreak when supported
    sg13g2_lv_pmos_psp #(.w(w), .l(l), .ng(ng), .m(m), .mm_ok(mm_ok), .trise(trise), .as(as), .ad(ad), .pd(pd), .ps(ps), .pre_layout(pre_layout), .rfmode(rfmode)) Nsg13_lv_pmos(d, g, s, b);
endmodule
