//#######################################################################
//
// Verilog-A sg13g2_dschottky_nbl1 Schottky diode wrapper module
// Ported from `ngspice/models/sg13g2_dschottky_nbl1_mod.lib`.
//
// Sources:
//   SPICE: ngspice/models/sg13g2_dschottky_nbl1_mod.lib
//   Xyce : xyce/models/sg13g2_dschottky_nbl1_mod.lib
//   Corner scaling lives in ngspice/models/cornerDIO.lib; the typical
//   corner is loaded as `dio_tt corner_dio();` from a sibling .gc/test.
//
// SPICE -> Verilog-A mapping notes:
// - SPICE `.MODEL D ...` blocks map to Gnucap `paramset sp_diode`
//   cards (one per SPICE D model).
// - SPICE `.MODEL pnp ...` maps to a Gnucap `paramset bjt` with
//   `.type = -1;` (PNP).
// - SPICE resistor `tc1`/`tc2` temperature coefficients on `rsmain`
//   map onto the VAMS `resistor` primitive's `.tc1`/`.tc2` parameters.
//   `rsub` has no SPICE temperature coefficients.
// - The corner multipliers `schottky_nbl1_is` / `schottky_nbl1_kf`
//   are read from the externally-instantiated `corner_dio` module
//   (defined in `models/cornerDIO.va`).
//
// (c) Lukas Deutz 2026
//#######################################################################

//******************************************************************************
// schottky_nbl1
//
//   Ports : A (anode), C (cathode), S (substrate)
//   SPICE topology (ngspice/models/sg13g2_dschottky_nbl1_mod.lib):
//     dmain 1  C  dmain_mod area = (Nx*Ny)*(l*w) / scaling^2
//     drev  C  1  drev_mod  area = (Nx*Ny)*(l*w) / scaling^2
//     dsub  S  C  dsub_mod  area = ls * ws
//     Q1    A  C  S  schottky_nbl1_mod1_pnp area = (Nx*Ny)*(l*w) / scaling^2
//     rsmain A 1  R = 1360 / (Nx*Ny)   tc1 = 2.975e-3  tc2 = 4.630e-6
//     cstray A C  C = (2.185E-14/25) * (Nx*Ny)
//     cin    A S  C = (5E-16/5) * Nx
//     cdsub  C 2  C = (1.7E-14/168) * (ls*ws)
//     csub   2 S  C = 6E-16
//     rsub   2 S  R = 1E+4
//   Where scaling = 1e-6; ls = ((Nx*(l+2u))/scaling) + 0.5;
//   ws = ((Ny*(w+1.7u))/scaling) + 0.5.
//******************************************************************************

(* desc="SG13G2 schottky_nbl1 Schottky diode (3-terminal: anode, cathode, substrate)" *)
module schottky_nbl1(A, C, S);
    inout A, C, S;
    electrical A, C, S;
    electrical n1, n2;

    (* desc="Drawn length", units="m" *)
    parameter real l = 1u from (0:1e99);
    (* desc="Drawn width",  units="m" *)
    parameter real w = 0.3u from (0:1e99);
    (* desc="Number of columns" *)
    parameter integer Nx = 1 from [1:1e99);
    (* desc="Number of rows" *)
    parameter integer Ny = 1 from [1:1e99);

    localparam real scaling = 1e-6;
    localparam real nxy = Nx * Ny;
    localparam real area = (nxy * (l * w)) / (scaling * scaling);
    localparam real ls = ((Nx * (l + 2u)) / scaling) + 0.5;
    localparam real ws = ((Ny * (w + 1.7u)) / scaling) + 0.5;
    localparam real area_sub  = ls * ws;

    localparam real rsmain_val = 1360.0 / nxy;
    localparam real cstray_val = (2.185e-14 / 25) * nxy;
    localparam real cin_val    = (5e-16 / 5) * Nx;
    localparam real cdsub_val  = (1.7e-14 / 168) * area_sub;
    localparam real csub_val   = 6e-16;
    localparam real rsub_val   = 1e4;

    dmain_mod #(.area(area)) dmain(n1, C);
    drev_mod  #(.area(area)) drev(C,  n1);
    dsub_mod  #(.area(area_sub)) dsub(S,  C);
    mod1_pnp  #(.area(area)) Q1(A, C, S);

    resistor  #(.r(rsmain_val), .tc1(2.975e-3), .tc2(4.630e-6)) Rsmain(A, n1);
    capacitor #(.c(cstray_val)) Cstray(A,  C);
    capacitor #(.c(cin_val))    Cin   (A,  S);
    capacitor #(.c(cdsub_val))  Cdsub (C,  n2);
    capacitor #(.c(csub_val))   Csub  (n2, S);
    resistor  #(.r(rsub_val))   Rsub  (n2, S);
endmodule
