//`include "disciplines.vams"

module lc_osc(vdd, out1, out2, vss, ibias);

    inout vdd,  vss, ibias;
    output out1, out2;
    electrical vdd, out1, out2, vss, ibias;
    electrical tapl;

    sg13_lv_nmos #(.w(6u), .l(0.13u), .ng(6), .m(1), .mm_ok(0)) MN1(out1, out2, ibias, vss);
    sg13_lv_nmos #(.w(6u), .l(0.13u), .ng(6), .m(1), .mm_ok(0)) MN2(out2, out1, ibias, vss);

    sg13_lv_pmos #(.w(8.5u), .l(0.13u), .ng(1), .m(1), .mm_ok(0)) MP1(out1, out2, vdd, vdd);
    sg13_lv_pmos #(.w(8.5u), .l(0.13u), .ng(1), .m(1), .mm_ok(0)) MP2(out2, out1, vdd, vdd);

    inductor #(.l(20n)) L1(out1, tapl);
    inductor #(.l(20n)) L2(out2, tapl);

//  cap_cmim #(.w(18.3u), .l(18.3u)) C1(out1, vdd);
//  cap_cmim #(.w(18.3u), .l(18.3u)) C2(out2, vdd);
    capacitor #(.c(80f)) C1(out1, vdd);
    capacitor #(.c(80f)) C2(out2, vdd);
endmodule
